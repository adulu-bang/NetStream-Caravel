* NGSPICE file created from RAM32.ext - technology: sky130A

* Black-box entry subcircuit for sky130_fd_sc_hd__ebufn_2 abstract view
.subckt sky130_fd_sc_hd__ebufn_2 A TE_B VGND VNB VPB VPWR Z
.ends

* Black-box entry subcircuit for sky130_fd_sc_hd__tapvpwrvgnd_1 abstract view
.subckt sky130_fd_sc_hd__tapvpwrvgnd_1 VGND VPWR
.ends

* Black-box entry subcircuit for sky130_fd_sc_hd__and2_1 abstract view
.subckt sky130_fd_sc_hd__and2_1 A B VGND VNB VPB VPWR X
.ends

* Black-box entry subcircuit for sky130_fd_sc_hd__dlxtp_1 abstract view
.subckt sky130_fd_sc_hd__dlxtp_1 D GATE VGND VNB VPB VPWR Q
.ends

* Black-box entry subcircuit for sky130_fd_sc_hd__inv_1 abstract view
.subckt sky130_fd_sc_hd__inv_1 A VGND VNB VPB VPWR Y
.ends

* Black-box entry subcircuit for sky130_fd_sc_hd__diode_2 abstract view
.subckt sky130_fd_sc_hd__diode_2 DIODE VGND VNB VPB VPWR
.ends

* Black-box entry subcircuit for sky130_fd_sc_hd__decap_12 abstract view
.subckt sky130_fd_sc_hd__decap_12 VGND VNB VPB VPWR
.ends

* Black-box entry subcircuit for sky130_fd_sc_hd__clkbuf_2 abstract view
.subckt sky130_fd_sc_hd__clkbuf_2 A VGND VNB VPB VPWR X
.ends

* Black-box entry subcircuit for sky130_fd_sc_hd__decap_3 abstract view
.subckt sky130_fd_sc_hd__decap_3 VGND VNB VPB VPWR
.ends

* Black-box entry subcircuit for sky130_fd_sc_hd__dlclkp_1 abstract view
.subckt sky130_fd_sc_hd__dlclkp_1 CLK GATE VGND VNB VPB VPWR GCLK
.ends

* Black-box entry subcircuit for sky130_fd_sc_hd__dfxtp_1 abstract view
.subckt sky130_fd_sc_hd__dfxtp_1 CLK D VGND VNB VPB VPWR Q
.ends

* Black-box entry subcircuit for sky130_fd_sc_hd__decap_6 abstract view
.subckt sky130_fd_sc_hd__decap_6 VGND VNB VPB VPWR
.ends

* Black-box entry subcircuit for sky130_fd_sc_hd__fill_2 abstract view
.subckt sky130_fd_sc_hd__fill_2 VGND VNB VPB VPWR
.ends

* Black-box entry subcircuit for sky130_fd_sc_hd__and4bb_2 abstract view
.subckt sky130_fd_sc_hd__and4bb_2 A_N B_N C D VGND VNB VPB VPWR X
.ends

* Black-box entry subcircuit for sky130_fd_sc_hd__clkbuf_4 abstract view
.subckt sky130_fd_sc_hd__clkbuf_4 A VGND VNB VPB VPWR X
.ends

* Black-box entry subcircuit for sky130_fd_sc_hd__and4b_2 abstract view
.subckt sky130_fd_sc_hd__and4b_2 A_N B C D VGND VNB VPB VPWR X
.ends

* Black-box entry subcircuit for sky130_fd_sc_hd__mux2_1 abstract view
.subckt sky130_fd_sc_hd__mux2_1 A0 A1 S VGND VNB VPB VPWR X
.ends

* Black-box entry subcircuit for sky130_fd_sc_hd__clkbuf_16 abstract view
.subckt sky130_fd_sc_hd__clkbuf_16 A VGND VNB VPB VPWR X
.ends

* Black-box entry subcircuit for sky130_fd_sc_hd__decap_8 abstract view
.subckt sky130_fd_sc_hd__decap_8 VGND VNB VPB VPWR
.ends

* Black-box entry subcircuit for sky130_fd_sc_hd__and4_2 abstract view
.subckt sky130_fd_sc_hd__and4_2 A B C D VGND VNB VPB VPWR X
.ends

* Black-box entry subcircuit for sky130_fd_sc_hd__decap_4 abstract view
.subckt sky130_fd_sc_hd__decap_4 VGND VNB VPB VPWR
.ends

* Black-box entry subcircuit for sky130_fd_sc_hd__and2b_2 abstract view
.subckt sky130_fd_sc_hd__and2b_2 A_N B VGND VNB VPB VPWR X
.ends

* Black-box entry subcircuit for sky130_fd_sc_hd__and2_2 abstract view
.subckt sky130_fd_sc_hd__and2_2 A B VGND VNB VPB VPWR X
.ends

* Black-box entry subcircuit for sky130_fd_sc_hd__nor4b_2 abstract view
.subckt sky130_fd_sc_hd__nor4b_2 A B C D_N VGND VNB VPB VPWR Y
.ends

* Black-box entry subcircuit for sky130_fd_sc_hd__conb_1 abstract view
.subckt sky130_fd_sc_hd__conb_1 VGND VNB VPB VPWR HI LO
.ends

.subckt RAM32 A0[0] A0[1] A0[2] A0[3] A0[4] CLK Di0[0] Di0[10] Di0[11] Di0[12] Di0[13]
+ Di0[14] Di0[15] Di0[16] Di0[17] Di0[18] Di0[19] Di0[1] Di0[20] Di0[21] Di0[22] Di0[23]
+ Di0[24] Di0[25] Di0[26] Di0[27] Di0[28] Di0[29] Di0[2] Di0[30] Di0[31] Di0[3] Di0[4]
+ Di0[5] Di0[6] Di0[7] Di0[8] Di0[9] Do0[0] Do0[10] Do0[11] Do0[12] Do0[13] Do0[14]
+ Do0[15] Do0[16] Do0[17] Do0[18] Do0[19] Do0[1] Do0[20] Do0[21] Do0[22] Do0[23] Do0[24]
+ Do0[25] Do0[26] Do0[27] Do0[28] Do0[29] Do0[2] Do0[30] Do0[31] Do0[3] Do0[4] Do0[5]
+ Do0[6] Do0[7] Do0[8] Do0[9] EN0 VGND VPWR WE0[0] WE0[1] WE0[2] WE0[3]
XSLICE_16\[1\].RAM16.SLICE\[0\].RAM8.WORD\[2\].W.BYTE\[0\].B.BIT\[1\].OBUF0 SLICE_16\[1\].RAM16.SLICE\[0\].RAM8.WORD\[2\].W.BYTE\[0\].B.Q_WIRE\[1\]
+ SLICE_16\[1\].RAM16.SLICE\[0\].RAM8.WORD\[2\].W.BYTE\[0\].B.SEL0_B VGND VGND VPWR
+ VPWR SLICE_16\[1\].RAM16.BYTE\[0\].FLOATBUF0\[1\].Z sky130_fd_sc_hd__ebufn_2
Xtap_24_35 VGND VPWR sky130_fd_sc_hd__tapvpwrvgnd_1
Xtap_24_24 VGND VPWR sky130_fd_sc_hd__tapvpwrvgnd_1
Xtap_24_13 VGND VPWR sky130_fd_sc_hd__tapvpwrvgnd_1
XSLICE_16\[1\].RAM16.SLICE\[0\].RAM8.WORD\[1\].W.BYTE\[0\].B.CGAND SLICE_16\[1\].RAM16.SLICE\[0\].RAM8.WORD\[1\].W.BYTE\[0\].B.SEL0
+ SLICE_16\[1\].RAM16.SLICE\[0\].RAM8.WE0_buf\[0\] VGND VGND VPWR VPWR SLICE_16\[1\].RAM16.SLICE\[0\].RAM8.WORD\[1\].W.BYTE\[0\].B.WE0_WIRE
+ sky130_fd_sc_hd__and2_1
Xtap_3_8 VGND VPWR sky130_fd_sc_hd__tapvpwrvgnd_1
XSLICE_16\[0\].RAM16.SLICE\[0\].RAM8.WORD\[2\].W.BYTE\[2\].B.BIT\[4\].genblk1.STORAGE
+ DIBUF\[20\].X SLICE_16\[0\].RAM16.SLICE\[0\].RAM8.WORD\[2\].W.BYTE\[2\].B.GCLK VGND
+ VGND VPWR VPWR SLICE_16\[0\].RAM16.SLICE\[0\].RAM8.WORD\[2\].W.BYTE\[2\].B.Q_WIRE\[4\]
+ sky130_fd_sc_hd__dlxtp_1
Xtap_40_23 VGND VPWR sky130_fd_sc_hd__tapvpwrvgnd_1
Xtap_40_12 VGND VPWR sky130_fd_sc_hd__tapvpwrvgnd_1
XSLICE_16\[1\].RAM16.SLICE\[0\].RAM8.WORD\[6\].W.BYTE\[3\].B.BIT\[4\].OBUF0 SLICE_16\[1\].RAM16.SLICE\[0\].RAM8.WORD\[6\].W.BYTE\[3\].B.Q_WIRE\[4\]
+ SLICE_16\[1\].RAM16.SLICE\[0\].RAM8.WORD\[6\].W.BYTE\[3\].B.SEL0_B VGND VGND VPWR
+ VPWR SLICE_16\[1\].RAM16.BYTE\[3\].FLOATBUF0\[28\].Z sky130_fd_sc_hd__ebufn_2
XSLICE_16\[0\].RAM16.SLICE\[1\].RAM8.WORD\[4\].W.BYTE\[2\].B.genblk1.CLKINV SLICE_16\[0\].RAM16.SLICE\[1\].RAM8.WORD\[4\].W.BYTE\[0\].B.CLK
+ VGND VGND VPWR VPWR SLICE_16\[0\].RAM16.SLICE\[1\].RAM8.WORD\[4\].W.BYTE\[2\].B.CLK_B
+ sky130_fd_sc_hd__inv_1
XSLICE_16\[0\].RAM16.SLICE\[0\].RAM8.WORD\[0\].W.BYTE\[0\].B.BIT\[3\].genblk1.STORAGE
+ DIBUF\[3\].X SLICE_16\[0\].RAM16.SLICE\[0\].RAM8.WORD\[0\].W.BYTE\[0\].B.GCLK VGND
+ VGND VPWR VPWR SLICE_16\[0\].RAM16.SLICE\[0\].RAM8.WORD\[0\].W.BYTE\[0\].B.Q_WIRE\[3\]
+ sky130_fd_sc_hd__dlxtp_1
XSLICE_16\[1\].RAM16.Do0_REG.OUTREG_BYTE\[3\].DIODE\[5\] SLICE_16\[1\].RAM16.BYTE\[3\].FLOATBUF0\[29\].Z
+ VGND VGND VPWR VPWR sky130_fd_sc_hd__diode_2
Xfill_0_14 VGND VGND VPWR VPWR sky130_fd_sc_hd__decap_12
XSLICE_16\[1\].RAM16.SLICE\[0\].RAM8.WORD\[5\].W.BYTE\[2\].B.DIODE_CLK SLICE_16\[1\].RAM16.SLICE\[0\].RAM8.WORD\[5\].W.BYTE\[0\].B.CLK
+ VGND VGND VPWR VPWR sky130_fd_sc_hd__diode_2
Xfill_43_3 VGND VPWR sky130_fd_sc_hd__tapvpwrvgnd_1
XSLICE_16\[0\].RAM16.SLICE\[1\].RAM8.WORD\[1\].W.SEL0BUF SLICE_16\[0\].RAM16.SLICE\[1\].RAM8.DEC0.SEL\[1\]
+ VGND VGND VPWR VPWR SLICE_16\[0\].RAM16.SLICE\[1\].RAM8.WORD\[1\].W.BYTE\[0\].B.SEL0
+ sky130_fd_sc_hd__clkbuf_2
Xfill_46_121 VGND VGND VPWR VPWR sky130_fd_sc_hd__decap_12
Xfill_46_110 VGND VGND VPWR VPWR sky130_fd_sc_hd__decap_12
XSLICE_16\[1\].RAM16.SLICE\[1\].RAM8.WORD\[7\].W.BYTE\[3\].B.BIT\[2\].genblk1.STORAGE
+ DIBUF\[26\].X SLICE_16\[1\].RAM16.SLICE\[1\].RAM8.WORD\[7\].W.BYTE\[3\].B.GCLK VGND
+ VGND VPWR VPWR SLICE_16\[1\].RAM16.SLICE\[1\].RAM8.WORD\[7\].W.BYTE\[3\].B.Q_WIRE\[2\]
+ sky130_fd_sc_hd__dlxtp_1
Xfill_36_2 VGND VGND VPWR VPWR sky130_fd_sc_hd__decap_3
Xfill_29_1 VGND VGND VPWR VPWR sky130_fd_sc_hd__decap_3
XSLICE_16\[1\].RAM16.SLICE\[0\].RAM8.WORD\[5\].W.BYTE\[1\].B.BIT\[1\].OBUF0 SLICE_16\[1\].RAM16.SLICE\[0\].RAM8.WORD\[5\].W.BYTE\[1\].B.Q_WIRE\[1\]
+ SLICE_16\[1\].RAM16.SLICE\[0\].RAM8.WORD\[5\].W.BYTE\[1\].B.SEL0_B VGND VGND VPWR
+ VPWR SLICE_16\[1\].RAM16.BYTE\[1\].FLOATBUF0\[9\].Z sky130_fd_sc_hd__ebufn_2
XSLICE_16\[0\].RAM16.SLICE\[0\].RAM8.WORD\[3\].W.BYTE\[2\].B.CGAND SLICE_16\[0\].RAM16.SLICE\[0\].RAM8.WORD\[3\].W.BYTE\[0\].B.SEL0
+ SLICE_16\[0\].RAM16.SLICE\[0\].RAM8.WE0_buf\[2\] VGND VGND VPWR VPWR SLICE_16\[0\].RAM16.SLICE\[0\].RAM8.WORD\[3\].W.BYTE\[2\].B.WE0_WIRE
+ sky130_fd_sc_hd__and2_1
XSLICE_16\[0\].RAM16.SLICE\[1\].RAM8.WORD\[2\].W.BYTE\[3\].B.BIT\[0\].OBUF0 SLICE_16\[0\].RAM16.SLICE\[1\].RAM8.WORD\[2\].W.BYTE\[3\].B.Q_WIRE\[0\]
+ SLICE_16\[0\].RAM16.SLICE\[1\].RAM8.WORD\[2\].W.BYTE\[3\].B.SEL0_B VGND VGND VPWR
+ VPWR SLICE_16\[0\].RAM16.BYTE\[3\].FLOATBUF0\[24\].Z sky130_fd_sc_hd__ebufn_2
Xfill_46_143 VGND VPWR sky130_fd_sc_hd__tapvpwrvgnd_1
Xfill_46_132 VGND VPWR sky130_fd_sc_hd__tapvpwrvgnd_1
XSLICE_16\[1\].RAM16.SLICE\[1\].RAM8.WORD\[5\].W.BYTE\[1\].B.BIT\[1\].genblk1.STORAGE
+ DIBUF\[9\].X SLICE_16\[1\].RAM16.SLICE\[1\].RAM8.WORD\[5\].W.BYTE\[1\].B.GCLK VGND
+ VGND VPWR VPWR SLICE_16\[1\].RAM16.SLICE\[1\].RAM8.WORD\[5\].W.BYTE\[1\].B.Q_WIRE\[1\]
+ sky130_fd_sc_hd__dlxtp_1
XSLICE_16\[0\].RAM16.SLICE\[1\].RAM8.WORD\[7\].W.BYTE\[3\].B.genblk1.CLKINV SLICE_16\[0\].RAM16.SLICE\[1\].RAM8.WORD\[7\].W.BYTE\[0\].B.CLK
+ VGND VGND VPWR VPWR SLICE_16\[0\].RAM16.SLICE\[1\].RAM8.WORD\[7\].W.BYTE\[3\].B.CLK_B
+ sky130_fd_sc_hd__inv_1
Xtap_10_15 VGND VPWR sky130_fd_sc_hd__tapvpwrvgnd_1
Xtap_10_26 VGND VPWR sky130_fd_sc_hd__tapvpwrvgnd_1
XSLICE_16\[0\].RAM16.SLICE\[1\].RAM8.WORD\[2\].W.BYTE\[2\].B.DIODE_CLK SLICE_16\[0\].RAM16.SLICE\[1\].RAM8.WORD\[2\].W.BYTE\[0\].B.CLK
+ VGND VGND VPWR VPWR sky130_fd_sc_hd__diode_2
XSLICE_16\[1\].RAM16.SLICE\[0\].RAM8.WORD\[1\].W.BYTE\[3\].B.SEL0INV SLICE_16\[1\].RAM16.SLICE\[0\].RAM8.WORD\[1\].W.BYTE\[0\].B.SEL0
+ VGND VGND VPWR VPWR SLICE_16\[1\].RAM16.SLICE\[0\].RAM8.WORD\[1\].W.BYTE\[3\].B.SEL0_B
+ sky130_fd_sc_hd__inv_1
XSLICE_16\[0\].RAM16.SLICE\[0\].RAM8.WORD\[7\].W.BYTE\[0\].B.BIT\[2\].OBUF0 SLICE_16\[0\].RAM16.SLICE\[0\].RAM8.WORD\[7\].W.BYTE\[0\].B.Q_WIRE\[2\]
+ SLICE_16\[0\].RAM16.SLICE\[0\].RAM8.WORD\[7\].W.BYTE\[0\].B.SEL0_B VGND VGND VPWR
+ VPWR SLICE_16\[0\].RAM16.BYTE\[0\].FLOATBUF0\[2\].Z sky130_fd_sc_hd__ebufn_2
XSLICE_16\[0\].RAM16.SLICE\[0\].RAM8.WORD\[7\].W.BYTE\[1\].B.SEL0INV SLICE_16\[0\].RAM16.SLICE\[0\].RAM8.WORD\[7\].W.BYTE\[0\].B.SEL0
+ VGND VGND VPWR VPWR SLICE_16\[0\].RAM16.SLICE\[0\].RAM8.WORD\[7\].W.BYTE\[1\].B.SEL0_B
+ sky130_fd_sc_hd__inv_1
Xtap_35_34 VGND VPWR sky130_fd_sc_hd__tapvpwrvgnd_1
Xtap_35_23 VGND VPWR sky130_fd_sc_hd__tapvpwrvgnd_1
Xtap_35_12 VGND VPWR sky130_fd_sc_hd__tapvpwrvgnd_1
Xtap_1_5 VGND VPWR sky130_fd_sc_hd__tapvpwrvgnd_1
XSLICE_16\[0\].RAM16.SLICE\[0\].RAM8.WORD\[3\].W.BYTE\[0\].B.genblk1.CG SLICE_16\[0\].RAM16.SLICE\[0\].RAM8.WORD\[3\].W.BYTE\[0\].B.CLK_B
+ SLICE_16\[0\].RAM16.SLICE\[0\].RAM8.WORD\[3\].W.BYTE\[0\].B.WE0_WIRE VGND VGND VPWR
+ VPWR SLICE_16\[0\].RAM16.SLICE\[0\].RAM8.WORD\[3\].W.BYTE\[0\].B.GCLK sky130_fd_sc_hd__dlclkp_1
XSLICE_16\[1\].RAM16.SLICE\[0\].RAM8.WORD\[2\].W.BYTE\[1\].B.BIT\[7\].genblk1.STORAGE
+ DIBUF\[15\].X SLICE_16\[1\].RAM16.SLICE\[0\].RAM8.WORD\[2\].W.BYTE\[1\].B.GCLK VGND
+ VGND VPWR VPWR SLICE_16\[1\].RAM16.SLICE\[0\].RAM8.WORD\[2\].W.BYTE\[1\].B.Q_WIRE\[7\]
+ sky130_fd_sc_hd__dlxtp_1
XSLICE_16\[1\].RAM16.Do0_REG.OUTREG_BYTE\[2\].Do_FF\[6\] SLICE_16\[1\].RAM16.Do0_REG.CLKBUF\[2\]
+ SLICE_16\[1\].RAM16.BYTE\[2\].FLOATBUF0\[22\].Z VGND VGND VPWR VPWR Do0MUX.A1\[22\]
+ sky130_fd_sc_hd__dfxtp_1
XSLICE_16\[1\].RAM16.SLICE\[0\].RAM8.WORD\[5\].W.BYTE\[3\].B.genblk1.CG SLICE_16\[1\].RAM16.SLICE\[0\].RAM8.WORD\[5\].W.BYTE\[3\].B.CLK_B
+ SLICE_16\[1\].RAM16.SLICE\[0\].RAM8.WORD\[5\].W.BYTE\[3\].B.WE0_WIRE VGND VGND VPWR
+ VPWR SLICE_16\[1\].RAM16.SLICE\[0\].RAM8.WORD\[5\].W.BYTE\[3\].B.GCLK sky130_fd_sc_hd__dlclkp_1
XSLICE_16\[0\].RAM16.SLICE\[0\].RAM8.WORD\[5\].W.BYTE\[3\].B.BIT\[4\].genblk1.STORAGE
+ DIBUF\[28\].X SLICE_16\[0\].RAM16.SLICE\[0\].RAM8.WORD\[5\].W.BYTE\[3\].B.GCLK VGND
+ VGND VPWR VPWR SLICE_16\[0\].RAM16.SLICE\[0\].RAM8.WORD\[5\].W.BYTE\[3\].B.Q_WIRE\[4\]
+ sky130_fd_sc_hd__dlxtp_1
XSLICE_16\[1\].RAM16.SLICE\[1\].RAM8.WORD\[0\].W.BYTE\[2\].B.BIT\[4\].OBUF0 SLICE_16\[1\].RAM16.SLICE\[1\].RAM8.WORD\[0\].W.BYTE\[2\].B.Q_WIRE\[4\]
+ SLICE_16\[1\].RAM16.SLICE\[1\].RAM8.WORD\[0\].W.BYTE\[2\].B.SEL0_B VGND VGND VPWR
+ VPWR SLICE_16\[1\].RAM16.BYTE\[2\].FLOATBUF0\[20\].Z sky130_fd_sc_hd__ebufn_2
Xfill_22_8 VGND VGND VPWR VPWR sky130_fd_sc_hd__decap_12
Xfill_15_7 VGND VGND VPWR VPWR sky130_fd_sc_hd__decap_6
XSLICE_16\[0\].RAM16.SLICE\[0\].RAM8.WORD\[3\].W.BYTE\[1\].B.BIT\[3\].genblk1.STORAGE
+ DIBUF\[11\].X SLICE_16\[0\].RAM16.SLICE\[0\].RAM8.WORD\[3\].W.BYTE\[1\].B.GCLK VGND
+ VGND VPWR VPWR SLICE_16\[0\].RAM16.SLICE\[0\].RAM8.WORD\[3\].W.BYTE\[1\].B.Q_WIRE\[3\]
+ sky130_fd_sc_hd__dlxtp_1
Xfill_43_102 VGND VGND VPWR VPWR sky130_fd_sc_hd__decap_3
Xtap_2_29 VGND VPWR sky130_fd_sc_hd__tapvpwrvgnd_1
Xtap_2_18 VGND VPWR sky130_fd_sc_hd__tapvpwrvgnd_1
XSLICE_16\[0\].RAM16.SLICE\[1\].RAM8.WORD\[2\].W.BYTE\[1\].B.BIT\[5\].OBUF0 SLICE_16\[0\].RAM16.SLICE\[1\].RAM8.WORD\[2\].W.BYTE\[1\].B.Q_WIRE\[5\]
+ SLICE_16\[0\].RAM16.SLICE\[1\].RAM8.WORD\[2\].W.BYTE\[1\].B.SEL0_B VGND VGND VPWR
+ VPWR SLICE_16\[0\].RAM16.BYTE\[1\].FLOATBUF0\[13\].Z sky130_fd_sc_hd__ebufn_2
Xfill_41_0 VGND VPWR sky130_fd_sc_hd__tapvpwrvgnd_1
XSLICE_16\[1\].RAM16.DIODE_A0\[0\].__cell__ A0BUF\[0\].X VGND VGND VPWR VPWR sky130_fd_sc_hd__diode_2
XSLICE_16\[0\].RAM16.SLICE\[1\].RAM8.WORD\[4\].W.BYTE\[1\].B.CGAND SLICE_16\[0\].RAM16.SLICE\[1\].RAM8.WORD\[4\].W.BYTE\[0\].B.SEL0
+ SLICE_16\[0\].RAM16.SLICE\[1\].RAM8.WE0_buf\[1\] VGND VGND VPWR VPWR SLICE_16\[0\].RAM16.SLICE\[1\].RAM8.WORD\[4\].W.BYTE\[1\].B.WE0_WIRE
+ sky130_fd_sc_hd__and2_1
XSLICE_16\[0\].RAM16.BYTE\[2\].FLOATBUF0\[21\].__cell__ SLICE_16\[0\].RAM16.BYTE\[2\].FLOATBUF0\[16\].A
+ SLICE_16\[0\].RAM16.BYTE\[2\].FLOATBUF0\[16\].TE_B VGND VGND VPWR VPWR SLICE_16\[0\].RAM16.BYTE\[2\].FLOATBUF0\[21\].Z
+ sky130_fd_sc_hd__ebufn_2
XSLICE_16\[0\].RAM16.SLICE\[0\].RAM8.WORD\[1\].W.BYTE\[3\].B.BIT\[7\].OBUF0 SLICE_16\[0\].RAM16.SLICE\[0\].RAM8.WORD\[1\].W.BYTE\[3\].B.Q_WIRE\[7\]
+ SLICE_16\[0\].RAM16.SLICE\[0\].RAM8.WORD\[1\].W.BYTE\[3\].B.SEL0_B VGND VGND VPWR
+ VPWR SLICE_16\[0\].RAM16.BYTE\[3\].FLOATBUF0\[31\].Z sky130_fd_sc_hd__ebufn_2
XSLICE_16\[1\].RAM16.SLICE\[1\].RAM8.WORD\[6\].W.BYTE\[0\].B.BIT\[0\].genblk1.STORAGE
+ DIBUF\[0\].X SLICE_16\[1\].RAM16.SLICE\[1\].RAM8.WORD\[6\].W.BYTE\[0\].B.GCLK VGND
+ VGND VPWR VPWR SLICE_16\[1\].RAM16.SLICE\[1\].RAM8.WORD\[6\].W.BYTE\[0\].B.Q_WIRE\[0\]
+ sky130_fd_sc_hd__dlxtp_1
XSLICE_16\[1\].RAM16.SLICE\[1\].RAM8.WORD\[3\].W.BYTE\[3\].B.BIT\[4\].OBUF0 SLICE_16\[1\].RAM16.SLICE\[1\].RAM8.WORD\[3\].W.BYTE\[3\].B.Q_WIRE\[4\]
+ SLICE_16\[1\].RAM16.SLICE\[1\].RAM8.WORD\[3\].W.BYTE\[3\].B.SEL0_B VGND VGND VPWR
+ VPWR SLICE_16\[1\].RAM16.BYTE\[3\].FLOATBUF0\[28\].Z sky130_fd_sc_hd__ebufn_2
XSLICE_16\[1\].RAM16.SLICE\[1\].RAM8.WORD\[2\].W.BYTE\[3\].B.BIT\[2\].genblk1.STORAGE
+ DIBUF\[26\].X SLICE_16\[1\].RAM16.SLICE\[1\].RAM8.WORD\[2\].W.BYTE\[3\].B.GCLK VGND
+ VGND VPWR VPWR SLICE_16\[1\].RAM16.SLICE\[1\].RAM8.WORD\[2\].W.BYTE\[3\].B.Q_WIRE\[2\]
+ sky130_fd_sc_hd__dlxtp_1
XSLICE_16\[1\].RAM16.SLICE\[1\].RAM8.WORD\[0\].W.BYTE\[1\].B.BIT\[1\].genblk1.STORAGE
+ DIBUF\[9\].X SLICE_16\[1\].RAM16.SLICE\[1\].RAM8.WORD\[0\].W.BYTE\[1\].B.GCLK VGND
+ VGND VPWR VPWR SLICE_16\[1\].RAM16.SLICE\[1\].RAM8.WORD\[0\].W.BYTE\[1\].B.Q_WIRE\[1\]
+ sky130_fd_sc_hd__dlxtp_1
Xfill_18_22 VGND VGND VPWR VPWR sky130_fd_sc_hd__decap_12
Xfill_18_11 VGND VGND VPWR VPWR sky130_fd_sc_hd__decap_12
XSLICE_16\[0\].RAM16.SLICE\[0\].RAM8.DEC0.ABUF\[0\] SLICE_16\[0\].RAM16.A0BUF\[0\].X
+ VGND VGND VPWR VPWR SLICE_16\[0\].RAM16.SLICE\[0\].RAM8.DEC0.A_buf\[0\] sky130_fd_sc_hd__clkbuf_2
XSLICE_16\[1\].RAM16.SLICE\[1\].RAM8.WORD\[7\].W.BYTE\[2\].B.DIODE_CLK SLICE_16\[1\].RAM16.SLICE\[1\].RAM8.WORD\[7\].W.BYTE\[0\].B.CLK
+ VGND VGND VPWR VPWR sky130_fd_sc_hd__diode_2
XSLICE_16\[0\].RAM16.SLICE\[1\].RAM8.WORD\[5\].W.BYTE\[2\].B.BIT\[5\].OBUF0 SLICE_16\[0\].RAM16.SLICE\[1\].RAM8.WORD\[5\].W.BYTE\[2\].B.Q_WIRE\[5\]
+ SLICE_16\[0\].RAM16.SLICE\[1\].RAM8.WORD\[5\].W.BYTE\[2\].B.SEL0_B VGND VGND VPWR
+ VPWR SLICE_16\[0\].RAM16.BYTE\[2\].FLOATBUF0\[21\].Z sky130_fd_sc_hd__ebufn_2
XSLICE_16\[1\].RAM16.SLICE\[0\].RAM8.WORD\[5\].W.BYTE\[2\].B.BIT\[7\].genblk1.STORAGE
+ DIBUF\[23\].X SLICE_16\[1\].RAM16.SLICE\[0\].RAM8.WORD\[5\].W.BYTE\[2\].B.GCLK VGND
+ VGND VPWR VPWR SLICE_16\[1\].RAM16.SLICE\[0\].RAM8.WORD\[5\].W.BYTE\[2\].B.Q_WIRE\[7\]
+ sky130_fd_sc_hd__dlxtp_1
XSLICE_16\[1\].RAM16.SLICE\[0\].RAM8.WORD\[3\].W.BYTE\[0\].B.BIT\[6\].genblk1.STORAGE
+ DIBUF\[6\].X SLICE_16\[1\].RAM16.SLICE\[0\].RAM8.WORD\[3\].W.BYTE\[0\].B.GCLK VGND
+ VGND VPWR VPWR SLICE_16\[1\].RAM16.SLICE\[0\].RAM8.WORD\[3\].W.BYTE\[0\].B.Q_WIRE\[6\]
+ sky130_fd_sc_hd__dlxtp_1
Xfill_20_5 VGND VGND VPWR VPWR sky130_fd_sc_hd__decap_12
Xfill_13_4 VGND VGND VPWR VPWR sky130_fd_sc_hd__fill_2
XSLICE_16\[0\].RAM16.SLICE\[0\].RAM8.WORD\[0\].W.BYTE\[1\].B.BIT\[4\].OBUF0 SLICE_16\[0\].RAM16.SLICE\[0\].RAM8.WORD\[0\].W.BYTE\[1\].B.Q_WIRE\[4\]
+ SLICE_16\[0\].RAM16.SLICE\[0\].RAM8.WORD\[0\].W.BYTE\[1\].B.SEL0_B VGND VGND VPWR
+ VPWR SLICE_16\[0\].RAM16.BYTE\[1\].FLOATBUF0\[12\].Z sky130_fd_sc_hd__ebufn_2
XSLICE_16\[1\].RAM16.DIODE_CLK.__cell__ CLK VGND VGND VPWR VPWR sky130_fd_sc_hd__diode_2
XSLICE_16\[1\].RAM16.SLICE\[1\].RAM8.WORD\[2\].W.BYTE\[1\].B.BIT\[1\].OBUF0 SLICE_16\[1\].RAM16.SLICE\[1\].RAM8.WORD\[2\].W.BYTE\[1\].B.Q_WIRE\[1\]
+ SLICE_16\[1\].RAM16.SLICE\[1\].RAM8.WORD\[2\].W.BYTE\[1\].B.SEL0_B VGND VGND VPWR
+ VPWR SLICE_16\[1\].RAM16.BYTE\[1\].FLOATBUF0\[9\].Z sky130_fd_sc_hd__ebufn_2
XSLICE_16\[0\].RAM16.SLICE\[1\].RAM8.WORD\[5\].W.BYTE\[0\].B.BIT\[7\].genblk1.STORAGE
+ DIBUF\[7\].X SLICE_16\[0\].RAM16.SLICE\[1\].RAM8.WORD\[5\].W.BYTE\[0\].B.GCLK VGND
+ VGND VPWR VPWR SLICE_16\[0\].RAM16.SLICE\[1\].RAM8.WORD\[5\].W.BYTE\[0\].B.Q_WIRE\[7\]
+ sky130_fd_sc_hd__dlxtp_1
XSLICE_16\[0\].RAM16.Do0_REG.OUTREG_BYTE\[1\].DIODE\[6\] SLICE_16\[0\].RAM16.BYTE\[1\].FLOATBUF0\[14\].Z
+ VGND VGND VPWR VPWR sky130_fd_sc_hd__diode_2
XSLICE_16\[0\].RAM16.SLICE\[0\].RAM8.WORD\[0\].W.BYTE\[3\].B.BIT\[4\].genblk1.STORAGE
+ DIBUF\[28\].X SLICE_16\[0\].RAM16.SLICE\[0\].RAM8.WORD\[0\].W.BYTE\[3\].B.GCLK VGND
+ VGND VPWR VPWR SLICE_16\[0\].RAM16.SLICE\[0\].RAM8.WORD\[0\].W.BYTE\[3\].B.Q_WIRE\[4\]
+ sky130_fd_sc_hd__dlxtp_1
XSLICE_16\[0\].RAM16.SLICE\[0\].RAM8.WORD\[6\].W.BYTE\[2\].B.BIT\[3\].genblk1.STORAGE
+ DIBUF\[19\].X SLICE_16\[0\].RAM16.SLICE\[0\].RAM8.WORD\[6\].W.BYTE\[2\].B.GCLK VGND
+ VGND VPWR VPWR SLICE_16\[0\].RAM16.SLICE\[0\].RAM8.WORD\[6\].W.BYTE\[2\].B.Q_WIRE\[3\]
+ sky130_fd_sc_hd__dlxtp_1
XSLICE_16\[1\].RAM16.SLICE\[0\].RAM8.DEC0.AND1 SLICE_16\[1\].RAM16.SLICE\[0\].RAM8.DEC0.A_buf\[2\]
+ SLICE_16\[1\].RAM16.SLICE\[0\].RAM8.DEC0.A_buf\[1\] SLICE_16\[1\].RAM16.SLICE\[0\].RAM8.DEC0.A_buf\[0\]
+ SLICE_16\[1\].RAM16.SLICE\[0\].RAM8.DEC0.EN_buf VGND VGND VPWR VPWR SLICE_16\[1\].RAM16.SLICE\[0\].RAM8.DEC0.SEL\[1\]
+ sky130_fd_sc_hd__and4bb_2
Xtap_16_25 VGND VPWR sky130_fd_sc_hd__tapvpwrvgnd_1
Xtap_16_14 VGND VPWR sky130_fd_sc_hd__tapvpwrvgnd_1
XSLICE_16\[0\].RAM16.SLICE\[0\].RAM8.WORD\[4\].W.BYTE\[0\].B.BIT\[2\].genblk1.STORAGE
+ DIBUF\[2\].X SLICE_16\[0\].RAM16.SLICE\[0\].RAM8.WORD\[4\].W.BYTE\[0\].B.GCLK VGND
+ VGND VPWR VPWR SLICE_16\[0\].RAM16.SLICE\[0\].RAM8.WORD\[4\].W.BYTE\[0\].B.Q_WIRE\[2\]
+ sky130_fd_sc_hd__dlxtp_1
Xtap_32_35 VGND VPWR sky130_fd_sc_hd__tapvpwrvgnd_1
Xtap_32_24 VGND VPWR sky130_fd_sc_hd__tapvpwrvgnd_1
Xtap_32_13 VGND VPWR sky130_fd_sc_hd__tapvpwrvgnd_1
XSLICE_16\[1\].RAM16.SLICE\[0\].RAM8.WORD\[5\].W.BYTE\[1\].B.SEL0INV SLICE_16\[1\].RAM16.SLICE\[0\].RAM8.WORD\[5\].W.BYTE\[0\].B.SEL0
+ VGND VGND VPWR VPWR SLICE_16\[1\].RAM16.SLICE\[0\].RAM8.WORD\[5\].W.BYTE\[1\].B.SEL0_B
+ sky130_fd_sc_hd__inv_1
XSLICE_16\[1\].RAM16.SLICE\[0\].RAM8.WORD\[2\].W.BYTE\[0\].B.genblk1.CLKINV SLICE_16\[1\].RAM16.SLICE\[0\].RAM8.WORD\[2\].W.BYTE\[0\].B.CLK
+ VGND VGND VPWR VPWR SLICE_16\[1\].RAM16.SLICE\[0\].RAM8.WORD\[2\].W.BYTE\[0\].B.CLK_B
+ sky130_fd_sc_hd__inv_1
XSLICE_16\[0\].RAM16.SLICE\[1\].RAM8.WORD\[4\].W.BYTE\[0\].B.BIT\[2\].OBUF0 SLICE_16\[0\].RAM16.SLICE\[1\].RAM8.WORD\[4\].W.BYTE\[0\].B.Q_WIRE\[2\]
+ SLICE_16\[0\].RAM16.SLICE\[1\].RAM8.WORD\[4\].W.BYTE\[0\].B.SEL0_B VGND VGND VPWR
+ VPWR SLICE_16\[0\].RAM16.BYTE\[0\].FLOATBUF0\[2\].Z sky130_fd_sc_hd__ebufn_2
Xtap_47_2 VGND VPWR sky130_fd_sc_hd__tapvpwrvgnd_1
XSLICE_16\[1\].RAM16.SLICE\[0\].RAM8.WORD\[1\].W.BYTE\[3\].B.BIT\[3\].OBUF0 SLICE_16\[1\].RAM16.SLICE\[0\].RAM8.WORD\[1\].W.BYTE\[3\].B.Q_WIRE\[3\]
+ SLICE_16\[1\].RAM16.SLICE\[0\].RAM8.WORD\[1\].W.BYTE\[3\].B.SEL0_B VGND VGND VPWR
+ VPWR SLICE_16\[1\].RAM16.BYTE\[3\].FLOATBUF0\[27\].Z sky130_fd_sc_hd__ebufn_2
Xfill_20_78 VGND VPWR sky130_fd_sc_hd__tapvpwrvgnd_1
Xfill_20_67 VGND VGND VPWR VPWR sky130_fd_sc_hd__decap_12
Xfill_20_56 VGND VGND VPWR VPWR sky130_fd_sc_hd__decap_12
Xfill_20_45 VGND VPWR sky130_fd_sc_hd__tapvpwrvgnd_1
Xfill_20_34 VGND VGND VPWR VPWR sky130_fd_sc_hd__decap_12
Xfill_20_23 VGND VGND VPWR VPWR sky130_fd_sc_hd__decap_12
Xfill_20_12 VGND VPWR sky130_fd_sc_hd__tapvpwrvgnd_1
Xfill_20_89 VGND VGND VPWR VPWR sky130_fd_sc_hd__decap_12
Xfill_45_97 VGND VGND VPWR VPWR sky130_fd_sc_hd__decap_12
Xfill_45_86 VGND VGND VPWR VPWR sky130_fd_sc_hd__decap_12
Xfill_45_75 VGND VPWR sky130_fd_sc_hd__tapvpwrvgnd_1
Xfill_45_64 VGND VGND VPWR VPWR sky130_fd_sc_hd__decap_12
Xfill_45_53 VGND VGND VPWR VPWR sky130_fd_sc_hd__decap_12
Xfill_45_42 VGND VPWR sky130_fd_sc_hd__tapvpwrvgnd_1
Xfill_45_31 VGND VGND VPWR VPWR sky130_fd_sc_hd__decap_12
Xfill_45_20 VGND VGND VPWR VPWR sky130_fd_sc_hd__decap_12
XSLICE_16\[0\].RAM16.SLICE\[1\].RAM8.WORD\[7\].W.BYTE\[3\].B.SEL0INV SLICE_16\[0\].RAM16.SLICE\[1\].RAM8.WORD\[7\].W.BYTE\[0\].B.SEL0
+ VGND VGND VPWR VPWR SLICE_16\[0\].RAM16.SLICE\[1\].RAM8.WORD\[7\].W.BYTE\[3\].B.SEL0_B
+ sky130_fd_sc_hd__inv_1
XSLICE_16\[0\].RAM16.SLICE\[0\].RAM8.WORD\[3\].W.BYTE\[2\].B.BIT\[4\].OBUF0 SLICE_16\[0\].RAM16.SLICE\[0\].RAM8.WORD\[3\].W.BYTE\[2\].B.Q_WIRE\[4\]
+ SLICE_16\[0\].RAM16.SLICE\[0\].RAM8.WORD\[3\].W.BYTE\[2\].B.SEL0_B VGND VGND VPWR
+ VPWR SLICE_16\[0\].RAM16.BYTE\[2\].FLOATBUF0\[20\].Z sky130_fd_sc_hd__ebufn_2
XSLICE_16\[1\].RAM16.SLICE\[1\].RAM8.WORD\[5\].W.BYTE\[2\].B.BIT\[1\].OBUF0 SLICE_16\[1\].RAM16.SLICE\[1\].RAM8.WORD\[5\].W.BYTE\[2\].B.Q_WIRE\[1\]
+ SLICE_16\[1\].RAM16.SLICE\[1\].RAM8.WORD\[5\].W.BYTE\[2\].B.SEL0_B VGND VGND VPWR
+ VPWR SLICE_16\[1\].RAM16.BYTE\[2\].FLOATBUF0\[17\].Z sky130_fd_sc_hd__ebufn_2
XSLICE_16\[1\].RAM16.SLICE\[1\].RAM8.WORD\[3\].W.BYTE\[2\].B.BIT\[1\].genblk1.STORAGE
+ DIBUF\[17\].X SLICE_16\[1\].RAM16.SLICE\[1\].RAM8.WORD\[3\].W.BYTE\[2\].B.GCLK VGND
+ VGND VPWR VPWR SLICE_16\[1\].RAM16.SLICE\[1\].RAM8.WORD\[3\].W.BYTE\[2\].B.Q_WIRE\[1\]
+ sky130_fd_sc_hd__dlxtp_1
XSLICE_16\[1\].RAM16.SLICE\[1\].RAM8.WORD\[1\].W.BYTE\[0\].B.BIT\[0\].genblk1.STORAGE
+ DIBUF\[0\].X SLICE_16\[1\].RAM16.SLICE\[1\].RAM8.WORD\[1\].W.BYTE\[0\].B.GCLK VGND
+ VGND VPWR VPWR SLICE_16\[1\].RAM16.SLICE\[1\].RAM8.WORD\[1\].W.BYTE\[0\].B.Q_WIRE\[0\]
+ sky130_fd_sc_hd__dlxtp_1
XSLICE_16\[1\].RAM16.SLICE\[0\].RAM8.WORD\[0\].W.BYTE\[1\].B.BIT\[0\].OBUF0 SLICE_16\[1\].RAM16.SLICE\[0\].RAM8.WORD\[0\].W.BYTE\[1\].B.Q_WIRE\[0\]
+ SLICE_16\[1\].RAM16.SLICE\[0\].RAM8.WORD\[0\].W.BYTE\[1\].B.SEL0_B VGND VGND VPWR
+ VPWR SLICE_16\[1\].RAM16.BYTE\[1\].FLOATBUF0\[8\].Z sky130_fd_sc_hd__ebufn_2
XSLICE_16\[0\].RAM16.SLICE\[1\].RAM8.WORD\[7\].W.BYTE\[1\].B.BIT\[2\].OBUF0 SLICE_16\[0\].RAM16.SLICE\[1\].RAM8.WORD\[7\].W.BYTE\[1\].B.Q_WIRE\[2\]
+ SLICE_16\[0\].RAM16.SLICE\[1\].RAM8.WORD\[7\].W.BYTE\[1\].B.SEL0_B VGND VGND VPWR
+ VPWR SLICE_16\[0\].RAM16.BYTE\[1\].FLOATBUF0\[10\].Z sky130_fd_sc_hd__ebufn_2
XSLICE_16\[0\].RAM16.SLICE\[0\].RAM8.WORD\[3\].W.BYTE\[2\].B.SEL0INV SLICE_16\[0\].RAM16.SLICE\[0\].RAM8.WORD\[3\].W.BYTE\[0\].B.SEL0
+ VGND VGND VPWR VPWR SLICE_16\[0\].RAM16.SLICE\[0\].RAM8.WORD\[3\].W.BYTE\[2\].B.SEL0_B
+ sky130_fd_sc_hd__inv_1
XSLICE_16\[1\].RAM16.SLICE\[0\].RAM8.WORD\[5\].W.BYTE\[1\].B.genblk1.CLKINV SLICE_16\[1\].RAM16.SLICE\[0\].RAM8.WORD\[5\].W.BYTE\[0\].B.CLK
+ VGND VGND VPWR VPWR SLICE_16\[1\].RAM16.SLICE\[0\].RAM8.WORD\[5\].W.BYTE\[1\].B.CLK_B
+ sky130_fd_sc_hd__inv_1
XSLICE_16\[0\].RAM16.Do0_REG.OUTREG_BYTE\[0\].Do_FF\[7\] SLICE_16\[0\].RAM16.Do0_REG.CLKBUF\[0\]
+ SLICE_16\[0\].RAM16.BYTE\[0\].FLOATBUF0\[7\].Z VGND VGND VPWR VPWR Do0MUX.A0\[7\]
+ sky130_fd_sc_hd__dfxtp_1
Xfill_11_1 VGND VPWR sky130_fd_sc_hd__tapvpwrvgnd_1
Xtap_8_17 VGND VPWR sky130_fd_sc_hd__tapvpwrvgnd_1
Xtap_8_28 VGND VPWR sky130_fd_sc_hd__tapvpwrvgnd_1
Xfill_9_3 VGND VGND VPWR VPWR sky130_fd_sc_hd__decap_6
Xtap_40_9 VGND VPWR sky130_fd_sc_hd__tapvpwrvgnd_1
Xtap_33_8 VGND VPWR sky130_fd_sc_hd__tapvpwrvgnd_1
XSLICE_16\[1\].RAM16.SLICE\[1\].RAM8.WORD\[2\].W.SEL0BUF SLICE_16\[1\].RAM16.SLICE\[1\].RAM8.DEC0.SEL\[2\]
+ VGND VGND VPWR VPWR SLICE_16\[1\].RAM16.SLICE\[1\].RAM8.WORD\[2\].W.BYTE\[0\].B.SEL0
+ sky130_fd_sc_hd__clkbuf_2
XSLICE_16\[1\].RAM16.SLICE\[0\].RAM8.WORD\[6\].W.BYTE\[1\].B.BIT\[6\].genblk1.STORAGE
+ DIBUF\[14\].X SLICE_16\[1\].RAM16.SLICE\[0\].RAM8.WORD\[6\].W.BYTE\[1\].B.GCLK VGND
+ VGND VPWR VPWR SLICE_16\[1\].RAM16.SLICE\[0\].RAM8.WORD\[6\].W.BYTE\[1\].B.Q_WIRE\[6\]
+ sky130_fd_sc_hd__dlxtp_1
Xtap_27_35 VGND VPWR sky130_fd_sc_hd__tapvpwrvgnd_1
Xtap_27_24 VGND VPWR sky130_fd_sc_hd__tapvpwrvgnd_1
Xtap_27_13 VGND VPWR sky130_fd_sc_hd__tapvpwrvgnd_1
Xtap_26_7 VGND VPWR sky130_fd_sc_hd__tapvpwrvgnd_1
XSLICE_16\[1\].RAM16.SLICE\[0\].RAM8.WORD\[0\].W.BYTE\[2\].B.BIT\[7\].genblk1.STORAGE
+ DIBUF\[23\].X SLICE_16\[1\].RAM16.SLICE\[0\].RAM8.WORD\[0\].W.BYTE\[2\].B.GCLK VGND
+ VGND VPWR VPWR SLICE_16\[1\].RAM16.SLICE\[0\].RAM8.WORD\[0\].W.BYTE\[2\].B.Q_WIRE\[7\]
+ sky130_fd_sc_hd__dlxtp_1
XSLICE_16\[0\].RAM16.SLICE\[0\].RAM8.WORD\[2\].W.BYTE\[0\].B.BIT\[1\].OBUF0 SLICE_16\[0\].RAM16.SLICE\[0\].RAM8.WORD\[2\].W.BYTE\[0\].B.Q_WIRE\[1\]
+ SLICE_16\[0\].RAM16.SLICE\[0\].RAM8.WORD\[2\].W.BYTE\[0\].B.SEL0_B VGND VGND VPWR
+ VPWR SLICE_16\[0\].RAM16.BYTE\[0\].FLOATBUF0\[1\].Z sky130_fd_sc_hd__ebufn_2
XSLICE_16\[0\].RAM16.SLICE\[0\].RAM8.WORD\[6\].W.BYTE\[3\].B.BIT\[4\].OBUF0 SLICE_16\[0\].RAM16.SLICE\[0\].RAM8.WORD\[6\].W.BYTE\[3\].B.Q_WIRE\[4\]
+ SLICE_16\[0\].RAM16.SLICE\[0\].RAM8.WORD\[6\].W.BYTE\[3\].B.SEL0_B VGND VGND VPWR
+ VPWR SLICE_16\[0\].RAM16.BYTE\[3\].FLOATBUF0\[28\].Z sky130_fd_sc_hd__ebufn_2
XSLICE_16\[0\].RAM16.SLICE\[1\].RAM8.WORD\[0\].W.BYTE\[0\].B.BIT\[7\].genblk1.STORAGE
+ DIBUF\[7\].X SLICE_16\[0\].RAM16.SLICE\[1\].RAM8.WORD\[0\].W.BYTE\[0\].B.GCLK VGND
+ VGND VPWR VPWR SLICE_16\[0\].RAM16.SLICE\[1\].RAM8.WORD\[0\].W.BYTE\[0\].B.Q_WIRE\[7\]
+ sky130_fd_sc_hd__dlxtp_1
XSLICE_16\[0\].RAM16.SLICE\[0\].RAM8.WORD\[1\].W.BYTE\[2\].B.BIT\[3\].genblk1.STORAGE
+ DIBUF\[19\].X SLICE_16\[0\].RAM16.SLICE\[0\].RAM8.WORD\[1\].W.BYTE\[2\].B.GCLK VGND
+ VGND VPWR VPWR SLICE_16\[0\].RAM16.SLICE\[0\].RAM8.WORD\[1\].W.BYTE\[2\].B.Q_WIRE\[3\]
+ sky130_fd_sc_hd__dlxtp_1
XSLICE_16\[0\].RAM16.SLICE\[0\].RAM8.WORD\[7\].W.BYTE\[1\].B.BIT\[2\].genblk1.STORAGE
+ DIBUF\[10\].X SLICE_16\[0\].RAM16.SLICE\[0\].RAM8.WORD\[7\].W.BYTE\[1\].B.GCLK VGND
+ VGND VPWR VPWR SLICE_16\[0\].RAM16.SLICE\[0\].RAM8.WORD\[7\].W.BYTE\[1\].B.Q_WIRE\[2\]
+ sky130_fd_sc_hd__dlxtp_1
XSLICE_16\[1\].RAM16.SLICE\[1\].RAM8.WORD\[5\].W.BYTE\[0\].B.BIT\[6\].OBUF0 SLICE_16\[1\].RAM16.SLICE\[1\].RAM8.WORD\[5\].W.BYTE\[0\].B.Q_WIRE\[6\]
+ SLICE_16\[1\].RAM16.SLICE\[1\].RAM8.WORD\[5\].W.BYTE\[0\].B.SEL0_B VGND VGND VPWR
+ VPWR SLICE_16\[1\].RAM16.BYTE\[0\].FLOATBUF0\[6\].Z sky130_fd_sc_hd__ebufn_2
XSLICE_16\[1\].RAM16.SLICE\[0\].RAM8.WORD\[3\].W.BYTE\[2\].B.BIT\[0\].OBUF0 SLICE_16\[1\].RAM16.SLICE\[0\].RAM8.WORD\[3\].W.BYTE\[2\].B.Q_WIRE\[0\]
+ SLICE_16\[1\].RAM16.SLICE\[0\].RAM8.WORD\[3\].W.BYTE\[2\].B.SEL0_B VGND VGND VPWR
+ VPWR SLICE_16\[1\].RAM16.BYTE\[2\].FLOATBUF0\[16\].Z sky130_fd_sc_hd__ebufn_2
XSLICE_16\[0\].RAM16.SLICE\[0\].RAM8.WORD\[4\].W.BYTE\[3\].B.genblk1.CG SLICE_16\[0\].RAM16.SLICE\[0\].RAM8.WORD\[4\].W.BYTE\[3\].B.CLK_B
+ SLICE_16\[0\].RAM16.SLICE\[0\].RAM8.WORD\[4\].W.BYTE\[3\].B.WE0_WIRE VGND VGND VPWR
+ VPWR SLICE_16\[0\].RAM16.SLICE\[0\].RAM8.WORD\[4\].W.BYTE\[3\].B.GCLK sky130_fd_sc_hd__dlclkp_1
XSLICE_16\[0\].RAM16.SLICE\[0\].RAM8.WORD\[5\].W.BYTE\[1\].B.BIT\[1\].OBUF0 SLICE_16\[0\].RAM16.SLICE\[0\].RAM8.WORD\[5\].W.BYTE\[1\].B.Q_WIRE\[1\]
+ SLICE_16\[0\].RAM16.SLICE\[0\].RAM8.WORD\[5\].W.BYTE\[1\].B.SEL0_B VGND VGND VPWR
+ VPWR SLICE_16\[0\].RAM16.BYTE\[1\].FLOATBUF0\[9\].Z sky130_fd_sc_hd__ebufn_2
XSLICE_16\[0\].RAM16.SLICE\[1\].RAM8.WORD\[0\].W.BYTE\[0\].B.CGAND SLICE_16\[0\].RAM16.SLICE\[1\].RAM8.WORD\[0\].W.BYTE\[0\].B.SEL0
+ SLICE_16\[0\].RAM16.SLICE\[1\].RAM8.WE0_buf\[0\] VGND VGND VPWR VPWR SLICE_16\[0\].RAM16.SLICE\[1\].RAM8.WORD\[0\].W.BYTE\[0\].B.WE0_WIRE
+ sky130_fd_sc_hd__and2_1
Xtap_13_15 VGND VPWR sky130_fd_sc_hd__tapvpwrvgnd_1
Xfill_7_0 VGND VPWR sky130_fd_sc_hd__tapvpwrvgnd_1
XSLICE_16\[1\].RAM16.SLICE\[1\].RAM8.WORD\[6\].W.BYTE\[3\].B.BIT\[1\].genblk1.STORAGE
+ DIBUF\[25\].X SLICE_16\[1\].RAM16.SLICE\[1\].RAM8.WORD\[6\].W.BYTE\[3\].B.GCLK VGND
+ VGND VPWR VPWR SLICE_16\[1\].RAM16.SLICE\[1\].RAM8.WORD\[6\].W.BYTE\[3\].B.Q_WIRE\[1\]
+ sky130_fd_sc_hd__dlxtp_1
XSLICE_16\[1\].RAM16.SLICE\[1\].RAM8.WORD\[3\].W.CLKBUF SLICE_16\[1\].RAM16.SLICE\[1\].RAM8.CLKBUF.X
+ VGND VGND VPWR VPWR SLICE_16\[1\].RAM16.SLICE\[1\].RAM8.WORD\[3\].W.BYTE\[0\].B.CLK
+ sky130_fd_sc_hd__clkbuf_4
Xtap_13_26 VGND VPWR sky130_fd_sc_hd__tapvpwrvgnd_1
Xtap_38_34 VGND VPWR sky130_fd_sc_hd__tapvpwrvgnd_1
Xtap_38_23 VGND VPWR sky130_fd_sc_hd__tapvpwrvgnd_1
Xtap_38_12 VGND VPWR sky130_fd_sc_hd__tapvpwrvgnd_1
XSLICE_16\[1\].RAM16.SLICE\[1\].RAM8.WORD\[4\].W.BYTE\[1\].B.BIT\[0\].genblk1.STORAGE
+ DIBUF\[8\].X SLICE_16\[1\].RAM16.SLICE\[1\].RAM8.WORD\[4\].W.BYTE\[1\].B.GCLK VGND
+ VGND VPWR VPWR SLICE_16\[1\].RAM16.SLICE\[1\].RAM8.WORD\[4\].W.BYTE\[1\].B.Q_WIRE\[0\]
+ sky130_fd_sc_hd__dlxtp_1
Xtap_31_5 VGND VPWR sky130_fd_sc_hd__tapvpwrvgnd_1
Xtap_24_4 VGND VPWR sky130_fd_sc_hd__tapvpwrvgnd_1
XSLICE_16\[0\].RAM16.SLICE\[0\].RAM8.DEC0.AND5 SLICE_16\[0\].RAM16.SLICE\[0\].RAM8.DEC0.A_buf\[1\]
+ SLICE_16\[0\].RAM16.SLICE\[0\].RAM8.DEC0.A_buf\[0\] SLICE_16\[0\].RAM16.SLICE\[0\].RAM8.DEC0.A_buf\[2\]
+ SLICE_16\[0\].RAM16.SLICE\[0\].RAM8.DEC0.EN_buf VGND VGND VPWR VPWR SLICE_16\[0\].RAM16.SLICE\[0\].RAM8.DEC0.SEL\[5\]
+ sky130_fd_sc_hd__and4b_2
XSLICE_16\[1\].RAM16.Do0_REG.OUTREG_BYTE\[0\].DIODE\[2\] SLICE_16\[1\].RAM16.BYTE\[0\].FLOATBUF0\[2\].Z
+ VGND VGND VPWR VPWR sky130_fd_sc_hd__diode_2
XSLICE_16\[1\].RAM16.SLICE\[0\].RAM8.WORD\[6\].W.BYTE\[3\].B.BIT\[0\].OBUF0 SLICE_16\[1\].RAM16.SLICE\[0\].RAM8.WORD\[6\].W.BYTE\[3\].B.Q_WIRE\[0\]
+ SLICE_16\[1\].RAM16.SLICE\[0\].RAM8.WORD\[6\].W.BYTE\[3\].B.SEL0_B VGND VGND VPWR
+ VPWR SLICE_16\[1\].RAM16.BYTE\[3\].FLOATBUF0\[24\].Z sky130_fd_sc_hd__ebufn_2
Xtap_17_3 VGND VPWR sky130_fd_sc_hd__tapvpwrvgnd_1
Xfill_42_21 VGND VPWR sky130_fd_sc_hd__tapvpwrvgnd_1
Xfill_42_10 VGND VGND VPWR VPWR sky130_fd_sc_hd__decap_12
XSLICE_16\[1\].RAM16.SLICE\[0\].RAM8.WORD\[1\].W.BYTE\[2\].B.genblk1.CG SLICE_16\[1\].RAM16.SLICE\[0\].RAM8.WORD\[1\].W.BYTE\[2\].B.CLK_B
+ SLICE_16\[1\].RAM16.SLICE\[0\].RAM8.WORD\[1\].W.BYTE\[2\].B.WE0_WIRE VGND VGND VPWR
+ VPWR SLICE_16\[1\].RAM16.SLICE\[0\].RAM8.WORD\[1\].W.BYTE\[2\].B.GCLK sky130_fd_sc_hd__dlclkp_1
Xfill_42_98 VGND VGND VPWR VPWR sky130_fd_sc_hd__decap_12
Xfill_42_87 VGND VPWR sky130_fd_sc_hd__tapvpwrvgnd_1
Xfill_42_76 VGND VGND VPWR VPWR sky130_fd_sc_hd__decap_12
Xfill_42_65 VGND VGND VPWR VPWR sky130_fd_sc_hd__decap_12
Xfill_42_54 VGND VPWR sky130_fd_sc_hd__tapvpwrvgnd_1
Xfill_42_43 VGND VGND VPWR VPWR sky130_fd_sc_hd__decap_12
Xfill_42_32 VGND VGND VPWR VPWR sky130_fd_sc_hd__decap_12
XSLICE_16\[1\].RAM16.SLICE\[0\].RAM8.WORD\[3\].W.BYTE\[3\].B.BIT\[7\].genblk1.STORAGE
+ DIBUF\[31\].X SLICE_16\[1\].RAM16.SLICE\[0\].RAM8.WORD\[3\].W.BYTE\[3\].B.GCLK VGND
+ VGND VPWR VPWR SLICE_16\[1\].RAM16.SLICE\[0\].RAM8.WORD\[3\].W.BYTE\[3\].B.Q_WIRE\[7\]
+ sky130_fd_sc_hd__dlxtp_1
XSLICE_16\[1\].RAM16.SLICE\[0\].RAM8.WORD\[3\].W.BYTE\[0\].B.BIT\[5\].OBUF0 SLICE_16\[1\].RAM16.SLICE\[0\].RAM8.WORD\[3\].W.BYTE\[0\].B.Q_WIRE\[5\]
+ SLICE_16\[1\].RAM16.SLICE\[0\].RAM8.WORD\[3\].W.BYTE\[0\].B.SEL0_B VGND VGND VPWR
+ VPWR SLICE_16\[1\].RAM16.BYTE\[0\].FLOATBUF0\[5\].Z sky130_fd_sc_hd__ebufn_2
XSLICE_16\[0\].RAM16.SLICE\[1\].RAM8.WORD\[0\].W.BYTE\[2\].B.BIT\[4\].OBUF0 SLICE_16\[0\].RAM16.SLICE\[1\].RAM8.WORD\[0\].W.BYTE\[2\].B.Q_WIRE\[4\]
+ SLICE_16\[0\].RAM16.SLICE\[1\].RAM8.WORD\[0\].W.BYTE\[2\].B.SEL0_B VGND VGND VPWR
+ VPWR SLICE_16\[0\].RAM16.BYTE\[2\].FLOATBUF0\[20\].Z sky130_fd_sc_hd__ebufn_2
XSLICE_16\[1\].RAM16.SLICE\[1\].RAM8.WORD\[5\].W.BYTE\[3\].B.SEL0INV SLICE_16\[1\].RAM16.SLICE\[1\].RAM8.WORD\[5\].W.BYTE\[0\].B.SEL0
+ VGND VGND VPWR VPWR SLICE_16\[1\].RAM16.SLICE\[1\].RAM8.WORD\[5\].W.BYTE\[3\].B.SEL0_B
+ sky130_fd_sc_hd__inv_1
XSLICE_16\[1\].RAM16.SLICE\[0\].RAM8.WORD\[7\].W.BYTE\[0\].B.BIT\[5\].genblk1.STORAGE
+ DIBUF\[5\].X SLICE_16\[1\].RAM16.SLICE\[0\].RAM8.WORD\[7\].W.BYTE\[0\].B.GCLK VGND
+ VGND VPWR VPWR SLICE_16\[1\].RAM16.SLICE\[0\].RAM8.WORD\[7\].W.BYTE\[0\].B.Q_WIRE\[5\]
+ sky130_fd_sc_hd__dlxtp_1
XSLICE_16\[1\].RAM16.SLICE\[0\].RAM8.WORD\[1\].W.BYTE\[1\].B.BIT\[6\].genblk1.STORAGE
+ DIBUF\[14\].X SLICE_16\[1\].RAM16.SLICE\[0\].RAM8.WORD\[1\].W.BYTE\[1\].B.GCLK VGND
+ VGND VPWR VPWR SLICE_16\[1\].RAM16.SLICE\[0\].RAM8.WORD\[1\].W.BYTE\[1\].B.Q_WIRE\[6\]
+ sky130_fd_sc_hd__dlxtp_1
XSLICE_16\[0\].RAM16.SLICE\[1\].RAM8.WORD\[0\].W.SEL0BUF SLICE_16\[0\].RAM16.SLICE\[1\].RAM8.DEC0.SEL\[0\]
+ VGND VGND VPWR VPWR SLICE_16\[0\].RAM16.SLICE\[1\].RAM8.WORD\[0\].W.BYTE\[0\].B.SEL0
+ sky130_fd_sc_hd__clkbuf_2
Xfill_45_7 VGND VGND VPWR VPWR sky130_fd_sc_hd__decap_12
Xfill_38_6 VGND VPWR sky130_fd_sc_hd__tapvpwrvgnd_1
XSLICE_16\[0\].RAM16.SLICE\[1\].RAM8.WORD\[3\].W.BYTE\[1\].B.BIT\[7\].genblk1.STORAGE
+ DIBUF\[15\].X SLICE_16\[0\].RAM16.SLICE\[1\].RAM8.WORD\[3\].W.BYTE\[1\].B.GCLK VGND
+ VGND VPWR VPWR SLICE_16\[0\].RAM16.SLICE\[1\].RAM8.WORD\[3\].W.BYTE\[1\].B.Q_WIRE\[7\]
+ sky130_fd_sc_hd__dlxtp_1
Xfill_0_7 VGND VGND VPWR VPWR sky130_fd_sc_hd__decap_12
XSLICE_16\[0\].RAM16.SLICE\[0\].RAM8.WORD\[2\].W.BYTE\[1\].B.BIT\[2\].genblk1.STORAGE
+ DIBUF\[10\].X SLICE_16\[0\].RAM16.SLICE\[0\].RAM8.WORD\[2\].W.BYTE\[1\].B.GCLK VGND
+ VGND VPWR VPWR SLICE_16\[0\].RAM16.SLICE\[0\].RAM8.WORD\[2\].W.BYTE\[1\].B.Q_WIRE\[2\]
+ sky130_fd_sc_hd__dlxtp_1
Xtap_5_18 VGND VPWR sky130_fd_sc_hd__tapvpwrvgnd_1
XSLICE_16\[0\].RAM16.SLICE\[0\].RAM8.WORD\[4\].W.BYTE\[3\].B.BIT\[3\].genblk1.STORAGE
+ DIBUF\[27\].X SLICE_16\[0\].RAM16.SLICE\[0\].RAM8.WORD\[4\].W.BYTE\[3\].B.GCLK VGND
+ VGND VPWR VPWR SLICE_16\[0\].RAM16.SLICE\[0\].RAM8.WORD\[4\].W.BYTE\[3\].B.Q_WIRE\[3\]
+ sky130_fd_sc_hd__dlxtp_1
XSLICE_16\[1\].RAM16.SLICE\[1\].RAM8.WORD\[2\].W.BYTE\[1\].B.genblk1.CLKINV SLICE_16\[1\].RAM16.SLICE\[1\].RAM8.WORD\[2\].W.BYTE\[0\].B.CLK
+ VGND VGND VPWR VPWR SLICE_16\[1\].RAM16.SLICE\[1\].RAM8.WORD\[2\].W.BYTE\[1\].B.CLK_B
+ sky130_fd_sc_hd__inv_1
XSLICE_16\[1\].RAM16.SLICE\[0\].RAM8.WORD\[1\].W.BYTE\[2\].B.SEL0INV SLICE_16\[1\].RAM16.SLICE\[0\].RAM8.WORD\[1\].W.BYTE\[0\].B.SEL0
+ VGND VGND VPWR VPWR SLICE_16\[1\].RAM16.SLICE\[0\].RAM8.WORD\[1\].W.BYTE\[2\].B.SEL0_B
+ sky130_fd_sc_hd__inv_1
Xtap_5_29 VGND VPWR sky130_fd_sc_hd__tapvpwrvgnd_1
XSLICE_16\[0\].RAM16.SLICE\[0\].RAM8.WORD\[7\].W.BYTE\[0\].B.SEL0INV SLICE_16\[0\].RAM16.SLICE\[0\].RAM8.WORD\[7\].W.BYTE\[0\].B.SEL0
+ VGND VGND VPWR VPWR SLICE_16\[0\].RAM16.SLICE\[0\].RAM8.WORD\[7\].W.BYTE\[0\].B.SEL0_B
+ sky130_fd_sc_hd__inv_1
XSLICE_16\[1\].RAM16.BYTE\[0\].FLOATBUF0\[5\].__cell__ SLICE_16\[1\].RAM16.BYTE\[0\].FLOATBUF0\[0\].A
+ SLICE_16\[1\].RAM16.BYTE\[0\].FLOATBUF0\[0\].TE_B VGND VGND VPWR VPWR SLICE_16\[1\].RAM16.BYTE\[0\].FLOATBUF0\[5\].Z
+ sky130_fd_sc_hd__ebufn_2
Xtap_3_9 VGND VPWR sky130_fd_sc_hd__tapvpwrvgnd_1
Xtap_24_25 VGND VPWR sky130_fd_sc_hd__tapvpwrvgnd_1
Xtap_24_14 VGND VPWR sky130_fd_sc_hd__tapvpwrvgnd_1
Xtap_40_24 VGND VPWR sky130_fd_sc_hd__tapvpwrvgnd_1
Xtap_40_13 VGND VPWR sky130_fd_sc_hd__tapvpwrvgnd_1
XSLICE_16\[1\].RAM16.SLICE\[0\].RAM8.WORD\[6\].W.BYTE\[1\].B.BIT\[5\].OBUF0 SLICE_16\[1\].RAM16.SLICE\[0\].RAM8.WORD\[6\].W.BYTE\[1\].B.Q_WIRE\[5\]
+ SLICE_16\[1\].RAM16.SLICE\[0\].RAM8.WORD\[6\].W.BYTE\[1\].B.SEL0_B VGND VGND VPWR
+ VPWR SLICE_16\[1\].RAM16.BYTE\[1\].FLOATBUF0\[13\].Z sky130_fd_sc_hd__ebufn_2
XSLICE_16\[1\].RAM16.SLICE\[0\].RAM8.WEBUF\[0\].__cell__ SLICE_16\[1\].RAM16.SLICE\[0\].RAM8.WE0\[0\]
+ VGND VGND VPWR VPWR SLICE_16\[1\].RAM16.SLICE\[0\].RAM8.WE0_buf\[0\] sky130_fd_sc_hd__clkbuf_2
XSLICE_16\[0\].RAM16.SLICE\[1\].RAM8.WORD\[3\].W.BYTE\[3\].B.BIT\[4\].OBUF0 SLICE_16\[0\].RAM16.SLICE\[1\].RAM8.WORD\[3\].W.BYTE\[3\].B.Q_WIRE\[4\]
+ SLICE_16\[0\].RAM16.SLICE\[1\].RAM8.WORD\[3\].W.BYTE\[3\].B.SEL0_B VGND VGND VPWR
+ VPWR SLICE_16\[0\].RAM16.BYTE\[3\].FLOATBUF0\[28\].Z sky130_fd_sc_hd__ebufn_2
Xtap_15_0 VGND VPWR sky130_fd_sc_hd__tapvpwrvgnd_1
XSLICE_16\[1\].RAM16.SLICE\[1\].RAM8.WORD\[7\].W.BYTE\[2\].B.BIT\[0\].genblk1.STORAGE
+ DIBUF\[16\].X SLICE_16\[1\].RAM16.SLICE\[1\].RAM8.WORD\[7\].W.BYTE\[2\].B.GCLK VGND
+ VGND VPWR VPWR SLICE_16\[1\].RAM16.SLICE\[1\].RAM8.WORD\[7\].W.BYTE\[2\].B.Q_WIRE\[0\]
+ sky130_fd_sc_hd__dlxtp_1
XSLICE_16\[1\].RAM16.SLICE\[1\].RAM8.WORD\[1\].W.BYTE\[3\].B.BIT\[1\].genblk1.STORAGE
+ DIBUF\[25\].X SLICE_16\[1\].RAM16.SLICE\[1\].RAM8.WORD\[1\].W.BYTE\[3\].B.GCLK VGND
+ VGND VPWR VPWR SLICE_16\[1\].RAM16.SLICE\[1\].RAM8.WORD\[1\].W.BYTE\[3\].B.Q_WIRE\[1\]
+ sky130_fd_sc_hd__dlxtp_1
Xfill_0_15 VGND VPWR sky130_fd_sc_hd__tapvpwrvgnd_1
XSLICE_16\[1\].RAM16.SLICE\[1\].RAM8.WORD\[5\].W.BYTE\[2\].B.genblk1.CLKINV SLICE_16\[1\].RAM16.SLICE\[1\].RAM8.WORD\[5\].W.BYTE\[0\].B.CLK
+ VGND VGND VPWR VPWR SLICE_16\[1\].RAM16.SLICE\[1\].RAM8.WORD\[5\].W.BYTE\[2\].B.CLK_B
+ sky130_fd_sc_hd__inv_1
XSLICE_16\[1\].RAM16.SLICE\[1\].RAM8.WORD\[0\].W.BYTE\[2\].B.BIT\[0\].OBUF0 SLICE_16\[1\].RAM16.SLICE\[1\].RAM8.WORD\[0\].W.BYTE\[2\].B.Q_WIRE\[0\]
+ SLICE_16\[1\].RAM16.SLICE\[1\].RAM8.WORD\[0\].W.BYTE\[2\].B.SEL0_B VGND VGND VPWR
+ VPWR SLICE_16\[1\].RAM16.BYTE\[2\].FLOATBUF0\[16\].Z sky130_fd_sc_hd__ebufn_2
Xfill_43_4 VGND VGND VPWR VPWR sky130_fd_sc_hd__decap_12
XSLICE_16\[1\].RAM16.SLICE\[1\].RAM8.WORD\[6\].W.BYTE\[2\].B.genblk1.CG SLICE_16\[1\].RAM16.SLICE\[1\].RAM8.WORD\[6\].W.BYTE\[2\].B.CLK_B
+ SLICE_16\[1\].RAM16.SLICE\[1\].RAM8.WORD\[6\].W.BYTE\[2\].B.WE0_WIRE VGND VGND VPWR
+ VPWR SLICE_16\[1\].RAM16.SLICE\[1\].RAM8.WORD\[6\].W.BYTE\[2\].B.GCLK sky130_fd_sc_hd__dlclkp_1
XSLICE_16\[0\].RAM16.Do0_REG.OUTREG_BYTE\[1\].Do_FF\[0\] SLICE_16\[0\].RAM16.Do0_REG.CLKBUF\[1\]
+ SLICE_16\[0\].RAM16.BYTE\[1\].FLOATBUF0\[8\].Z VGND VGND VPWR VPWR Do0MUX.A0\[8\]
+ sky130_fd_sc_hd__dfxtp_1
Xfill_46_144 VGND VGND VPWR VPWR sky130_fd_sc_hd__decap_6
Xfill_46_133 VGND VGND VPWR VPWR sky130_fd_sc_hd__decap_12
Xfill_46_122 VGND VGND VPWR VPWR sky130_fd_sc_hd__decap_12
Xfill_46_111 VGND VPWR sky130_fd_sc_hd__tapvpwrvgnd_1
Xfill_46_100 VGND VGND VPWR VPWR sky130_fd_sc_hd__decap_12
XDo0MUX.M\[3\].MUX\[2\] Do0MUX.A0\[26\] Do0MUX.A1\[26\] Do0MUX.SEL\[3\] VGND VGND
+ VPWR VPWR Do0[26] sky130_fd_sc_hd__mux2_1
Xfill_36_3 VGND VPWR sky130_fd_sc_hd__tapvpwrvgnd_1
Xfill_29_2 VGND VPWR sky130_fd_sc_hd__tapvpwrvgnd_1
XSLICE_16\[0\].RAM16.SLICE\[1\].RAM8.WORD\[2\].W.BYTE\[1\].B.BIT\[1\].OBUF0 SLICE_16\[0\].RAM16.SLICE\[1\].RAM8.WORD\[2\].W.BYTE\[1\].B.Q_WIRE\[1\]
+ SLICE_16\[0\].RAM16.SLICE\[1\].RAM8.WORD\[2\].W.BYTE\[1\].B.SEL0_B VGND VGND VPWR
+ VPWR SLICE_16\[0\].RAM16.BYTE\[1\].FLOATBUF0\[9\].Z sky130_fd_sc_hd__ebufn_2
XSLICE_16\[1\].RAM16.SLICE\[0\].RAM8.WORD\[4\].W.BYTE\[2\].B.BIT\[6\].genblk1.STORAGE
+ DIBUF\[22\].X SLICE_16\[1\].RAM16.SLICE\[0\].RAM8.WORD\[4\].W.BYTE\[2\].B.GCLK VGND
+ VGND VPWR VPWR SLICE_16\[1\].RAM16.SLICE\[0\].RAM8.WORD\[4\].W.BYTE\[2\].B.Q_WIRE\[6\]
+ sky130_fd_sc_hd__dlxtp_1
Xtap_10_16 VGND VPWR sky130_fd_sc_hd__tapvpwrvgnd_1
Xtap_10_27 VGND VPWR sky130_fd_sc_hd__tapvpwrvgnd_1
XSLICE_16\[1\].RAM16.BYTE\[3\].FLOATBUF0\[31\].__cell__ SLICE_16\[1\].RAM16.BYTE\[3\].FLOATBUF0\[24\].A
+ SLICE_16\[1\].RAM16.BYTE\[3\].FLOATBUF0\[24\].TE_B VGND VGND VPWR VPWR SLICE_16\[1\].RAM16.BYTE\[3\].FLOATBUF0\[31\].Z
+ sky130_fd_sc_hd__ebufn_2
XSLICE_16\[1\].RAM16.SLICE\[0\].RAM8.WORD\[2\].W.BYTE\[0\].B.BIT\[5\].genblk1.STORAGE
+ DIBUF\[5\].X SLICE_16\[1\].RAM16.SLICE\[0\].RAM8.WORD\[2\].W.BYTE\[0\].B.GCLK VGND
+ VGND VPWR VPWR SLICE_16\[1\].RAM16.SLICE\[0\].RAM8.WORD\[2\].W.BYTE\[0\].B.Q_WIRE\[5\]
+ sky130_fd_sc_hd__dlxtp_1
XSLICE_16\[0\].RAM16.SLICE\[1\].RAM8.WORD\[6\].W.BYTE\[2\].B.BIT\[7\].genblk1.STORAGE
+ DIBUF\[23\].X SLICE_16\[0\].RAM16.SLICE\[1\].RAM8.WORD\[6\].W.BYTE\[2\].B.GCLK VGND
+ VGND VPWR VPWR SLICE_16\[0\].RAM16.SLICE\[1\].RAM8.WORD\[6\].W.BYTE\[2\].B.Q_WIRE\[7\]
+ sky130_fd_sc_hd__dlxtp_1
Xtap_35_35 VGND VPWR sky130_fd_sc_hd__tapvpwrvgnd_1
Xtap_35_24 VGND VPWR sky130_fd_sc_hd__tapvpwrvgnd_1
Xtap_35_13 VGND VPWR sky130_fd_sc_hd__tapvpwrvgnd_1
XSLICE_16\[0\].RAM16.SLICE\[1\].RAM8.WORD\[4\].W.BYTE\[0\].B.BIT\[6\].genblk1.STORAGE
+ DIBUF\[6\].X SLICE_16\[0\].RAM16.SLICE\[1\].RAM8.WORD\[4\].W.BYTE\[0\].B.GCLK VGND
+ VGND VPWR VPWR SLICE_16\[0\].RAM16.SLICE\[1\].RAM8.WORD\[4\].W.BYTE\[0\].B.Q_WIRE\[6\]
+ sky130_fd_sc_hd__dlxtp_1
XSLICE_16\[0\].RAM16.SLICE\[0\].RAM8.WORD\[2\].W.BYTE\[0\].B.genblk1.CLKINV SLICE_16\[0\].RAM16.SLICE\[0\].RAM8.WORD\[2\].W.BYTE\[0\].B.CLK
+ VGND VGND VPWR VPWR SLICE_16\[0\].RAM16.SLICE\[0\].RAM8.WORD\[2\].W.BYTE\[0\].B.CLK_B
+ sky130_fd_sc_hd__inv_1
XSLICE_16\[0\].RAM16.SLICE\[0\].RAM8.WORD\[1\].W.BYTE\[3\].B.BIT\[3\].OBUF0 SLICE_16\[0\].RAM16.SLICE\[0\].RAM8.WORD\[1\].W.BYTE\[3\].B.Q_WIRE\[3\]
+ SLICE_16\[0\].RAM16.SLICE\[0\].RAM8.WORD\[1\].W.BYTE\[3\].B.SEL0_B VGND VGND VPWR
+ VPWR SLICE_16\[0\].RAM16.BYTE\[3\].FLOATBUF0\[27\].Z sky130_fd_sc_hd__ebufn_2
Xtap_1_6 VGND VPWR sky130_fd_sc_hd__tapvpwrvgnd_1
XSLICE_16\[0\].RAM16.SLICE\[0\].RAM8.WORD\[5\].W.BYTE\[2\].B.BIT\[2\].genblk1.STORAGE
+ DIBUF\[18\].X SLICE_16\[0\].RAM16.SLICE\[0\].RAM8.WORD\[5\].W.BYTE\[2\].B.GCLK VGND
+ VGND VPWR VPWR SLICE_16\[0\].RAM16.SLICE\[0\].RAM8.WORD\[5\].W.BYTE\[2\].B.Q_WIRE\[2\]
+ sky130_fd_sc_hd__dlxtp_1
XSLICE_16\[1\].RAM16.SLICE\[1\].RAM8.WORD\[2\].W.BYTE\[3\].B.CGAND SLICE_16\[1\].RAM16.SLICE\[1\].RAM8.WORD\[2\].W.BYTE\[0\].B.SEL0
+ SLICE_16\[1\].RAM16.SLICE\[1\].RAM8.WE0_buf\[3\] VGND VGND VPWR VPWR SLICE_16\[1\].RAM16.SLICE\[1\].RAM8.WORD\[2\].W.BYTE\[3\].B.WE0_WIRE
+ sky130_fd_sc_hd__and2_1
XSLICE_16\[1\].RAM16.SLICE\[1\].RAM8.WORD\[3\].W.BYTE\[3\].B.BIT\[0\].OBUF0 SLICE_16\[1\].RAM16.SLICE\[1\].RAM8.WORD\[3\].W.BYTE\[3\].B.Q_WIRE\[0\]
+ SLICE_16\[1\].RAM16.SLICE\[1\].RAM8.WORD\[3\].W.BYTE\[3\].B.SEL0_B VGND VGND VPWR
+ VPWR SLICE_16\[1\].RAM16.BYTE\[3\].FLOATBUF0\[24\].Z sky130_fd_sc_hd__ebufn_2
XSLICE_16\[0\].RAM16.SLICE\[0\].RAM8.WORD\[3\].W.BYTE\[0\].B.BIT\[1\].genblk1.STORAGE
+ DIBUF\[1\].X SLICE_16\[0\].RAM16.SLICE\[0\].RAM8.WORD\[3\].W.BYTE\[0\].B.GCLK VGND
+ VGND VPWR VPWR SLICE_16\[0\].RAM16.SLICE\[0\].RAM8.WORD\[3\].W.BYTE\[0\].B.Q_WIRE\[1\]
+ sky130_fd_sc_hd__dlxtp_1
XDo0MUX.M\[2\].MUX\[4\] Do0MUX.A0\[20\] Do0MUX.A1\[20\] Do0MUX.SEL\[2\] VGND VGND
+ VPWR VPWR Do0[20] sky130_fd_sc_hd__mux2_1
XSLICE_16\[1\].RAM16.SLICE\[1\].RAM8.WORD\[0\].W.BYTE\[0\].B.BIT\[5\].OBUF0 SLICE_16\[1\].RAM16.SLICE\[1\].RAM8.WORD\[0\].W.BYTE\[0\].B.Q_WIRE\[5\]
+ SLICE_16\[1\].RAM16.SLICE\[1\].RAM8.WORD\[0\].W.BYTE\[0\].B.SEL0_B VGND VGND VPWR
+ VPWR SLICE_16\[1\].RAM16.BYTE\[0\].FLOATBUF0\[5\].Z sky130_fd_sc_hd__ebufn_2
Xfill_22_9 VGND VPWR sky130_fd_sc_hd__tapvpwrvgnd_1
XSLICE_16\[0\].RAM16.SLICE\[1\].RAM8.WORD\[5\].W.BYTE\[2\].B.BIT\[1\].OBUF0 SLICE_16\[0\].RAM16.SLICE\[1\].RAM8.WORD\[5\].W.BYTE\[2\].B.Q_WIRE\[1\]
+ SLICE_16\[0\].RAM16.SLICE\[1\].RAM8.WORD\[5\].W.BYTE\[2\].B.SEL0_B VGND VGND VPWR
+ VPWR SLICE_16\[0\].RAM16.BYTE\[2\].FLOATBUF0\[17\].Z sky130_fd_sc_hd__ebufn_2
Xfill_43_103 VGND VPWR sky130_fd_sc_hd__tapvpwrvgnd_1
XDo0MUX.M\[3\].DIODE_A0MUX\[31\] Do0MUX.A0\[31\] VGND VGND VPWR VPWR sky130_fd_sc_hd__diode_2
Xtap_2_19 VGND VPWR sky130_fd_sc_hd__tapvpwrvgnd_1
XSLICE_16\[0\].RAM16.SLICE\[0\].RAM8.WORD\[0\].W.BYTE\[1\].B.BIT\[0\].OBUF0 SLICE_16\[0\].RAM16.SLICE\[0\].RAM8.WORD\[0\].W.BYTE\[1\].B.Q_WIRE\[0\]
+ SLICE_16\[0\].RAM16.SLICE\[0\].RAM8.WORD\[0\].W.BYTE\[1\].B.SEL0_B VGND VGND VPWR
+ VPWR SLICE_16\[0\].RAM16.BYTE\[1\].FLOATBUF0\[8\].Z sky130_fd_sc_hd__ebufn_2
XSLICE_16\[0\].RAM16.SLICE\[0\].RAM8.WORD\[2\].W.BYTE\[3\].B.DIODE_CLK SLICE_16\[0\].RAM16.SLICE\[0\].RAM8.WORD\[2\].W.BYTE\[0\].B.CLK
+ VGND VGND VPWR VPWR sky130_fd_sc_hd__diode_2
Xfill_41_1 VGND VGND VPWR VPWR sky130_fd_sc_hd__decap_12
Xfill_34_0 VGND VPWR sky130_fd_sc_hd__tapvpwrvgnd_1
XSLICE_16\[1\].RAM16.SLICE\[1\].RAM8.WORD\[2\].W.BYTE\[2\].B.BIT\[0\].genblk1.STORAGE
+ DIBUF\[16\].X SLICE_16\[1\].RAM16.SLICE\[1\].RAM8.WORD\[2\].W.BYTE\[2\].B.GCLK VGND
+ VGND VPWR VPWR SLICE_16\[1\].RAM16.SLICE\[1\].RAM8.WORD\[2\].W.BYTE\[2\].B.Q_WIRE\[0\]
+ sky130_fd_sc_hd__dlxtp_1
XSLICE_16\[0\].RAM16.SLICE\[0\].RAM8.WORD\[5\].W.BYTE\[1\].B.genblk1.CLKINV SLICE_16\[0\].RAM16.SLICE\[0\].RAM8.WORD\[5\].W.BYTE\[0\].B.CLK
+ VGND VGND VPWR VPWR SLICE_16\[0\].RAM16.SLICE\[0\].RAM8.WORD\[5\].W.BYTE\[1\].B.CLK_B
+ sky130_fd_sc_hd__inv_1
XDo0MUX.M\[1\].MUX\[6\] Do0MUX.A0\[14\] Do0MUX.A1\[14\] Do0MUX.SEL\[1\] VGND VGND
+ VPWR VPWR Do0[14] sky130_fd_sc_hd__mux2_1
XSLICE_16\[1\].RAM16.SLICE\[0\].RAM8.WORD\[5\].W.BYTE\[0\].B.SEL0INV SLICE_16\[1\].RAM16.SLICE\[0\].RAM8.WORD\[5\].W.BYTE\[0\].B.SEL0
+ VGND VGND VPWR VPWR SLICE_16\[1\].RAM16.SLICE\[0\].RAM8.WORD\[5\].W.BYTE\[0\].B.SEL0_B
+ sky130_fd_sc_hd__inv_1
XSLICE_16\[1\].RAM16.SLICE\[0\].RAM8.WORD\[4\].W.BYTE\[0\].B.DIODE_CLK SLICE_16\[1\].RAM16.SLICE\[0\].RAM8.WORD\[4\].W.BYTE\[0\].B.CLK
+ VGND VGND VPWR VPWR sky130_fd_sc_hd__diode_2
Xfill_19_100 VGND VGND VPWR VPWR sky130_fd_sc_hd__decap_12
XSLICE_16\[1\].RAM16.SLICE\[1\].RAM8.WORD\[3\].W.BYTE\[1\].B.BIT\[5\].OBUF0 SLICE_16\[1\].RAM16.SLICE\[1\].RAM8.WORD\[3\].W.BYTE\[1\].B.Q_WIRE\[5\]
+ SLICE_16\[1\].RAM16.SLICE\[1\].RAM8.WORD\[3\].W.BYTE\[1\].B.SEL0_B VGND VGND VPWR
+ VPWR SLICE_16\[1\].RAM16.BYTE\[1\].FLOATBUF0\[13\].Z sky130_fd_sc_hd__ebufn_2
XSLICE_16\[1\].RAM16.SLICE\[0\].RAM8.WORD\[6\].W.BYTE\[0\].B.CGAND SLICE_16\[1\].RAM16.SLICE\[0\].RAM8.WORD\[6\].W.BYTE\[0\].B.SEL0
+ SLICE_16\[1\].RAM16.SLICE\[0\].RAM8.WE0_buf\[0\] VGND VGND VPWR VPWR SLICE_16\[1\].RAM16.SLICE\[0\].RAM8.WORD\[6\].W.BYTE\[0\].B.WE0_WIRE
+ sky130_fd_sc_hd__and2_1
XSLICE_16\[0\].RAM16.BYTE\[1\].FLOATBUF0\[13\].__cell__ SLICE_16\[0\].RAM16.BYTE\[1\].FLOATBUF0\[10\].A
+ SLICE_16\[0\].RAM16.BYTE\[1\].FLOATBUF0\[10\].TE_B VGND VGND VPWR VPWR SLICE_16\[0\].RAM16.BYTE\[1\].FLOATBUF0\[13\].Z
+ sky130_fd_sc_hd__ebufn_2
XSLICE_16\[1\].RAM16.SLICE\[0\].RAM8.WORD\[7\].W.BYTE\[3\].B.BIT\[6\].genblk1.STORAGE
+ DIBUF\[30\].X SLICE_16\[1\].RAM16.SLICE\[0\].RAM8.WORD\[7\].W.BYTE\[3\].B.GCLK VGND
+ VGND VPWR VPWR SLICE_16\[1\].RAM16.SLICE\[0\].RAM8.WORD\[7\].W.BYTE\[3\].B.Q_WIRE\[6\]
+ sky130_fd_sc_hd__dlxtp_1
XSLICE_16\[1\].RAM16.SLICE\[0\].RAM8.WORD\[5\].W.BYTE\[1\].B.BIT\[5\].genblk1.STORAGE
+ DIBUF\[13\].X SLICE_16\[1\].RAM16.SLICE\[0\].RAM8.WORD\[5\].W.BYTE\[1\].B.GCLK VGND
+ VGND VPWR VPWR SLICE_16\[1\].RAM16.SLICE\[0\].RAM8.WORD\[5\].W.BYTE\[1\].B.Q_WIRE\[5\]
+ sky130_fd_sc_hd__dlxtp_1
Xfill_18_23 VGND VGND VPWR VPWR sky130_fd_sc_hd__decap_12
Xfill_18_12 VGND VPWR sky130_fd_sc_hd__tapvpwrvgnd_1
XSLICE_16\[0\].RAM16.SLICE\[1\].RAM8.WORD\[7\].W.BYTE\[2\].B.SEL0INV SLICE_16\[0\].RAM16.SLICE\[1\].RAM8.WORD\[7\].W.BYTE\[0\].B.SEL0
+ VGND VGND VPWR VPWR SLICE_16\[0\].RAM16.SLICE\[1\].RAM8.WORD\[7\].W.BYTE\[2\].B.SEL0_B
+ sky130_fd_sc_hd__inv_1
XSLICE_16\[0\].RAM16.SLICE\[1\].RAM8.WORD\[1\].W.BYTE\[0\].B.DIODE_CLK SLICE_16\[0\].RAM16.SLICE\[1\].RAM8.WORD\[1\].W.BYTE\[0\].B.CLK
+ VGND VGND VPWR VPWR sky130_fd_sc_hd__diode_2
XSLICE_16\[0\].RAM16.SLICE\[1\].RAM8.WORD\[7\].W.BYTE\[1\].B.BIT\[6\].genblk1.STORAGE
+ DIBUF\[14\].X SLICE_16\[0\].RAM16.SLICE\[1\].RAM8.WORD\[7\].W.BYTE\[1\].B.GCLK VGND
+ VGND VPWR VPWR SLICE_16\[0\].RAM16.SLICE\[1\].RAM8.WORD\[7\].W.BYTE\[1\].B.Q_WIRE\[6\]
+ sky130_fd_sc_hd__dlxtp_1
XSLICE_16\[0\].RAM16.SLICE\[1\].RAM8.WORD\[5\].W.BYTE\[0\].B.BIT\[6\].OBUF0 SLICE_16\[0\].RAM16.SLICE\[1\].RAM8.WORD\[5\].W.BYTE\[0\].B.Q_WIRE\[6\]
+ SLICE_16\[0\].RAM16.SLICE\[1\].RAM8.WORD\[5\].W.BYTE\[0\].B.SEL0_B VGND VGND VPWR
+ VPWR SLICE_16\[0\].RAM16.BYTE\[0\].FLOATBUF0\[6\].Z sky130_fd_sc_hd__ebufn_2
XSLICE_16\[0\].RAM16.SLICE\[0\].RAM8.WORD\[0\].W.BYTE\[2\].B.genblk1.CG SLICE_16\[0\].RAM16.SLICE\[0\].RAM8.WORD\[0\].W.BYTE\[2\].B.CLK_B
+ SLICE_16\[0\].RAM16.SLICE\[0\].RAM8.WORD\[0\].W.BYTE\[2\].B.WE0_WIRE VGND VGND VPWR
+ VPWR SLICE_16\[0\].RAM16.SLICE\[0\].RAM8.WORD\[0\].W.BYTE\[2\].B.GCLK sky130_fd_sc_hd__dlclkp_1
XSLICE_16\[0\].RAM16.SLICE\[0\].RAM8.WORD\[3\].W.BYTE\[2\].B.BIT\[0\].OBUF0 SLICE_16\[0\].RAM16.SLICE\[0\].RAM8.WORD\[3\].W.BYTE\[2\].B.Q_WIRE\[0\]
+ SLICE_16\[0\].RAM16.SLICE\[0\].RAM8.WORD\[3\].W.BYTE\[2\].B.SEL0_B VGND VGND VPWR
+ VPWR SLICE_16\[0\].RAM16.BYTE\[2\].FLOATBUF0\[16\].Z sky130_fd_sc_hd__ebufn_2
XSLICE_16\[0\].RAM16.SLICE\[1\].RAM8.WORD\[1\].W.BYTE\[2\].B.BIT\[7\].genblk1.STORAGE
+ DIBUF\[23\].X SLICE_16\[0\].RAM16.SLICE\[1\].RAM8.WORD\[1\].W.BYTE\[2\].B.GCLK VGND
+ VGND VPWR VPWR SLICE_16\[0\].RAM16.SLICE\[1\].RAM8.WORD\[1\].W.BYTE\[2\].B.Q_WIRE\[7\]
+ sky130_fd_sc_hd__dlxtp_1
XSLICE_16\[1\].RAM16.SLICE\[0\].RAM8.WORD\[2\].W.BYTE\[3\].B.BIT\[7\].OBUF0 SLICE_16\[1\].RAM16.SLICE\[0\].RAM8.WORD\[2\].W.BYTE\[3\].B.Q_WIRE\[7\]
+ SLICE_16\[1\].RAM16.SLICE\[0\].RAM8.WORD\[2\].W.BYTE\[3\].B.SEL0_B VGND VGND VPWR
+ VPWR SLICE_16\[1\].RAM16.BYTE\[3\].FLOATBUF0\[31\].Z sky130_fd_sc_hd__ebufn_2
XSLICE_16\[0\].RAM16.SLICE\[0\].RAM8.WORD\[0\].W.BYTE\[2\].B.BIT\[2\].genblk1.STORAGE
+ DIBUF\[18\].X SLICE_16\[0\].RAM16.SLICE\[0\].RAM8.WORD\[0\].W.BYTE\[2\].B.GCLK VGND
+ VGND VPWR VPWR SLICE_16\[0\].RAM16.SLICE\[0\].RAM8.WORD\[0\].W.BYTE\[2\].B.Q_WIRE\[2\]
+ sky130_fd_sc_hd__dlxtp_1
XSLICE_16\[0\].RAM16.SLICE\[0\].RAM8.WORD\[3\].W.BYTE\[1\].B.SEL0INV SLICE_16\[0\].RAM16.SLICE\[0\].RAM8.WORD\[3\].W.BYTE\[0\].B.SEL0
+ VGND VGND VPWR VPWR SLICE_16\[0\].RAM16.SLICE\[0\].RAM8.WORD\[3\].W.BYTE\[1\].B.SEL0_B
+ sky130_fd_sc_hd__inv_1
XSLICE_16\[0\].RAM16.SLICE\[0\].RAM8.WORD\[6\].W.BYTE\[1\].B.BIT\[1\].genblk1.STORAGE
+ DIBUF\[9\].X SLICE_16\[0\].RAM16.SLICE\[0\].RAM8.WORD\[6\].W.BYTE\[1\].B.GCLK VGND
+ VGND VPWR VPWR SLICE_16\[0\].RAM16.SLICE\[0\].RAM8.WORD\[6\].W.BYTE\[1\].B.Q_WIRE\[1\]
+ sky130_fd_sc_hd__dlxtp_1
Xfill_20_6 VGND VPWR sky130_fd_sc_hd__tapvpwrvgnd_1
Xfill_13_5 VGND VPWR sky130_fd_sc_hd__tapvpwrvgnd_1
XSLICE_16\[1\].RAM16.SLICE\[1\].RAM8.WORD\[6\].W.BYTE\[2\].B.BIT\[5\].OBUF0 SLICE_16\[1\].RAM16.SLICE\[1\].RAM8.WORD\[6\].W.BYTE\[2\].B.Q_WIRE\[5\]
+ SLICE_16\[1\].RAM16.SLICE\[1\].RAM8.WORD\[6\].W.BYTE\[2\].B.SEL0_B VGND VGND VPWR
+ VPWR SLICE_16\[1\].RAM16.BYTE\[2\].FLOATBUF0\[21\].Z sky130_fd_sc_hd__ebufn_2
XSLICE_16\[1\].RAM16.SLICE\[1\].RAM8.WORD\[1\].W.SEL0BUF SLICE_16\[1\].RAM16.SLICE\[1\].RAM8.DEC0.SEL\[1\]
+ VGND VGND VPWR VPWR SLICE_16\[1\].RAM16.SLICE\[1\].RAM8.WORD\[1\].W.BYTE\[0\].B.SEL0
+ sky130_fd_sc_hd__clkbuf_2
Xtap_32_14 VGND VPWR sky130_fd_sc_hd__tapvpwrvgnd_1
XSLICE_16\[1\].RAM16.SLICE\[0\].RAM8.DEC0.AND2 SLICE_16\[1\].RAM16.SLICE\[0\].RAM8.DEC0.A_buf\[2\]
+ SLICE_16\[1\].RAM16.SLICE\[0\].RAM8.DEC0.A_buf\[0\] SLICE_16\[1\].RAM16.SLICE\[0\].RAM8.DEC0.A_buf\[1\]
+ SLICE_16\[1\].RAM16.SLICE\[0\].RAM8.DEC0.EN_buf VGND VGND VPWR VPWR SLICE_16\[1\].RAM16.SLICE\[0\].RAM8.DEC0.SEL\[2\]
+ sky130_fd_sc_hd__and4bb_2
Xtap_16_26 VGND VPWR sky130_fd_sc_hd__tapvpwrvgnd_1
Xtap_16_15 VGND VPWR sky130_fd_sc_hd__tapvpwrvgnd_1
Xtap_32_25 VGND VPWR sky130_fd_sc_hd__tapvpwrvgnd_1
Xtap_47_3 VGND VPWR sky130_fd_sc_hd__tapvpwrvgnd_1
XSLICE_16\[1\].RAM16.SLICE\[1\].RAM8.WORD\[5\].W.BYTE\[3\].B.BIT\[0\].genblk1.STORAGE
+ DIBUF\[24\].X SLICE_16\[1\].RAM16.SLICE\[1\].RAM8.WORD\[5\].W.BYTE\[3\].B.GCLK VGND
+ VGND VPWR VPWR SLICE_16\[1\].RAM16.SLICE\[1\].RAM8.WORD\[5\].W.BYTE\[3\].B.Q_WIRE\[0\]
+ sky130_fd_sc_hd__dlxtp_1
XSLICE_16\[1\].RAM16.SLICE\[0\].RAM8.WORD\[7\].W.BYTE\[3\].B.DIODE_CLK SLICE_16\[1\].RAM16.SLICE\[0\].RAM8.WORD\[7\].W.BYTE\[0\].B.CLK
+ VGND VGND VPWR VPWR sky130_fd_sc_hd__diode_2
XSLICE_16\[1\].RAM16.SLICE\[0\].RAM8.WORD\[1\].W.BYTE\[1\].B.BIT\[4\].OBUF0 SLICE_16\[1\].RAM16.SLICE\[0\].RAM8.WORD\[1\].W.BYTE\[1\].B.Q_WIRE\[4\]
+ SLICE_16\[1\].RAM16.SLICE\[0\].RAM8.WORD\[1\].W.BYTE\[1\].B.SEL0_B VGND VGND VPWR
+ VPWR SLICE_16\[1\].RAM16.BYTE\[1\].FLOATBUF0\[12\].Z sky130_fd_sc_hd__ebufn_2
Xfill_20_79 VGND VGND VPWR VPWR sky130_fd_sc_hd__decap_12
Xfill_20_68 VGND VGND VPWR VPWR sky130_fd_sc_hd__decap_12
Xfill_20_57 VGND VPWR sky130_fd_sc_hd__tapvpwrvgnd_1
Xfill_20_46 VGND VGND VPWR VPWR sky130_fd_sc_hd__decap_12
Xfill_20_35 VGND VGND VPWR VPWR sky130_fd_sc_hd__decap_12
Xfill_20_24 VGND VPWR sky130_fd_sc_hd__tapvpwrvgnd_1
Xfill_20_13 VGND VGND VPWR VPWR sky130_fd_sc_hd__decap_12
XSLICE_16\[0\].RAM16.SLICE\[0\].RAM8.WORD\[6\].W.BYTE\[3\].B.BIT\[0\].OBUF0 SLICE_16\[0\].RAM16.SLICE\[0\].RAM8.WORD\[6\].W.BYTE\[3\].B.Q_WIRE\[0\]
+ SLICE_16\[0\].RAM16.SLICE\[0\].RAM8.WORD\[6\].W.BYTE\[3\].B.SEL0_B VGND VGND VPWR
+ VPWR SLICE_16\[0\].RAM16.BYTE\[3\].FLOATBUF0\[24\].Z sky130_fd_sc_hd__ebufn_2
XDo0MUX.M\[3\].DIODE_A1MUX\[29\] Do0MUX.A1\[29\] VGND VGND VPWR VPWR sky130_fd_sc_hd__diode_2
Xfill_45_98 VGND VGND VPWR VPWR sky130_fd_sc_hd__decap_12
Xfill_45_87 VGND VPWR sky130_fd_sc_hd__tapvpwrvgnd_1
Xfill_45_76 VGND VGND VPWR VPWR sky130_fd_sc_hd__decap_12
Xfill_45_65 VGND VGND VPWR VPWR sky130_fd_sc_hd__decap_12
Xfill_45_54 VGND VPWR sky130_fd_sc_hd__tapvpwrvgnd_1
Xfill_45_43 VGND VGND VPWR VPWR sky130_fd_sc_hd__decap_12
Xfill_45_32 VGND VGND VPWR VPWR sky130_fd_sc_hd__decap_12
Xfill_45_21 VGND VPWR sky130_fd_sc_hd__tapvpwrvgnd_1
Xfill_45_10 VGND VGND VPWR VPWR sky130_fd_sc_hd__decap_12
XSLICE_16\[0\].RAM16.SLICE\[0\].RAM8.WORD\[3\].W.BYTE\[0\].B.BIT\[5\].OBUF0 SLICE_16\[0\].RAM16.SLICE\[0\].RAM8.WORD\[3\].W.BYTE\[0\].B.Q_WIRE\[5\]
+ SLICE_16\[0\].RAM16.SLICE\[0\].RAM8.WORD\[3\].W.BYTE\[0\].B.SEL0_B VGND VGND VPWR
+ VPWR SLICE_16\[0\].RAM16.BYTE\[0\].FLOATBUF0\[5\].Z sky130_fd_sc_hd__ebufn_2
XSLICE_16\[1\].RAM16.SLICE\[1\].RAM8.WORD\[5\].W.BYTE\[0\].B.BIT\[2\].OBUF0 SLICE_16\[1\].RAM16.SLICE\[1\].RAM8.WORD\[5\].W.BYTE\[0\].B.Q_WIRE\[2\]
+ SLICE_16\[1\].RAM16.SLICE\[1\].RAM8.WORD\[5\].W.BYTE\[0\].B.SEL0_B VGND VGND VPWR
+ VPWR SLICE_16\[1\].RAM16.BYTE\[0\].FLOATBUF0\[2\].Z sky130_fd_sc_hd__ebufn_2
XSLICE_16\[1\].RAM16.SLICE\[0\].RAM8.WORD\[2\].W.BYTE\[3\].B.BIT\[6\].genblk1.STORAGE
+ DIBUF\[30\].X SLICE_16\[1\].RAM16.SLICE\[0\].RAM8.WORD\[2\].W.BYTE\[3\].B.GCLK VGND
+ VGND VPWR VPWR SLICE_16\[1\].RAM16.SLICE\[0\].RAM8.WORD\[2\].W.BYTE\[3\].B.Q_WIRE\[6\]
+ sky130_fd_sc_hd__dlxtp_1
XSLICE_16\[0\].RAM16.SLICE\[1\].RAM8.WORD\[4\].W.BYTE\[3\].B.DIODE_CLK SLICE_16\[0\].RAM16.SLICE\[1\].RAM8.WORD\[4\].W.BYTE\[0\].B.CLK
+ VGND VGND VPWR VPWR sky130_fd_sc_hd__diode_2
XSLICE_16\[1\].RAM16.SLICE\[1\].RAM8.WORD\[6\].W.BYTE\[0\].B.DIODE_CLK SLICE_16\[1\].RAM16.SLICE\[1\].RAM8.WORD\[6\].W.BYTE\[0\].B.CLK
+ VGND VGND VPWR VPWR sky130_fd_sc_hd__diode_2
XSLICE_16\[1\].RAM16.SLICE\[0\].RAM8.WORD\[6\].W.CLKBUF SLICE_16\[1\].RAM16.SLICE\[0\].RAM8.CLKBUF.X
+ VGND VGND VPWR VPWR SLICE_16\[1\].RAM16.SLICE\[0\].RAM8.WORD\[6\].W.BYTE\[0\].B.CLK
+ sky130_fd_sc_hd__clkbuf_4
XSLICE_16\[1\].RAM16.SLICE\[0\].RAM8.WORD\[6\].W.BYTE\[0\].B.BIT\[4\].genblk1.STORAGE
+ DIBUF\[4\].X SLICE_16\[1\].RAM16.SLICE\[0\].RAM8.WORD\[6\].W.BYTE\[0\].B.GCLK VGND
+ VGND VPWR VPWR SLICE_16\[1\].RAM16.SLICE\[0\].RAM8.WORD\[6\].W.BYTE\[0\].B.Q_WIRE\[4\]
+ sky130_fd_sc_hd__dlxtp_1
XSLICE_16\[1\].RAM16.SLICE\[0\].RAM8.WORD\[0\].W.BYTE\[1\].B.BIT\[5\].genblk1.STORAGE
+ DIBUF\[13\].X SLICE_16\[1\].RAM16.SLICE\[0\].RAM8.WORD\[0\].W.BYTE\[1\].B.GCLK VGND
+ VGND VPWR VPWR SLICE_16\[1\].RAM16.SLICE\[0\].RAM8.WORD\[0\].W.BYTE\[1\].B.Q_WIRE\[5\]
+ sky130_fd_sc_hd__dlxtp_1
XSLICE_16\[0\].RAM16.SLICE\[1\].RAM8.WORD\[4\].W.BYTE\[3\].B.BIT\[7\].genblk1.STORAGE
+ DIBUF\[31\].X SLICE_16\[0\].RAM16.SLICE\[1\].RAM8.WORD\[4\].W.BYTE\[3\].B.GCLK VGND
+ VGND VPWR VPWR SLICE_16\[0\].RAM16.SLICE\[1\].RAM8.WORD\[4\].W.BYTE\[3\].B.Q_WIRE\[7\]
+ sky130_fd_sc_hd__dlxtp_1
XSLICE_16\[1\].RAM16.SLICE\[0\].RAM8.WORD\[4\].W.BYTE\[2\].B.BIT\[4\].OBUF0 SLICE_16\[1\].RAM16.SLICE\[0\].RAM8.WORD\[4\].W.BYTE\[2\].B.Q_WIRE\[4\]
+ SLICE_16\[1\].RAM16.SLICE\[0\].RAM8.WORD\[4\].W.BYTE\[2\].B.SEL0_B VGND VGND VPWR
+ VPWR SLICE_16\[1\].RAM16.BYTE\[2\].FLOATBUF0\[20\].Z sky130_fd_sc_hd__ebufn_2
XSLICE_16\[0\].RAM16.SLICE\[1\].RAM8.WORD\[5\].W.BYTE\[2\].B.genblk1.CG SLICE_16\[0\].RAM16.SLICE\[1\].RAM8.WORD\[5\].W.BYTE\[2\].B.CLK_B
+ SLICE_16\[0\].RAM16.SLICE\[1\].RAM8.WORD\[5\].W.BYTE\[2\].B.WE0_WIRE VGND VGND VPWR
+ VPWR SLICE_16\[0\].RAM16.SLICE\[1\].RAM8.WORD\[5\].W.BYTE\[2\].B.GCLK sky130_fd_sc_hd__dlclkp_1
Xfill_11_2 VGND VPWR sky130_fd_sc_hd__tapvpwrvgnd_1
XDIBUF\[24\].__cell__ Di0[24] VGND VGND VPWR VPWR DIBUF\[24\].X sky130_fd_sc_hd__clkbuf_16
Xtap_8_18 VGND VPWR sky130_fd_sc_hd__tapvpwrvgnd_1
Xtap_8_29 VGND VPWR sky130_fd_sc_hd__tapvpwrvgnd_1
XSLICE_16\[0\].RAM16.SLICE\[1\].RAM8.WORD\[2\].W.BYTE\[1\].B.BIT\[6\].genblk1.STORAGE
+ DIBUF\[14\].X SLICE_16\[0\].RAM16.SLICE\[1\].RAM8.WORD\[2\].W.BYTE\[1\].B.GCLK VGND
+ VGND VPWR VPWR SLICE_16\[0\].RAM16.SLICE\[1\].RAM8.WORD\[2\].W.BYTE\[1\].B.Q_WIRE\[6\]
+ sky130_fd_sc_hd__dlxtp_1
XSLICE_16\[0\].RAM16.SLICE\[1\].RAM8.WORD\[2\].W.BYTE\[1\].B.genblk1.CLKINV SLICE_16\[0\].RAM16.SLICE\[1\].RAM8.WORD\[2\].W.BYTE\[0\].B.CLK
+ VGND VGND VPWR VPWR SLICE_16\[0\].RAM16.SLICE\[1\].RAM8.WORD\[2\].W.BYTE\[1\].B.CLK_B
+ sky130_fd_sc_hd__inv_1
Xtap_33_9 VGND VPWR sky130_fd_sc_hd__tapvpwrvgnd_1
XSLICE_16\[0\].RAM16.SLICE\[0\].RAM8.WORD\[3\].W.BYTE\[3\].B.BIT\[2\].genblk1.STORAGE
+ DIBUF\[26\].X SLICE_16\[0\].RAM16.SLICE\[0\].RAM8.WORD\[3\].W.BYTE\[3\].B.GCLK VGND
+ VGND VPWR VPWR SLICE_16\[0\].RAM16.SLICE\[0\].RAM8.WORD\[3\].W.BYTE\[3\].B.Q_WIRE\[2\]
+ sky130_fd_sc_hd__dlxtp_1
XSLICE_16\[0\].RAM16.SLICE\[0\].RAM8.WORD\[7\].W.BYTE\[0\].B.BIT\[0\].genblk1.STORAGE
+ DIBUF\[0\].X SLICE_16\[0\].RAM16.SLICE\[0\].RAM8.WORD\[7\].W.BYTE\[0\].B.GCLK VGND
+ VGND VPWR VPWR SLICE_16\[0\].RAM16.SLICE\[0\].RAM8.WORD\[7\].W.BYTE\[0\].B.Q_WIRE\[0\]
+ sky130_fd_sc_hd__dlxtp_1
Xtap_27_36 VGND VPWR sky130_fd_sc_hd__tapvpwrvgnd_1
Xtap_27_25 VGND VPWR sky130_fd_sc_hd__tapvpwrvgnd_1
Xtap_27_14 VGND VPWR sky130_fd_sc_hd__tapvpwrvgnd_1
Xtap_26_8 VGND VPWR sky130_fd_sc_hd__tapvpwrvgnd_1
XSLICE_16\[0\].RAM16.SLICE\[0\].RAM8.WORD\[1\].W.BYTE\[1\].B.BIT\[1\].genblk1.STORAGE
+ DIBUF\[9\].X SLICE_16\[0\].RAM16.SLICE\[0\].RAM8.WORD\[1\].W.BYTE\[1\].B.GCLK VGND
+ VGND VPWR VPWR SLICE_16\[0\].RAM16.SLICE\[0\].RAM8.WORD\[1\].W.BYTE\[1\].B.Q_WIRE\[1\]
+ sky130_fd_sc_hd__dlxtp_1
XSLICE_16\[0\].RAM16.SLICE\[0\].RAM8.WORD\[6\].W.BYTE\[1\].B.BIT\[5\].OBUF0 SLICE_16\[0\].RAM16.SLICE\[0\].RAM8.WORD\[6\].W.BYTE\[1\].B.Q_WIRE\[5\]
+ SLICE_16\[0\].RAM16.SLICE\[0\].RAM8.WORD\[6\].W.BYTE\[1\].B.SEL0_B VGND VGND VPWR
+ VPWR SLICE_16\[0\].RAM16.BYTE\[1\].FLOATBUF0\[13\].Z sky130_fd_sc_hd__ebufn_2
XSLICE_16\[1\].RAM16.SLICE\[1\].RAM8.WORD\[5\].W.BYTE\[2\].B.SEL0INV SLICE_16\[1\].RAM16.SLICE\[1\].RAM8.WORD\[5\].W.BYTE\[0\].B.SEL0
+ VGND VGND VPWR VPWR SLICE_16\[1\].RAM16.SLICE\[1\].RAM8.WORD\[5\].W.BYTE\[2\].B.SEL0_B
+ sky130_fd_sc_hd__inv_1
Xtap_45_0 VGND VPWR sky130_fd_sc_hd__tapvpwrvgnd_1
XSLICE_16\[1\].RAM16.SLICE\[1\].RAM8.WORD\[2\].W.BYTE\[1\].B.genblk1.CG SLICE_16\[1\].RAM16.SLICE\[1\].RAM8.WORD\[2\].W.BYTE\[1\].B.CLK_B
+ SLICE_16\[1\].RAM16.SLICE\[1\].RAM8.WORD\[2\].W.BYTE\[1\].B.WE0_WIRE VGND VGND VPWR
+ VPWR SLICE_16\[1\].RAM16.SLICE\[1\].RAM8.WORD\[2\].W.BYTE\[1\].B.GCLK sky130_fd_sc_hd__dlclkp_1
XSLICE_16\[1\].RAM16.SLICE\[0\].RAM8.WORD\[3\].W.BYTE\[0\].B.BIT\[1\].OBUF0 SLICE_16\[1\].RAM16.SLICE\[0\].RAM8.WORD\[3\].W.BYTE\[0\].B.Q_WIRE\[1\]
+ SLICE_16\[1\].RAM16.SLICE\[0\].RAM8.WORD\[3\].W.BYTE\[0\].B.SEL0_B VGND VGND VPWR
+ VPWR SLICE_16\[1\].RAM16.BYTE\[0\].FLOATBUF0\[1\].Z sky130_fd_sc_hd__ebufn_2
XSLICE_16\[0\].RAM16.SLICE\[1\].RAM8.WORD\[0\].W.BYTE\[2\].B.BIT\[0\].OBUF0 SLICE_16\[0\].RAM16.SLICE\[1\].RAM8.WORD\[0\].W.BYTE\[2\].B.Q_WIRE\[0\]
+ SLICE_16\[0\].RAM16.SLICE\[1\].RAM8.WORD\[0\].W.BYTE\[2\].B.SEL0_B VGND VGND VPWR
+ VPWR SLICE_16\[0\].RAM16.BYTE\[2\].FLOATBUF0\[16\].Z sky130_fd_sc_hd__ebufn_2
XSLICE_16\[1\].RAM16.SLICE\[0\].RAM8.WORD\[7\].W.BYTE\[3\].B.BIT\[4\].OBUF0 SLICE_16\[1\].RAM16.SLICE\[0\].RAM8.WORD\[7\].W.BYTE\[3\].B.Q_WIRE\[4\]
+ SLICE_16\[1\].RAM16.SLICE\[0\].RAM8.WORD\[7\].W.BYTE\[3\].B.SEL0_B VGND VGND VPWR
+ VPWR SLICE_16\[1\].RAM16.BYTE\[3\].FLOATBUF0\[28\].Z sky130_fd_sc_hd__ebufn_2
XSLICE_16\[0\].RAM16.SLICE\[1\].RAM8.WORD\[5\].W.BYTE\[2\].B.genblk1.CLKINV SLICE_16\[0\].RAM16.SLICE\[1\].RAM8.WORD\[5\].W.BYTE\[0\].B.CLK
+ VGND VGND VPWR VPWR SLICE_16\[0\].RAM16.SLICE\[1\].RAM8.WORD\[5\].W.BYTE\[2\].B.CLK_B
+ sky130_fd_sc_hd__inv_1
XSLICE_16\[1\].RAM16.SLICE\[1\].RAM8.WORD\[0\].W.BYTE\[3\].B.BIT\[0\].genblk1.STORAGE
+ DIBUF\[24\].X SLICE_16\[1\].RAM16.SLICE\[1\].RAM8.WORD\[0\].W.BYTE\[3\].B.GCLK VGND
+ VGND VPWR VPWR SLICE_16\[1\].RAM16.SLICE\[1\].RAM8.WORD\[0\].W.BYTE\[3\].B.Q_WIRE\[0\]
+ sky130_fd_sc_hd__dlxtp_1
XSLICE_16\[1\].RAM16.SLICE\[0\].RAM8.WORD\[1\].W.BYTE\[1\].B.SEL0INV SLICE_16\[1\].RAM16.SLICE\[0\].RAM8.WORD\[1\].W.BYTE\[0\].B.SEL0
+ VGND VGND VPWR VPWR SLICE_16\[1\].RAM16.SLICE\[0\].RAM8.WORD\[1\].W.BYTE\[1\].B.SEL0_B
+ sky130_fd_sc_hd__inv_1
Xtap_13_27 VGND VPWR sky130_fd_sc_hd__tapvpwrvgnd_1
Xtap_13_16 VGND VPWR sky130_fd_sc_hd__tapvpwrvgnd_1
Xfill_7_1 VGND VGND VPWR VPWR sky130_fd_sc_hd__decap_3
XSLICE_16\[1\].RAM16.Do0_REG.OUTREG_BYTE\[1\].DIODE\[6\] SLICE_16\[1\].RAM16.BYTE\[1\].FLOATBUF0\[14\].Z
+ VGND VGND VPWR VPWR sky130_fd_sc_hd__diode_2
XSLICE_16\[0\].RAM16.SLICE\[1\].RAM8.WORD\[3\].W.BYTE\[3\].B.SEL0INV SLICE_16\[0\].RAM16.SLICE\[1\].RAM8.WORD\[3\].W.BYTE\[0\].B.SEL0
+ VGND VGND VPWR VPWR SLICE_16\[0\].RAM16.SLICE\[1\].RAM8.WORD\[3\].W.BYTE\[3\].B.SEL0_B
+ sky130_fd_sc_hd__inv_1
XSLICE_16\[0\].RAM16.SLICE\[0\].RAM8.DEC0.AND6 SLICE_16\[0\].RAM16.SLICE\[0\].RAM8.DEC0.A_buf\[0\]
+ SLICE_16\[0\].RAM16.SLICE\[0\].RAM8.DEC0.A_buf\[1\] SLICE_16\[0\].RAM16.SLICE\[0\].RAM8.DEC0.A_buf\[2\]
+ SLICE_16\[0\].RAM16.SLICE\[0\].RAM8.DEC0.EN_buf VGND VGND VPWR VPWR SLICE_16\[0\].RAM16.SLICE\[0\].RAM8.DEC0.SEL\[6\]
+ sky130_fd_sc_hd__and4b_2
Xtap_38_35 VGND VPWR sky130_fd_sc_hd__tapvpwrvgnd_1
Xtap_38_24 VGND VPWR sky130_fd_sc_hd__tapvpwrvgnd_1
Xtap_38_13 VGND VPWR sky130_fd_sc_hd__tapvpwrvgnd_1
Xtap_31_6 VGND VPWR sky130_fd_sc_hd__tapvpwrvgnd_1
XSLICE_16\[1\].RAM16.SLICE\[0\].RAM8.WORD\[3\].W.BYTE\[2\].B.BIT\[5\].genblk1.STORAGE
+ DIBUF\[21\].X SLICE_16\[1\].RAM16.SLICE\[0\].RAM8.WORD\[3\].W.BYTE\[2\].B.GCLK VGND
+ VGND VPWR VPWR SLICE_16\[1\].RAM16.SLICE\[0\].RAM8.WORD\[3\].W.BYTE\[2\].B.Q_WIRE\[5\]
+ sky130_fd_sc_hd__dlxtp_1
Xtap_24_5 VGND VPWR sky130_fd_sc_hd__tapvpwrvgnd_1
Xtap_17_4 VGND VPWR sky130_fd_sc_hd__tapvpwrvgnd_1
XSLICE_16\[1\].RAM16.SLICE\[0\].RAM8.WORD\[6\].W.BYTE\[1\].B.BIT\[1\].OBUF0 SLICE_16\[1\].RAM16.SLICE\[0\].RAM8.WORD\[6\].W.BYTE\[1\].B.Q_WIRE\[1\]
+ SLICE_16\[1\].RAM16.SLICE\[0\].RAM8.WORD\[6\].W.BYTE\[1\].B.SEL0_B VGND VGND VPWR
+ VPWR SLICE_16\[1\].RAM16.BYTE\[1\].FLOATBUF0\[9\].Z sky130_fd_sc_hd__ebufn_2
XSLICE_16\[1\].RAM16.SLICE\[0\].RAM8.WORD\[1\].W.BYTE\[0\].B.BIT\[4\].genblk1.STORAGE
+ DIBUF\[4\].X SLICE_16\[1\].RAM16.SLICE\[0\].RAM8.WORD\[1\].W.BYTE\[0\].B.GCLK VGND
+ VGND VPWR VPWR SLICE_16\[1\].RAM16.SLICE\[0\].RAM8.WORD\[1\].W.BYTE\[0\].B.Q_WIRE\[4\]
+ sky130_fd_sc_hd__dlxtp_1
XSLICE_16\[0\].RAM16.SLICE\[1\].RAM8.WORD\[5\].W.BYTE\[2\].B.BIT\[6\].genblk1.STORAGE
+ DIBUF\[22\].X SLICE_16\[0\].RAM16.SLICE\[1\].RAM8.WORD\[5\].W.BYTE\[2\].B.GCLK VGND
+ VGND VPWR VPWR SLICE_16\[0\].RAM16.SLICE\[1\].RAM8.WORD\[5\].W.BYTE\[2\].B.Q_WIRE\[6\]
+ sky130_fd_sc_hd__dlxtp_1
XSLICE_16\[0\].RAM16.SLICE\[1\].RAM8.WORD\[3\].W.BYTE\[3\].B.BIT\[0\].OBUF0 SLICE_16\[0\].RAM16.SLICE\[1\].RAM8.WORD\[3\].W.BYTE\[3\].B.Q_WIRE\[0\]
+ SLICE_16\[0\].RAM16.SLICE\[1\].RAM8.WORD\[3\].W.BYTE\[3\].B.SEL0_B VGND VGND VPWR
+ VPWR SLICE_16\[0\].RAM16.BYTE\[3\].FLOATBUF0\[24\].Z sky130_fd_sc_hd__ebufn_2
Xtap_0_30 VGND VPWR sky130_fd_sc_hd__tapvpwrvgnd_1
Xfill_42_44 VGND VGND VPWR VPWR sky130_fd_sc_hd__decap_12
Xfill_42_33 VGND VPWR sky130_fd_sc_hd__tapvpwrvgnd_1
Xfill_42_22 VGND VGND VPWR VPWR sky130_fd_sc_hd__decap_12
Xfill_42_11 VGND VGND VPWR VPWR sky130_fd_sc_hd__decap_12
XSLICE_16\[0\].RAM16.SLICE\[1\].RAM8.WORD\[3\].W.BYTE\[0\].B.BIT\[5\].genblk1.STORAGE
+ DIBUF\[5\].X SLICE_16\[0\].RAM16.SLICE\[1\].RAM8.WORD\[3\].W.BYTE\[0\].B.GCLK VGND
+ VGND VPWR VPWR SLICE_16\[0\].RAM16.SLICE\[1\].RAM8.WORD\[3\].W.BYTE\[0\].B.Q_WIRE\[5\]
+ sky130_fd_sc_hd__dlxtp_1
XSLICE_16\[0\].RAM16.SLICE\[0\].RAM8.WORD\[4\].W.BYTE\[2\].B.BIT\[1\].genblk1.STORAGE
+ DIBUF\[17\].X SLICE_16\[0\].RAM16.SLICE\[0\].RAM8.WORD\[4\].W.BYTE\[2\].B.GCLK VGND
+ VGND VPWR VPWR SLICE_16\[0\].RAM16.SLICE\[0\].RAM8.WORD\[4\].W.BYTE\[2\].B.Q_WIRE\[1\]
+ sky130_fd_sc_hd__dlxtp_1
Xfill_42_99 VGND VPWR sky130_fd_sc_hd__tapvpwrvgnd_1
Xfill_42_88 VGND VGND VPWR VPWR sky130_fd_sc_hd__decap_12
Xfill_42_77 VGND VGND VPWR VPWR sky130_fd_sc_hd__decap_12
Xfill_42_66 VGND VPWR sky130_fd_sc_hd__tapvpwrvgnd_1
Xfill_42_55 VGND VGND VPWR VPWR sky130_fd_sc_hd__decap_12
XSLICE_16\[0\].RAM16.Do0_REG.OUTREG_BYTE\[3\].DIODE\[3\] SLICE_16\[0\].RAM16.BYTE\[3\].FLOATBUF0\[27\].Z
+ VGND VGND VPWR VPWR sky130_fd_sc_hd__diode_2
XSLICE_16\[0\].RAM16.SLICE\[0\].RAM8.WORD\[2\].W.BYTE\[0\].B.BIT\[0\].genblk1.STORAGE
+ DIBUF\[0\].X SLICE_16\[0\].RAM16.SLICE\[0\].RAM8.WORD\[2\].W.BYTE\[0\].B.GCLK VGND
+ VGND VPWR VPWR SLICE_16\[0\].RAM16.SLICE\[0\].RAM8.WORD\[2\].W.BYTE\[0\].B.Q_WIRE\[0\]
+ sky130_fd_sc_hd__dlxtp_1
XDIBUF\[8\].__cell__ Di0[8] VGND VGND VPWR VPWR DIBUF\[8\].X sky130_fd_sc_hd__clkbuf_16
XSLICE_16\[0\].RAM16.SLICE\[1\].RAM8.WORD\[0\].W.BYTE\[0\].B.BIT\[5\].OBUF0 SLICE_16\[0\].RAM16.SLICE\[1\].RAM8.WORD\[0\].W.BYTE\[0\].B.Q_WIRE\[5\]
+ SLICE_16\[0\].RAM16.SLICE\[1\].RAM8.WORD\[0\].W.BYTE\[0\].B.SEL0_B VGND VGND VPWR
+ VPWR SLICE_16\[0\].RAM16.BYTE\[0\].FLOATBUF0\[5\].Z sky130_fd_sc_hd__ebufn_2
Xfill_45_8 VGND VGND VPWR VPWR sky130_fd_sc_hd__decap_12
Xfill_38_7 VGND VGND VPWR VPWR sky130_fd_sc_hd__fill_2
Xfill_0_8 VGND VGND VPWR VPWR sky130_fd_sc_hd__decap_12
XSLICE_16\[0\].RAM16.SLICE\[0\].RAM8.WORD\[4\].W.BYTE\[1\].B.CGAND SLICE_16\[0\].RAM16.SLICE\[0\].RAM8.WORD\[4\].W.BYTE\[0\].B.SEL0
+ SLICE_16\[0\].RAM16.SLICE\[0\].RAM8.WE0_buf\[1\] VGND VGND VPWR VPWR SLICE_16\[0\].RAM16.SLICE\[0\].RAM8.WORD\[4\].W.BYTE\[1\].B.WE0_WIRE
+ sky130_fd_sc_hd__and2_1
Xtap_5_19 VGND VPWR sky130_fd_sc_hd__tapvpwrvgnd_1
XSLICE_16\[1\].RAM16.Do0_REG.OUTREG_BYTE\[0\].Do_FF\[7\] SLICE_16\[1\].RAM16.Do0_REG.CLKBUF\[0\]
+ SLICE_16\[1\].RAM16.BYTE\[0\].FLOATBUF0\[7\].Z VGND VGND VPWR VPWR Do0MUX.A1\[7\]
+ sky130_fd_sc_hd__dfxtp_1
XSLICE_16\[1\].RAM16.SLICE\[1\].RAM8.WORD\[1\].W.BYTE\[2\].B.BIT\[4\].OBUF0 SLICE_16\[1\].RAM16.SLICE\[1\].RAM8.WORD\[1\].W.BYTE\[2\].B.Q_WIRE\[4\]
+ SLICE_16\[1\].RAM16.SLICE\[1\].RAM8.WORD\[1\].W.BYTE\[2\].B.SEL0_B VGND VGND VPWR
+ VPWR SLICE_16\[1\].RAM16.BYTE\[2\].FLOATBUF0\[20\].Z sky130_fd_sc_hd__ebufn_2
Xtap_24_15 VGND VPWR sky130_fd_sc_hd__tapvpwrvgnd_1
Xtap_40_25 VGND VPWR sky130_fd_sc_hd__tapvpwrvgnd_1
Xtap_40_14 VGND VPWR sky130_fd_sc_hd__tapvpwrvgnd_1
Xtap_24_26 VGND VPWR sky130_fd_sc_hd__tapvpwrvgnd_1
XSLICE_16\[0\].RAM16.SLICE\[1\].RAM8.WORD\[3\].W.BYTE\[1\].B.BIT\[5\].OBUF0 SLICE_16\[0\].RAM16.SLICE\[1\].RAM8.WORD\[3\].W.BYTE\[1\].B.Q_WIRE\[5\]
+ SLICE_16\[0\].RAM16.SLICE\[1\].RAM8.WORD\[3\].W.BYTE\[1\].B.SEL0_B VGND VGND VPWR
+ VPWR SLICE_16\[0\].RAM16.BYTE\[1\].FLOATBUF0\[13\].Z sky130_fd_sc_hd__ebufn_2
Xtap_15_1 VGND VPWR sky130_fd_sc_hd__tapvpwrvgnd_1
XSLICE_16\[0\].RAM16.SLICE\[0\].RAM8.WORD\[7\].W.SEL0BUF SLICE_16\[0\].RAM16.SLICE\[0\].RAM8.DEC0.SEL\[7\]
+ VGND VGND VPWR VPWR SLICE_16\[0\].RAM16.SLICE\[0\].RAM8.WORD\[7\].W.BYTE\[0\].B.SEL0
+ sky130_fd_sc_hd__clkbuf_2
XSLICE_16\[0\].RAM16.Do0_REG.OUTREG_BYTE\[2\].Do_FF\[4\] SLICE_16\[0\].RAM16.Do0_REG.CLKBUF\[2\]
+ SLICE_16\[0\].RAM16.BYTE\[2\].FLOATBUF0\[20\].Z VGND VGND VPWR VPWR Do0MUX.A0\[20\]
+ sky130_fd_sc_hd__dfxtp_1
Xtap_8_0 VGND VPWR sky130_fd_sc_hd__tapvpwrvgnd_1
XSLICE_16\[1\].RAM16.SLICE\[0\].RAM8.WORD\[6\].W.BYTE\[3\].B.BIT\[5\].genblk1.STORAGE
+ DIBUF\[29\].X SLICE_16\[1\].RAM16.SLICE\[0\].RAM8.WORD\[6\].W.BYTE\[3\].B.GCLK VGND
+ VGND VPWR VPWR SLICE_16\[1\].RAM16.SLICE\[0\].RAM8.WORD\[6\].W.BYTE\[3\].B.Q_WIRE\[5\]
+ sky130_fd_sc_hd__dlxtp_1
Xfill_0_16 VGND VGND VPWR VPWR sky130_fd_sc_hd__decap_12
XSLICE_16\[0\].RAM16.SLICE\[0\].RAM8.WORD\[2\].W.BYTE\[3\].B.BIT\[7\].OBUF0 SLICE_16\[0\].RAM16.SLICE\[0\].RAM8.WORD\[2\].W.BYTE\[3\].B.Q_WIRE\[7\]
+ SLICE_16\[0\].RAM16.SLICE\[0\].RAM8.WORD\[2\].W.BYTE\[3\].B.SEL0_B VGND VGND VPWR
+ VPWR SLICE_16\[0\].RAM16.BYTE\[3\].FLOATBUF0\[31\].Z sky130_fd_sc_hd__ebufn_2
XSLICE_16\[1\].RAM16.SLICE\[1\].RAM8.WORD\[0\].W.BYTE\[0\].B.BIT\[1\].OBUF0 SLICE_16\[1\].RAM16.SLICE\[1\].RAM8.WORD\[0\].W.BYTE\[0\].B.Q_WIRE\[1\]
+ SLICE_16\[1\].RAM16.SLICE\[1\].RAM8.WORD\[0\].W.BYTE\[0\].B.SEL0_B VGND VGND VPWR
+ VPWR SLICE_16\[1\].RAM16.BYTE\[0\].FLOATBUF0\[1\].Z sky130_fd_sc_hd__ebufn_2
XSLICE_16\[1\].RAM16.SLICE\[0\].RAM8.WORD\[4\].W.BYTE\[1\].B.BIT\[4\].genblk1.STORAGE
+ DIBUF\[12\].X SLICE_16\[1\].RAM16.SLICE\[0\].RAM8.WORD\[4\].W.BYTE\[1\].B.GCLK VGND
+ VGND VPWR VPWR SLICE_16\[1\].RAM16.SLICE\[0\].RAM8.WORD\[4\].W.BYTE\[1\].B.Q_WIRE\[4\]
+ sky130_fd_sc_hd__dlxtp_1
Xfill_43_5 VGND VGND VPWR VPWR sky130_fd_sc_hd__decap_12
Xfill_36_4 VGND VGND VPWR VPWR sky130_fd_sc_hd__decap_6
XSLICE_16\[1\].RAM16.SLICE\[1\].RAM8.WORD\[4\].W.BYTE\[3\].B.BIT\[4\].OBUF0 SLICE_16\[1\].RAM16.SLICE\[1\].RAM8.WORD\[4\].W.BYTE\[3\].B.Q_WIRE\[4\]
+ SLICE_16\[1\].RAM16.SLICE\[1\].RAM8.WORD\[4\].W.BYTE\[3\].B.SEL0_B VGND VGND VPWR
+ VPWR SLICE_16\[1\].RAM16.BYTE\[3\].FLOATBUF0\[28\].Z sky130_fd_sc_hd__ebufn_2
XSLICE_16\[0\].RAM16.SLICE\[1\].RAM8.WORD\[6\].W.BYTE\[1\].B.BIT\[5\].genblk1.STORAGE
+ DIBUF\[13\].X SLICE_16\[0\].RAM16.SLICE\[1\].RAM8.WORD\[6\].W.BYTE\[1\].B.GCLK VGND
+ VGND VPWR VPWR SLICE_16\[0\].RAM16.SLICE\[1\].RAM8.WORD\[6\].W.BYTE\[1\].B.Q_WIRE\[5\]
+ sky130_fd_sc_hd__dlxtp_1
XSLICE_16\[0\].RAM16.SLICE\[0\].RAM8.WORD\[7\].W.BYTE\[3\].B.BIT\[1\].genblk1.STORAGE
+ DIBUF\[25\].X SLICE_16\[0\].RAM16.SLICE\[0\].RAM8.WORD\[7\].W.BYTE\[3\].B.GCLK VGND
+ VGND VPWR VPWR SLICE_16\[0\].RAM16.SLICE\[0\].RAM8.WORD\[7\].W.BYTE\[3\].B.Q_WIRE\[1\]
+ sky130_fd_sc_hd__dlxtp_1
XSLICE_16\[0\].RAM16.SLICE\[1\].RAM8.WORD\[0\].W.BYTE\[2\].B.BIT\[6\].genblk1.STORAGE
+ DIBUF\[22\].X SLICE_16\[0\].RAM16.SLICE\[1\].RAM8.WORD\[0\].W.BYTE\[2\].B.GCLK VGND
+ VGND VPWR VPWR SLICE_16\[0\].RAM16.SLICE\[1\].RAM8.WORD\[0\].W.BYTE\[2\].B.Q_WIRE\[6\]
+ sky130_fd_sc_hd__dlxtp_1
Xfill_46_134 VGND VGND VPWR VPWR sky130_fd_sc_hd__decap_12
Xfill_46_123 VGND VPWR sky130_fd_sc_hd__tapvpwrvgnd_1
Xfill_46_112 VGND VGND VPWR VPWR sky130_fd_sc_hd__decap_12
Xfill_46_101 VGND VGND VPWR VPWR sky130_fd_sc_hd__decap_12
Xfill_29_3 VGND VGND VPWR VPWR sky130_fd_sc_hd__decap_6
XSLICE_16\[0\].RAM16.SLICE\[1\].RAM8.WORD\[5\].W.BYTE\[0\].B.CGAND SLICE_16\[0\].RAM16.SLICE\[1\].RAM8.WORD\[5\].W.BYTE\[0\].B.SEL0
+ SLICE_16\[0\].RAM16.SLICE\[1\].RAM8.WE0_buf\[0\] VGND VGND VPWR VPWR SLICE_16\[0\].RAM16.SLICE\[1\].RAM8.WORD\[5\].W.BYTE\[0\].B.WE0_WIRE
+ sky130_fd_sc_hd__and2_1
XSLICE_16\[0\].RAM16.SLICE\[0\].RAM8.WORD\[5\].W.BYTE\[1\].B.BIT\[0\].genblk1.STORAGE
+ DIBUF\[8\].X SLICE_16\[0\].RAM16.SLICE\[0\].RAM8.WORD\[5\].W.BYTE\[1\].B.GCLK VGND
+ VGND VPWR VPWR SLICE_16\[0\].RAM16.SLICE\[0\].RAM8.WORD\[5\].W.BYTE\[1\].B.Q_WIRE\[0\]
+ sky130_fd_sc_hd__dlxtp_1
XSLICE_16\[0\].RAM16.SLICE\[1\].RAM8.WORD\[6\].W.BYTE\[2\].B.BIT\[5\].OBUF0 SLICE_16\[0\].RAM16.SLICE\[1\].RAM8.WORD\[6\].W.BYTE\[2\].B.Q_WIRE\[5\]
+ SLICE_16\[0\].RAM16.SLICE\[1\].RAM8.WORD\[6\].W.BYTE\[2\].B.SEL0_B VGND VGND VPWR
+ VPWR SLICE_16\[0\].RAM16.BYTE\[2\].FLOATBUF0\[21\].Z sky130_fd_sc_hd__ebufn_2
Xtap_10_17 VGND VPWR sky130_fd_sc_hd__tapvpwrvgnd_1
Xtap_10_28 VGND VPWR sky130_fd_sc_hd__tapvpwrvgnd_1
XSLICE_16\[0\].RAM16.SLICE\[1\].RAM8.WORD\[7\].W.BYTE\[1\].B.SEL0INV SLICE_16\[0\].RAM16.SLICE\[1\].RAM8.WORD\[7\].W.BYTE\[0\].B.SEL0
+ VGND VGND VPWR VPWR SLICE_16\[0\].RAM16.SLICE\[1\].RAM8.WORD\[7\].W.BYTE\[1\].B.SEL0_B
+ sky130_fd_sc_hd__inv_1
XSLICE_16\[1\].RAM16.BYTE\[2\].FLOATBUF0\[23\].__cell__ SLICE_16\[1\].RAM16.BYTE\[2\].FLOATBUF0\[16\].A
+ SLICE_16\[1\].RAM16.BYTE\[2\].FLOATBUF0\[16\].TE_B VGND VGND VPWR VPWR SLICE_16\[1\].RAM16.BYTE\[2\].FLOATBUF0\[23\].Z
+ sky130_fd_sc_hd__ebufn_2
Xtap_35_36 VGND VPWR sky130_fd_sc_hd__tapvpwrvgnd_1
Xtap_35_25 VGND VPWR sky130_fd_sc_hd__tapvpwrvgnd_1
Xtap_35_14 VGND VPWR sky130_fd_sc_hd__tapvpwrvgnd_1
XSLICE_16\[1\].RAM16.SLICE\[1\].RAM8.WORD\[1\].W.BYTE\[3\].B.SEL0INV SLICE_16\[1\].RAM16.SLICE\[1\].RAM8.WORD\[1\].W.BYTE\[0\].B.SEL0
+ VGND VGND VPWR VPWR SLICE_16\[1\].RAM16.SLICE\[1\].RAM8.WORD\[1\].W.BYTE\[3\].B.SEL0_B
+ sky130_fd_sc_hd__inv_1
XSLICE_16\[0\].RAM16.SLICE\[0\].RAM8.WORD\[1\].W.BYTE\[1\].B.BIT\[4\].OBUF0 SLICE_16\[0\].RAM16.SLICE\[0\].RAM8.WORD\[1\].W.BYTE\[1\].B.Q_WIRE\[4\]
+ SLICE_16\[0\].RAM16.SLICE\[0\].RAM8.WORD\[1\].W.BYTE\[1\].B.SEL0_B VGND VGND VPWR
+ VPWR SLICE_16\[0\].RAM16.BYTE\[1\].FLOATBUF0\[12\].Z sky130_fd_sc_hd__ebufn_2
Xtap_1_7 VGND VPWR sky130_fd_sc_hd__tapvpwrvgnd_1
XDo0MUX.M\[2\].DIODE_A0MUX\[20\] Do0MUX.A0\[20\] VGND VGND VPWR VPWR sky130_fd_sc_hd__diode_2
XSLICE_16\[1\].RAM16.SLICE\[1\].RAM8.WORD\[3\].W.BYTE\[1\].B.BIT\[1\].OBUF0 SLICE_16\[1\].RAM16.SLICE\[1\].RAM8.WORD\[3\].W.BYTE\[1\].B.Q_WIRE\[1\]
+ SLICE_16\[1\].RAM16.SLICE\[1\].RAM8.WORD\[3\].W.BYTE\[1\].B.SEL0_B VGND VGND VPWR
+ VPWR SLICE_16\[1\].RAM16.BYTE\[1\].FLOATBUF0\[9\].Z sky130_fd_sc_hd__ebufn_2
XSLICE_16\[0\].RAM16.SLICE\[0\].RAM8.WORD\[3\].W.BYTE\[0\].B.SEL0INV SLICE_16\[0\].RAM16.SLICE\[0\].RAM8.WORD\[3\].W.BYTE\[0\].B.SEL0
+ VGND VGND VPWR VPWR SLICE_16\[0\].RAM16.SLICE\[0\].RAM8.WORD\[3\].W.BYTE\[0\].B.SEL0_B
+ sky130_fd_sc_hd__inv_1
Xfill_43_104 VGND VGND VPWR VPWR sky130_fd_sc_hd__decap_6
XSLICE_16\[1\].RAM16.SLICE\[0\].RAM8.WORD\[3\].W.BYTE\[0\].B.genblk1.CLKINV SLICE_16\[1\].RAM16.SLICE\[0\].RAM8.WORD\[3\].W.BYTE\[0\].B.CLK
+ VGND VGND VPWR VPWR SLICE_16\[1\].RAM16.SLICE\[0\].RAM8.WORD\[3\].W.BYTE\[0\].B.CLK_B
+ sky130_fd_sc_hd__inv_1
XSLICE_16\[0\].RAM16.SLICE\[1\].RAM8.WORD\[5\].W.BYTE\[0\].B.BIT\[2\].OBUF0 SLICE_16\[0\].RAM16.SLICE\[1\].RAM8.WORD\[5\].W.BYTE\[0\].B.Q_WIRE\[2\]
+ SLICE_16\[0\].RAM16.SLICE\[1\].RAM8.WORD\[5\].W.BYTE\[0\].B.SEL0_B VGND VGND VPWR
+ VPWR SLICE_16\[0\].RAM16.BYTE\[0\].FLOATBUF0\[2\].Z sky130_fd_sc_hd__ebufn_2
XSLICE_16\[0\].RAM16.SLICE\[1\].RAM8.WORD\[0\].W.CLKBUF SLICE_16\[0\].RAM16.SLICE\[1\].RAM8.CLKBUF.X
+ VGND VGND VPWR VPWR SLICE_16\[0\].RAM16.SLICE\[1\].RAM8.WORD\[0\].W.BYTE\[0\].B.CLK
+ sky130_fd_sc_hd__clkbuf_4
XSLICE_16\[1\].RAM16.SLICE\[1\].RAM8.WORD\[0\].W.SEL0BUF SLICE_16\[1\].RAM16.SLICE\[1\].RAM8.DEC0.SEL\[0\]
+ VGND VGND VPWR VPWR SLICE_16\[1\].RAM16.SLICE\[1\].RAM8.WORD\[0\].W.BYTE\[0\].B.SEL0
+ sky130_fd_sc_hd__clkbuf_2
XSLICE_16\[1\].RAM16.SLICE\[0\].RAM8.WORD\[2\].W.BYTE\[3\].B.BIT\[3\].OBUF0 SLICE_16\[1\].RAM16.SLICE\[0\].RAM8.WORD\[2\].W.BYTE\[3\].B.Q_WIRE\[3\]
+ SLICE_16\[1\].RAM16.SLICE\[0\].RAM8.WORD\[2\].W.BYTE\[3\].B.SEL0_B VGND VGND VPWR
+ VPWR SLICE_16\[1\].RAM16.BYTE\[3\].FLOATBUF0\[27\].Z sky130_fd_sc_hd__ebufn_2
XSLICE_16\[0\].RAM16.SLICE\[1\].RAM8.WORD\[1\].W.BYTE\[1\].B.genblk1.CG SLICE_16\[0\].RAM16.SLICE\[1\].RAM8.WORD\[1\].W.BYTE\[1\].B.CLK_B
+ SLICE_16\[0\].RAM16.SLICE\[1\].RAM8.WORD\[1\].W.BYTE\[1\].B.WE0_WIRE VGND VGND VPWR
+ VPWR SLICE_16\[0\].RAM16.SLICE\[1\].RAM8.WORD\[1\].W.BYTE\[1\].B.GCLK sky130_fd_sc_hd__dlclkp_1
XDo0MUX.M\[3\].DIODE_A0MUX\[24\] Do0MUX.A0\[24\] VGND VGND VPWR VPWR sky130_fd_sc_hd__diode_2
Xfill_41_2 VGND VGND VPWR VPWR sky130_fd_sc_hd__decap_12
Xfill_34_1 VGND VPWR sky130_fd_sc_hd__tapvpwrvgnd_1
Xfill_27_0 VGND VPWR sky130_fd_sc_hd__tapvpwrvgnd_1
Xfill_19_101 VGND VGND VPWR VPWR sky130_fd_sc_hd__decap_8
XSLICE_16\[0\].RAM16.SLICE\[0\].RAM8.WORD\[4\].W.BYTE\[2\].B.BIT\[4\].OBUF0 SLICE_16\[0\].RAM16.SLICE\[0\].RAM8.WORD\[4\].W.BYTE\[2\].B.Q_WIRE\[4\]
+ SLICE_16\[0\].RAM16.SLICE\[0\].RAM8.WORD\[4\].W.BYTE\[2\].B.SEL0_B VGND VGND VPWR
+ VPWR SLICE_16\[0\].RAM16.BYTE\[2\].FLOATBUF0\[20\].Z sky130_fd_sc_hd__ebufn_2
XSLICE_16\[1\].RAM16.SLICE\[1\].RAM8.WORD\[6\].W.BYTE\[2\].B.BIT\[1\].OBUF0 SLICE_16\[1\].RAM16.SLICE\[1\].RAM8.WORD\[6\].W.BYTE\[2\].B.Q_WIRE\[1\]
+ SLICE_16\[1\].RAM16.SLICE\[1\].RAM8.WORD\[6\].W.BYTE\[2\].B.SEL0_B VGND VGND VPWR
+ VPWR SLICE_16\[1\].RAM16.BYTE\[2\].FLOATBUF0\[17\].Z sky130_fd_sc_hd__ebufn_2
XSLICE_16\[1\].RAM16.SLICE\[0\].RAM8.WORD\[7\].W.BYTE\[2\].B.BIT\[4\].genblk1.STORAGE
+ DIBUF\[20\].X SLICE_16\[1\].RAM16.SLICE\[0\].RAM8.WORD\[7\].W.BYTE\[2\].B.GCLK VGND
+ VGND VPWR VPWR SLICE_16\[1\].RAM16.SLICE\[0\].RAM8.WORD\[7\].W.BYTE\[2\].B.Q_WIRE\[4\]
+ sky130_fd_sc_hd__dlxtp_1
XSLICE_16\[1\].RAM16.SLICE\[0\].RAM8.WORD\[5\].W.BYTE\[0\].B.BIT\[3\].genblk1.STORAGE
+ DIBUF\[3\].X SLICE_16\[1\].RAM16.SLICE\[0\].RAM8.WORD\[5\].W.BYTE\[0\].B.GCLK VGND
+ VGND VPWR VPWR SLICE_16\[1\].RAM16.SLICE\[0\].RAM8.WORD\[5\].W.BYTE\[0\].B.Q_WIRE\[3\]
+ sky130_fd_sc_hd__dlxtp_1
XSLICE_16\[1\].RAM16.SLICE\[0\].RAM8.WORD\[1\].W.BYTE\[3\].B.BIT\[5\].genblk1.STORAGE
+ DIBUF\[29\].X SLICE_16\[1\].RAM16.SLICE\[0\].RAM8.WORD\[1\].W.BYTE\[3\].B.GCLK VGND
+ VGND VPWR VPWR SLICE_16\[1\].RAM16.SLICE\[0\].RAM8.WORD\[1\].W.BYTE\[3\].B.Q_WIRE\[5\]
+ sky130_fd_sc_hd__dlxtp_1
XSLICE_16\[0\].RAM16.SLICE\[1\].RAM8.WORD\[7\].W.BYTE\[0\].B.BIT\[4\].genblk1.STORAGE
+ DIBUF\[4\].X SLICE_16\[0\].RAM16.SLICE\[1\].RAM8.WORD\[7\].W.BYTE\[0\].B.GCLK VGND
+ VGND VPWR VPWR SLICE_16\[0\].RAM16.SLICE\[1\].RAM8.WORD\[7\].W.BYTE\[0\].B.Q_WIRE\[4\]
+ sky130_fd_sc_hd__dlxtp_1
XSLICE_16\[0\].RAM16.SLICE\[1\].RAM8.WORD\[3\].W.BYTE\[3\].B.BIT\[6\].genblk1.STORAGE
+ DIBUF\[30\].X SLICE_16\[0\].RAM16.SLICE\[1\].RAM8.WORD\[3\].W.BYTE\[3\].B.GCLK VGND
+ VGND VPWR VPWR SLICE_16\[0\].RAM16.SLICE\[1\].RAM8.WORD\[3\].W.BYTE\[3\].B.Q_WIRE\[6\]
+ sky130_fd_sc_hd__dlxtp_1
XSLICE_16\[0\].RAM16.SLICE\[1\].RAM8.WORD\[1\].W.BYTE\[1\].B.BIT\[5\].genblk1.STORAGE
+ DIBUF\[13\].X SLICE_16\[0\].RAM16.SLICE\[1\].RAM8.WORD\[1\].W.BYTE\[1\].B.GCLK VGND
+ VGND VPWR VPWR SLICE_16\[0\].RAM16.SLICE\[1\].RAM8.WORD\[1\].W.BYTE\[1\].B.Q_WIRE\[5\]
+ sky130_fd_sc_hd__dlxtp_1
XSLICE_16\[1\].RAM16.SLICE\[0\].RAM8.WORD\[1\].W.BYTE\[1\].B.BIT\[0\].OBUF0 SLICE_16\[1\].RAM16.SLICE\[0\].RAM8.WORD\[1\].W.BYTE\[1\].B.Q_WIRE\[0\]
+ SLICE_16\[1\].RAM16.SLICE\[0\].RAM8.WORD\[1\].W.BYTE\[1\].B.SEL0_B VGND VGND VPWR
+ VPWR SLICE_16\[1\].RAM16.BYTE\[1\].FLOATBUF0\[8\].Z sky130_fd_sc_hd__ebufn_2
Xfill_18_24 VGND VGND VPWR VPWR sky130_fd_sc_hd__decap_8
Xfill_18_13 VGND VGND VPWR VPWR sky130_fd_sc_hd__decap_12
XSLICE_16\[0\].RAM16.SLICE\[0\].RAM8.WORD\[2\].W.BYTE\[3\].B.BIT\[1\].genblk1.STORAGE
+ DIBUF\[25\].X SLICE_16\[0\].RAM16.SLICE\[0\].RAM8.WORD\[2\].W.BYTE\[3\].B.GCLK VGND
+ VGND VPWR VPWR SLICE_16\[0\].RAM16.SLICE\[0\].RAM8.WORD\[2\].W.BYTE\[3\].B.Q_WIRE\[1\]
+ sky130_fd_sc_hd__dlxtp_1
XDo0MUX.M\[1\].DIODE_A1MUX\[14\] Do0MUX.A1\[14\] VGND VGND VPWR VPWR sky130_fd_sc_hd__diode_2
XSLICE_16\[1\].RAM16.SLICE\[0\].RAM8.WORD\[6\].W.BYTE\[1\].B.genblk1.CLKINV SLICE_16\[1\].RAM16.SLICE\[0\].RAM8.WORD\[6\].W.BYTE\[0\].B.CLK
+ VGND VGND VPWR VPWR SLICE_16\[1\].RAM16.SLICE\[0\].RAM8.WORD\[6\].W.BYTE\[1\].B.CLK_B
+ sky130_fd_sc_hd__inv_1
XSLICE_16\[1\].RAM16.SLICE\[0\].RAM8.DEC0.ABUF\[0\] SLICE_16\[1\].RAM16.A0BUF\[0\].X
+ VGND VGND VPWR VPWR SLICE_16\[1\].RAM16.SLICE\[0\].RAM8.DEC0.A_buf\[0\] sky130_fd_sc_hd__clkbuf_2
XSLICE_16\[0\].RAM16.SLICE\[0\].RAM8.WORD\[0\].W.BYTE\[1\].B.BIT\[0\].genblk1.STORAGE
+ DIBUF\[8\].X SLICE_16\[0\].RAM16.SLICE\[0\].RAM8.WORD\[0\].W.BYTE\[1\].B.GCLK VGND
+ VGND VPWR VPWR SLICE_16\[0\].RAM16.SLICE\[0\].RAM8.WORD\[0\].W.BYTE\[1\].B.Q_WIRE\[0\]
+ sky130_fd_sc_hd__dlxtp_1
XSLICE_16\[0\].RAM16.SLICE\[0\].RAM8.WORD\[0\].W.BYTE\[0\].B.CGAND SLICE_16\[0\].RAM16.SLICE\[0\].RAM8.WORD\[0\].W.BYTE\[0\].B.SEL0
+ SLICE_16\[0\].RAM16.SLICE\[0\].RAM8.WE0_buf\[0\] VGND VGND VPWR VPWR SLICE_16\[0\].RAM16.SLICE\[0\].RAM8.WORD\[0\].W.BYTE\[0\].B.WE0_WIRE
+ sky130_fd_sc_hd__and2_1
XSLICE_16\[0\].RAM16.SLICE\[0\].RAM8.WORD\[3\].W.BYTE\[0\].B.BIT\[1\].OBUF0 SLICE_16\[0\].RAM16.SLICE\[0\].RAM8.WORD\[3\].W.BYTE\[0\].B.Q_WIRE\[1\]
+ SLICE_16\[0\].RAM16.SLICE\[0\].RAM8.WORD\[3\].W.BYTE\[0\].B.SEL0_B VGND VGND VPWR
+ VPWR SLICE_16\[0\].RAM16.BYTE\[0\].FLOATBUF0\[1\].Z sky130_fd_sc_hd__ebufn_2
Xfill_20_7 VGND VGND VPWR VPWR sky130_fd_sc_hd__decap_12
XSLICE_16\[0\].RAM16.SLICE\[0\].RAM8.WORD\[7\].W.BYTE\[3\].B.BIT\[4\].OBUF0 SLICE_16\[0\].RAM16.SLICE\[0\].RAM8.WORD\[7\].W.BYTE\[3\].B.Q_WIRE\[4\]
+ SLICE_16\[0\].RAM16.SLICE\[0\].RAM8.WORD\[7\].W.BYTE\[3\].B.SEL0_B VGND VGND VPWR
+ VPWR SLICE_16\[0\].RAM16.BYTE\[3\].FLOATBUF0\[28\].Z sky130_fd_sc_hd__ebufn_2
Xfill_13_6 VGND VGND VPWR VPWR sky130_fd_sc_hd__decap_6
XDIBUF\[14\].__cell__ Di0[14] VGND VGND VPWR VPWR DIBUF\[14\].X sky130_fd_sc_hd__clkbuf_16
XDo0MUX.M\[2\].DIODE_A1MUX\[18\] Do0MUX.A1\[18\] VGND VGND VPWR VPWR sky130_fd_sc_hd__diode_2
XSLICE_16\[1\].RAM16.Do0_REG.OUTREG_BYTE\[1\].Do_FF\[0\] SLICE_16\[1\].RAM16.Do0_REG.CLKBUF\[1\]
+ SLICE_16\[1\].RAM16.BYTE\[1\].FLOATBUF0\[8\].Z VGND VGND VPWR VPWR Do0MUX.A1\[8\]
+ sky130_fd_sc_hd__dfxtp_1
XSLICE_16\[1\].RAM16.SLICE\[1\].RAM8.WORD\[6\].W.BYTE\[0\].B.BIT\[6\].OBUF0 SLICE_16\[1\].RAM16.SLICE\[1\].RAM8.WORD\[6\].W.BYTE\[0\].B.Q_WIRE\[6\]
+ SLICE_16\[1\].RAM16.SLICE\[1\].RAM8.WORD\[6\].W.BYTE\[0\].B.SEL0_B VGND VGND VPWR
+ VPWR SLICE_16\[1\].RAM16.BYTE\[0\].FLOATBUF0\[6\].Z sky130_fd_sc_hd__ebufn_2
XSLICE_16\[1\].RAM16.SLICE\[0\].RAM8.WORD\[4\].W.BYTE\[2\].B.BIT\[0\].OBUF0 SLICE_16\[1\].RAM16.SLICE\[0\].RAM8.WORD\[4\].W.BYTE\[2\].B.Q_WIRE\[0\]
+ SLICE_16\[1\].RAM16.SLICE\[0\].RAM8.WORD\[4\].W.BYTE\[2\].B.SEL0_B VGND VGND VPWR
+ VPWR SLICE_16\[1\].RAM16.BYTE\[2\].FLOATBUF0\[16\].Z sky130_fd_sc_hd__ebufn_2
Xtap_16_27 VGND VPWR sky130_fd_sc_hd__tapvpwrvgnd_1
Xtap_16_16 VGND VPWR sky130_fd_sc_hd__tapvpwrvgnd_1
Xtap_32_26 VGND VPWR sky130_fd_sc_hd__tapvpwrvgnd_1
Xtap_32_15 VGND VPWR sky130_fd_sc_hd__tapvpwrvgnd_1
XSLICE_16\[1\].RAM16.SLICE\[0\].RAM8.DEC0.AND3 SLICE_16\[1\].RAM16.SLICE\[0\].RAM8.DEC0.A_buf\[2\]
+ SLICE_16\[1\].RAM16.SLICE\[0\].RAM8.DEC0.A_buf\[1\] SLICE_16\[1\].RAM16.SLICE\[0\].RAM8.DEC0.A_buf\[0\]
+ SLICE_16\[1\].RAM16.SLICE\[0\].RAM8.DEC0.EN_buf VGND VGND VPWR VPWR SLICE_16\[1\].RAM16.SLICE\[0\].RAM8.DEC0.SEL\[3\]
+ sky130_fd_sc_hd__and4b_2
XSLICE_16\[1\].RAM16.SLICE\[1\].RAM8.WORD\[5\].W.BYTE\[1\].B.SEL0INV SLICE_16\[1\].RAM16.SLICE\[1\].RAM8.WORD\[5\].W.BYTE\[0\].B.SEL0
+ VGND VGND VPWR VPWR SLICE_16\[1\].RAM16.SLICE\[1\].RAM8.WORD\[5\].W.BYTE\[1\].B.SEL0_B
+ sky130_fd_sc_hd__inv_1
XSLICE_16\[0\].RAM16.SLICE\[0\].RAM8.WORD\[1\].W.BYTE\[1\].B.DIODE_CLK SLICE_16\[0\].RAM16.SLICE\[0\].RAM8.WORD\[1\].W.BYTE\[0\].B.CLK
+ VGND VGND VPWR VPWR sky130_fd_sc_hd__diode_2
Xtap_47_4 VGND VPWR sky130_fd_sc_hd__tapvpwrvgnd_1
Xfill_20_69 VGND VPWR sky130_fd_sc_hd__tapvpwrvgnd_1
Xfill_20_58 VGND VGND VPWR VPWR sky130_fd_sc_hd__decap_12
Xfill_20_47 VGND VGND VPWR VPWR sky130_fd_sc_hd__decap_12
Xfill_20_36 VGND VPWR sky130_fd_sc_hd__tapvpwrvgnd_1
Xfill_20_25 VGND VGND VPWR VPWR sky130_fd_sc_hd__decap_12
Xfill_20_14 VGND VGND VPWR VPWR sky130_fd_sc_hd__decap_12
Xtap_3_30 VGND VPWR sky130_fd_sc_hd__tapvpwrvgnd_1
XSLICE_16\[0\].RAM16.SLICE\[0\].RAM8.WORD\[6\].W.BYTE\[1\].B.BIT\[1\].OBUF0 SLICE_16\[0\].RAM16.SLICE\[0\].RAM8.WORD\[6\].W.BYTE\[1\].B.Q_WIRE\[1\]
+ SLICE_16\[0\].RAM16.SLICE\[0\].RAM8.WORD\[6\].W.BYTE\[1\].B.SEL0_B VGND VGND VPWR
+ VPWR SLICE_16\[0\].RAM16.BYTE\[1\].FLOATBUF0\[9\].Z sky130_fd_sc_hd__ebufn_2
Xfill_45_22 VGND VGND VPWR VPWR sky130_fd_sc_hd__decap_12
Xfill_45_11 VGND VGND VPWR VPWR sky130_fd_sc_hd__decap_12
XSLICE_16\[1\].RAM16.SLICE\[1\].RAM8.WORD\[7\].W.BYTE\[3\].B.CGAND SLICE_16\[1\].RAM16.SLICE\[1\].RAM8.WORD\[7\].W.BYTE\[0\].B.SEL0
+ SLICE_16\[1\].RAM16.SLICE\[1\].RAM8.WE0_buf\[3\] VGND VGND VPWR VPWR SLICE_16\[1\].RAM16.SLICE\[1\].RAM8.WORD\[7\].W.BYTE\[3\].B.WE0_WIRE
+ sky130_fd_sc_hd__and2_1
XSLICE_16\[1\].RAM16.SLICE\[0\].RAM8.WORD\[2\].W.BYTE\[2\].B.BIT\[4\].genblk1.STORAGE
+ DIBUF\[20\].X SLICE_16\[1\].RAM16.SLICE\[0\].RAM8.WORD\[2\].W.BYTE\[2\].B.GCLK VGND
+ VGND VPWR VPWR SLICE_16\[1\].RAM16.SLICE\[0\].RAM8.WORD\[2\].W.BYTE\[2\].B.Q_WIRE\[4\]
+ sky130_fd_sc_hd__dlxtp_1
Xfill_45_99 VGND VPWR sky130_fd_sc_hd__tapvpwrvgnd_1
Xfill_45_88 VGND VGND VPWR VPWR sky130_fd_sc_hd__decap_12
Xfill_45_77 VGND VGND VPWR VPWR sky130_fd_sc_hd__decap_12
Xfill_45_66 VGND VPWR sky130_fd_sc_hd__tapvpwrvgnd_1
Xfill_45_55 VGND VGND VPWR VPWR sky130_fd_sc_hd__decap_12
Xfill_45_44 VGND VGND VPWR VPWR sky130_fd_sc_hd__decap_12
Xfill_45_33 VGND VPWR sky130_fd_sc_hd__tapvpwrvgnd_1
XSLICE_16\[1\].RAM16.SLICE\[0\].RAM8.WORD\[0\].W.BYTE\[0\].B.BIT\[3\].genblk1.STORAGE
+ DIBUF\[3\].X SLICE_16\[1\].RAM16.SLICE\[0\].RAM8.WORD\[0\].W.BYTE\[0\].B.GCLK VGND
+ VGND VPWR VPWR SLICE_16\[1\].RAM16.SLICE\[0\].RAM8.WORD\[0\].W.BYTE\[0\].B.Q_WIRE\[3\]
+ sky130_fd_sc_hd__dlxtp_1
XSLICE_16\[0\].RAM16.SLICE\[1\].RAM8.WORD\[4\].W.BYTE\[2\].B.BIT\[5\].genblk1.STORAGE
+ DIBUF\[21\].X SLICE_16\[0\].RAM16.SLICE\[1\].RAM8.WORD\[4\].W.BYTE\[2\].B.GCLK VGND
+ VGND VPWR VPWR SLICE_16\[0\].RAM16.SLICE\[1\].RAM8.WORD\[4\].W.BYTE\[2\].B.Q_WIRE\[5\]
+ sky130_fd_sc_hd__dlxtp_1
XSLICE_16\[1\].RAM16.SLICE\[0\].RAM8.WORD\[1\].W.BYTE\[0\].B.SEL0INV SLICE_16\[1\].RAM16.SLICE\[0\].RAM8.WORD\[1\].W.BYTE\[0\].B.SEL0
+ VGND VGND VPWR VPWR SLICE_16\[1\].RAM16.SLICE\[0\].RAM8.WORD\[1\].W.BYTE\[0\].B.SEL0_B
+ sky130_fd_sc_hd__inv_1
XSLICE_16\[0\].RAM16.SLICE\[1\].RAM8.WORD\[2\].W.BYTE\[0\].B.BIT\[4\].genblk1.STORAGE
+ DIBUF\[4\].X SLICE_16\[0\].RAM16.SLICE\[1\].RAM8.WORD\[2\].W.BYTE\[0\].B.GCLK VGND
+ VGND VPWR VPWR SLICE_16\[0\].RAM16.SLICE\[1\].RAM8.WORD\[2\].W.BYTE\[0\].B.Q_WIRE\[4\]
+ sky130_fd_sc_hd__dlxtp_1
XSLICE_16\[1\].RAM16.SLICE\[1\].RAM8.WORD\[0\].W.BYTE\[0\].B.genblk1.CLKINV SLICE_16\[1\].RAM16.SLICE\[1\].RAM8.WORD\[0\].W.BYTE\[0\].B.CLK
+ VGND VGND VPWR VPWR SLICE_16\[1\].RAM16.SLICE\[1\].RAM8.WORD\[0\].W.BYTE\[0\].B.CLK_B
+ sky130_fd_sc_hd__inv_1
XSLICE_16\[1\].RAM16.SLICE\[0\].RAM8.WORD\[7\].W.BYTE\[3\].B.BIT\[0\].OBUF0 SLICE_16\[1\].RAM16.SLICE\[0\].RAM8.WORD\[7\].W.BYTE\[3\].B.Q_WIRE\[0\]
+ SLICE_16\[1\].RAM16.SLICE\[0\].RAM8.WORD\[7\].W.BYTE\[3\].B.SEL0_B VGND VGND VPWR
+ VPWR SLICE_16\[1\].RAM16.BYTE\[3\].FLOATBUF0\[24\].Z sky130_fd_sc_hd__ebufn_2
XSLICE_16\[0\].RAM16.SLICE\[0\].RAM8.WORD\[3\].W.BYTE\[2\].B.BIT\[0\].genblk1.STORAGE
+ DIBUF\[16\].X SLICE_16\[0\].RAM16.SLICE\[0\].RAM8.WORD\[3\].W.BYTE\[2\].B.GCLK VGND
+ VGND VPWR VPWR SLICE_16\[0\].RAM16.SLICE\[0\].RAM8.WORD\[3\].W.BYTE\[2\].B.Q_WIRE\[0\]
+ sky130_fd_sc_hd__dlxtp_1
Xfill_11_3 VGND VGND VPWR VPWR sky130_fd_sc_hd__fill_2
Xtap_8_19 VGND VPWR sky130_fd_sc_hd__tapvpwrvgnd_1
XSLICE_16\[1\].RAM16.SLICE\[0\].RAM8.WORD\[4\].W.BYTE\[0\].B.BIT\[5\].OBUF0 SLICE_16\[1\].RAM16.SLICE\[0\].RAM8.WORD\[4\].W.BYTE\[0\].B.Q_WIRE\[5\]
+ SLICE_16\[1\].RAM16.SLICE\[0\].RAM8.WORD\[4\].W.BYTE\[0\].B.SEL0_B VGND VGND VPWR
+ VPWR SLICE_16\[1\].RAM16.BYTE\[0\].FLOATBUF0\[5\].Z sky130_fd_sc_hd__ebufn_2
XSLICE_16\[0\].RAM16.SLICE\[1\].RAM8.WORD\[3\].W.BYTE\[2\].B.SEL0INV SLICE_16\[0\].RAM16.SLICE\[1\].RAM8.WORD\[3\].W.BYTE\[0\].B.SEL0
+ VGND VGND VPWR VPWR SLICE_16\[0\].RAM16.SLICE\[1\].RAM8.WORD\[3\].W.BYTE\[2\].B.SEL0_B
+ sky130_fd_sc_hd__inv_1
XSLICE_16\[0\].RAM16.SLICE\[1\].RAM8.WORD\[1\].W.BYTE\[2\].B.BIT\[4\].OBUF0 SLICE_16\[0\].RAM16.SLICE\[1\].RAM8.WORD\[1\].W.BYTE\[2\].B.Q_WIRE\[4\]
+ SLICE_16\[0\].RAM16.SLICE\[1\].RAM8.WORD\[1\].W.BYTE\[2\].B.SEL0_B VGND VGND VPWR
+ VPWR SLICE_16\[0\].RAM16.BYTE\[2\].FLOATBUF0\[20\].Z sky130_fd_sc_hd__ebufn_2
Xtap_26_9 VGND VPWR sky130_fd_sc_hd__tapvpwrvgnd_1
Xtap_27_26 VGND VPWR sky130_fd_sc_hd__tapvpwrvgnd_1
Xtap_27_15 VGND VPWR sky130_fd_sc_hd__tapvpwrvgnd_1
XSLICE_16\[0\].RAM16.Do0_REG.OUTREG_BYTE\[0\].DIODE\[0\] SLICE_16\[0\].RAM16.BYTE\[0\].FLOATBUF0\[0\].Z
+ VGND VGND VPWR VPWR sky130_fd_sc_hd__diode_2
Xtap_38_0 VGND VPWR sky130_fd_sc_hd__tapvpwrvgnd_1
XSLICE_16\[1\].RAM16.SLICE\[1\].RAM8.WORD\[3\].W.BYTE\[1\].B.genblk1.CLKINV SLICE_16\[1\].RAM16.SLICE\[1\].RAM8.WORD\[3\].W.BYTE\[0\].B.CLK
+ VGND VGND VPWR VPWR SLICE_16\[1\].RAM16.SLICE\[1\].RAM8.WORD\[3\].W.BYTE\[1\].B.CLK_B
+ sky130_fd_sc_hd__inv_1
XSLICE_16\[0\].RAM16.SLICE\[1\].RAM8.WORD\[0\].W.BYTE\[0\].B.BIT\[1\].OBUF0 SLICE_16\[0\].RAM16.SLICE\[1\].RAM8.WORD\[0\].W.BYTE\[0\].B.Q_WIRE\[1\]
+ SLICE_16\[0\].RAM16.SLICE\[1\].RAM8.WORD\[0\].W.BYTE\[0\].B.SEL0_B VGND VGND VPWR
+ VPWR SLICE_16\[0\].RAM16.BYTE\[0\].FLOATBUF0\[1\].Z sky130_fd_sc_hd__ebufn_2
XSLICE_16\[1\].RAM16.SLICE\[1\].RAM8.WORD\[0\].W.BYTE\[2\].B.DIODE_CLK SLICE_16\[1\].RAM16.SLICE\[1\].RAM8.WORD\[0\].W.BYTE\[0\].B.CLK
+ VGND VGND VPWR VPWR sky130_fd_sc_hd__diode_2
XSLICE_16\[1\].RAM16.SLICE\[0\].RAM8.WORD\[7\].W.BYTE\[1\].B.BIT\[5\].OBUF0 SLICE_16\[1\].RAM16.SLICE\[0\].RAM8.WORD\[7\].W.BYTE\[1\].B.Q_WIRE\[5\]
+ SLICE_16\[1\].RAM16.SLICE\[0\].RAM8.WORD\[7\].W.BYTE\[1\].B.SEL0_B VGND VGND VPWR
+ VPWR SLICE_16\[1\].RAM16.BYTE\[1\].FLOATBUF0\[13\].Z sky130_fd_sc_hd__ebufn_2
XSLICE_16\[1\].RAM16.SLICE\[0\].RAM8.WORD\[6\].W.BYTE\[1\].B.DIODE_CLK SLICE_16\[1\].RAM16.SLICE\[0\].RAM8.WORD\[6\].W.BYTE\[0\].B.CLK
+ VGND VGND VPWR VPWR sky130_fd_sc_hd__diode_2
XSLICE_16\[0\].RAM16.SLICE\[1\].RAM8.WORD\[4\].W.BYTE\[3\].B.BIT\[4\].OBUF0 SLICE_16\[0\].RAM16.SLICE\[1\].RAM8.WORD\[4\].W.BYTE\[3\].B.Q_WIRE\[4\]
+ SLICE_16\[0\].RAM16.SLICE\[1\].RAM8.WORD\[4\].W.BYTE\[3\].B.SEL0_B VGND VGND VPWR
+ VPWR SLICE_16\[0\].RAM16.BYTE\[3\].FLOATBUF0\[28\].Z sky130_fd_sc_hd__ebufn_2
XSLICE_16\[1\].RAM16.SLICE\[0\].RAM8.WORD\[5\].W.BYTE\[3\].B.BIT\[4\].genblk1.STORAGE
+ DIBUF\[28\].X SLICE_16\[1\].RAM16.SLICE\[0\].RAM8.WORD\[5\].W.BYTE\[3\].B.GCLK VGND
+ VGND VPWR VPWR SLICE_16\[1\].RAM16.SLICE\[0\].RAM8.WORD\[5\].W.BYTE\[3\].B.Q_WIRE\[4\]
+ sky130_fd_sc_hd__dlxtp_1
Xfill_21_90 VGND VPWR sky130_fd_sc_hd__tapvpwrvgnd_1
XSLICE_16\[1\].RAM16.SLICE\[0\].RAM8.WORD\[3\].W.BYTE\[1\].B.BIT\[3\].genblk1.STORAGE
+ DIBUF\[11\].X SLICE_16\[1\].RAM16.SLICE\[0\].RAM8.WORD\[3\].W.BYTE\[1\].B.GCLK VGND
+ VGND VPWR VPWR SLICE_16\[1\].RAM16.SLICE\[0\].RAM8.WORD\[3\].W.BYTE\[1\].B.Q_WIRE\[3\]
+ sky130_fd_sc_hd__dlxtp_1
XSLICE_16\[0\].RAM16.SLICE\[1\].RAM8.WORD\[7\].W.BYTE\[3\].B.BIT\[5\].genblk1.STORAGE
+ DIBUF\[29\].X SLICE_16\[0\].RAM16.SLICE\[1\].RAM8.WORD\[7\].W.BYTE\[3\].B.GCLK VGND
+ VGND VPWR VPWR SLICE_16\[0\].RAM16.SLICE\[1\].RAM8.WORD\[7\].W.BYTE\[3\].B.Q_WIRE\[5\]
+ sky130_fd_sc_hd__dlxtp_1
XSLICE_16\[1\].RAM16.SLICE\[0\].RAM8.WORD\[2\].W.BYTE\[3\].B.CGAND SLICE_16\[1\].RAM16.SLICE\[0\].RAM8.WORD\[2\].W.BYTE\[0\].B.SEL0
+ SLICE_16\[1\].RAM16.SLICE\[0\].RAM8.WE0_buf\[3\] VGND VGND VPWR VPWR SLICE_16\[1\].RAM16.SLICE\[0\].RAM8.WORD\[2\].W.BYTE\[3\].B.WE0_WIRE
+ sky130_fd_sc_hd__and2_1
Xtap_13_28 VGND VPWR sky130_fd_sc_hd__tapvpwrvgnd_1
Xtap_13_17 VGND VPWR sky130_fd_sc_hd__tapvpwrvgnd_1
XSLICE_16\[0\].RAM16.SLICE\[1\].RAM8.WORD\[5\].W.BYTE\[1\].B.BIT\[4\].genblk1.STORAGE
+ DIBUF\[12\].X SLICE_16\[0\].RAM16.SLICE\[1\].RAM8.WORD\[5\].W.BYTE\[1\].B.GCLK VGND
+ VGND VPWR VPWR SLICE_16\[0\].RAM16.SLICE\[1\].RAM8.WORD\[5\].W.BYTE\[1\].B.Q_WIRE\[4\]
+ sky130_fd_sc_hd__dlxtp_1
XSLICE_16\[0\].RAM16.SLICE\[0\].RAM8.WORD\[6\].W.BYTE\[3\].B.BIT\[0\].genblk1.STORAGE
+ DIBUF\[24\].X SLICE_16\[0\].RAM16.SLICE\[0\].RAM8.WORD\[6\].W.BYTE\[3\].B.GCLK VGND
+ VGND VPWR VPWR SLICE_16\[0\].RAM16.SLICE\[0\].RAM8.WORD\[6\].W.BYTE\[3\].B.Q_WIRE\[0\]
+ sky130_fd_sc_hd__dlxtp_1
Xfill_7_2 VGND VPWR sky130_fd_sc_hd__tapvpwrvgnd_1
XSLICE_16\[1\].RAM16.SLICE\[1\].RAM8.WORD\[6\].W.BYTE\[2\].B.genblk1.CLKINV SLICE_16\[1\].RAM16.SLICE\[1\].RAM8.WORD\[6\].W.BYTE\[0\].B.CLK
+ VGND VGND VPWR VPWR SLICE_16\[1\].RAM16.SLICE\[1\].RAM8.WORD\[6\].W.BYTE\[2\].B.CLK_B
+ sky130_fd_sc_hd__inv_1
XSLICE_16\[1\].RAM16.SLICE\[1\].RAM8.WORD\[1\].W.BYTE\[2\].B.BIT\[0\].OBUF0 SLICE_16\[1\].RAM16.SLICE\[1\].RAM8.WORD\[1\].W.BYTE\[2\].B.Q_WIRE\[0\]
+ SLICE_16\[1\].RAM16.SLICE\[1\].RAM8.WORD\[1\].W.BYTE\[2\].B.SEL0_B VGND VGND VPWR
+ VPWR SLICE_16\[1\].RAM16.BYTE\[2\].FLOATBUF0\[16\].Z sky130_fd_sc_hd__ebufn_2
XSLICE_16\[0\].RAM16.SLICE\[1\].RAM8.WORD\[3\].W.BYTE\[1\].B.DIODE_CLK SLICE_16\[0\].RAM16.SLICE\[1\].RAM8.WORD\[3\].W.BYTE\[0\].B.CLK
+ VGND VGND VPWR VPWR sky130_fd_sc_hd__diode_2
XSLICE_16\[0\].RAM16.SLICE\[0\].RAM8.DEC0.AND7 SLICE_16\[0\].RAM16.SLICE\[0\].RAM8.DEC0.A_buf\[0\]
+ SLICE_16\[0\].RAM16.SLICE\[0\].RAM8.DEC0.A_buf\[1\] SLICE_16\[0\].RAM16.SLICE\[0\].RAM8.DEC0.A_buf\[2\]
+ SLICE_16\[0\].RAM16.SLICE\[0\].RAM8.DEC0.EN_buf VGND VGND VPWR VPWR SLICE_16\[0\].RAM16.SLICE\[0\].RAM8.DEC0.SEL\[7\]
+ sky130_fd_sc_hd__and4_2
Xtap_38_25 VGND VPWR sky130_fd_sc_hd__tapvpwrvgnd_1
Xtap_38_14 VGND VPWR sky130_fd_sc_hd__tapvpwrvgnd_1
Xtap_31_7 VGND VPWR sky130_fd_sc_hd__tapvpwrvgnd_1
Xtap_24_6 VGND VPWR sky130_fd_sc_hd__tapvpwrvgnd_1
Xtap_17_5 VGND VPWR sky130_fd_sc_hd__tapvpwrvgnd_1
XSLICE_16\[0\].RAM16.SLICE\[0\].RAM8.WORD\[6\].W.SEL0BUF SLICE_16\[0\].RAM16.SLICE\[0\].RAM8.DEC0.SEL\[6\]
+ VGND VGND VPWR VPWR SLICE_16\[0\].RAM16.SLICE\[0\].RAM8.WORD\[6\].W.BYTE\[0\].B.SEL0
+ sky130_fd_sc_hd__clkbuf_2
XSLICE_16\[0\].RAM16.SLICE\[1\].RAM8.WORD\[3\].W.BYTE\[1\].B.BIT\[1\].OBUF0 SLICE_16\[0\].RAM16.SLICE\[1\].RAM8.WORD\[3\].W.BYTE\[1\].B.Q_WIRE\[1\]
+ SLICE_16\[0\].RAM16.SLICE\[1\].RAM8.WORD\[3\].W.BYTE\[1\].B.SEL0_B VGND VGND VPWR
+ VPWR SLICE_16\[0\].RAM16.BYTE\[1\].FLOATBUF0\[9\].Z sky130_fd_sc_hd__ebufn_2
Xtap_0_31 VGND VPWR sky130_fd_sc_hd__tapvpwrvgnd_1
Xtap_0_20 VGND VPWR sky130_fd_sc_hd__tapvpwrvgnd_1
XDo0MUX.M\[0\].DIODE_A0MUX\[2\] Do0MUX.A0\[2\] VGND VGND VPWR VPWR sky130_fd_sc_hd__diode_2
Xfill_42_78 VGND VPWR sky130_fd_sc_hd__tapvpwrvgnd_1
Xfill_42_67 VGND VGND VPWR VPWR sky130_fd_sc_hd__decap_12
Xfill_42_56 VGND VGND VPWR VPWR sky130_fd_sc_hd__decap_12
Xfill_42_45 VGND VPWR sky130_fd_sc_hd__tapvpwrvgnd_1
Xfill_42_34 VGND VGND VPWR VPWR sky130_fd_sc_hd__decap_12
Xfill_42_23 VGND VGND VPWR VPWR sky130_fd_sc_hd__decap_12
Xfill_42_12 VGND VPWR sky130_fd_sc_hd__tapvpwrvgnd_1
Xfill_42_89 VGND VGND VPWR VPWR sky130_fd_sc_hd__decap_12
Xfill_45_9 VGND VPWR sky130_fd_sc_hd__tapvpwrvgnd_1
Xfill_38_8 VGND VPWR sky130_fd_sc_hd__tapvpwrvgnd_1
XSLICE_16\[0\].RAM16.BYTE\[0\].FLOATBUF0\[5\].__cell__ SLICE_16\[0\].RAM16.BYTE\[0\].FLOATBUF0\[0\].A
+ SLICE_16\[0\].RAM16.BYTE\[0\].FLOATBUF0\[0\].TE_B VGND VGND VPWR VPWR SLICE_16\[0\].RAM16.BYTE\[0\].FLOATBUF0\[5\].Z
+ sky130_fd_sc_hd__ebufn_2
XSLICE_16\[0\].RAM16.SLICE\[0\].RAM8.WORD\[2\].W.BYTE\[3\].B.BIT\[3\].OBUF0 SLICE_16\[0\].RAM16.SLICE\[0\].RAM8.WORD\[2\].W.BYTE\[3\].B.Q_WIRE\[3\]
+ SLICE_16\[0\].RAM16.SLICE\[0\].RAM8.WORD\[2\].W.BYTE\[3\].B.SEL0_B VGND VGND VPWR
+ VPWR SLICE_16\[0\].RAM16.BYTE\[3\].FLOATBUF0\[27\].Z sky130_fd_sc_hd__ebufn_2
XSLICE_16\[0\].RAM16.SLICE\[0\].RAM8.WORD\[3\].W.BYTE\[0\].B.genblk1.CLKINV SLICE_16\[0\].RAM16.SLICE\[0\].RAM8.WORD\[3\].W.BYTE\[0\].B.CLK
+ VGND VGND VPWR VPWR SLICE_16\[0\].RAM16.SLICE\[0\].RAM8.WORD\[3\].W.BYTE\[0\].B.CLK_B
+ sky130_fd_sc_hd__inv_1
XSLICE_16\[1\].RAM16.SLICE\[1\].RAM8.WORD\[4\].W.BYTE\[3\].B.BIT\[0\].OBUF0 SLICE_16\[1\].RAM16.SLICE\[1\].RAM8.WORD\[4\].W.BYTE\[3\].B.Q_WIRE\[0\]
+ SLICE_16\[1\].RAM16.SLICE\[1\].RAM8.WORD\[4\].W.BYTE\[3\].B.SEL0_B VGND VGND VPWR
+ VPWR SLICE_16\[1\].RAM16.BYTE\[3\].FLOATBUF0\[24\].Z sky130_fd_sc_hd__ebufn_2
Xfill_0_9 VGND VPWR sky130_fd_sc_hd__tapvpwrvgnd_1
XSLICE_16\[1\].RAM16.SLICE\[1\].RAM8.WORD\[1\].W.BYTE\[2\].B.SEL0INV SLICE_16\[1\].RAM16.SLICE\[1\].RAM8.WORD\[1\].W.BYTE\[0\].B.SEL0
+ VGND VGND VPWR VPWR SLICE_16\[1\].RAM16.SLICE\[1\].RAM8.WORD\[1\].W.BYTE\[2\].B.SEL0_B
+ sky130_fd_sc_hd__inv_1
XSLICE_16\[0\].RAM16.SLICE\[1\].RAM8.WORD\[7\].W.BYTE\[0\].B.SEL0INV SLICE_16\[0\].RAM16.SLICE\[1\].RAM8.WORD\[7\].W.BYTE\[0\].B.SEL0
+ VGND VGND VPWR VPWR SLICE_16\[0\].RAM16.SLICE\[1\].RAM8.WORD\[7\].W.BYTE\[0\].B.SEL0_B
+ sky130_fd_sc_hd__inv_1
XSLICE_16\[1\].RAM16.SLICE\[1\].RAM8.WORD\[1\].W.BYTE\[0\].B.BIT\[5\].OBUF0 SLICE_16\[1\].RAM16.SLICE\[1\].RAM8.WORD\[1\].W.BYTE\[0\].B.Q_WIRE\[5\]
+ SLICE_16\[1\].RAM16.SLICE\[1\].RAM8.WORD\[1\].W.BYTE\[0\].B.SEL0_B VGND VGND VPWR
+ VPWR SLICE_16\[1\].RAM16.BYTE\[0\].FLOATBUF0\[5\].Z sky130_fd_sc_hd__ebufn_2
Xtap_24_27 VGND VPWR sky130_fd_sc_hd__tapvpwrvgnd_1
Xtap_24_16 VGND VPWR sky130_fd_sc_hd__tapvpwrvgnd_1
XSLICE_16\[0\].RAM16.SLICE\[1\].RAM8.WORD\[6\].W.BYTE\[2\].B.BIT\[1\].OBUF0 SLICE_16\[0\].RAM16.SLICE\[1\].RAM8.WORD\[6\].W.BYTE\[2\].B.Q_WIRE\[1\]
+ SLICE_16\[0\].RAM16.SLICE\[1\].RAM8.WORD\[6\].W.BYTE\[2\].B.SEL0_B VGND VGND VPWR
+ VPWR SLICE_16\[0\].RAM16.BYTE\[2\].FLOATBUF0\[17\].Z sky130_fd_sc_hd__ebufn_2
Xtap_40_26 VGND VPWR sky130_fd_sc_hd__tapvpwrvgnd_1
Xtap_40_15 VGND VPWR sky130_fd_sc_hd__tapvpwrvgnd_1
XSLICE_16\[1\].RAM16.SLICE\[1\].RAM8.WORD\[5\].W.BYTE\[0\].B.BIT\[7\].genblk1.STORAGE
+ DIBUF\[7\].X SLICE_16\[1\].RAM16.SLICE\[1\].RAM8.WORD\[5\].W.BYTE\[0\].B.GCLK VGND
+ VGND VPWR VPWR SLICE_16\[1\].RAM16.SLICE\[1\].RAM8.WORD\[5\].W.BYTE\[0\].B.Q_WIRE\[7\]
+ sky130_fd_sc_hd__dlxtp_1
XSLICE_16\[1\].RAM16.SLICE\[1\].RAM8.WORD\[3\].W.BYTE\[2\].B.CGAND SLICE_16\[1\].RAM16.SLICE\[1\].RAM8.WORD\[3\].W.BYTE\[0\].B.SEL0
+ SLICE_16\[1\].RAM16.SLICE\[1\].RAM8.WE0_buf\[2\] VGND VGND VPWR VPWR SLICE_16\[1\].RAM16.SLICE\[1\].RAM8.WORD\[3\].W.BYTE\[2\].B.WE0_WIRE
+ sky130_fd_sc_hd__and2_1
XSLICE_16\[1\].RAM16.SLICE\[0\].RAM8.WORD\[6\].W.BYTE\[2\].B.genblk1.CG SLICE_16\[1\].RAM16.SLICE\[0\].RAM8.WORD\[6\].W.BYTE\[2\].B.CLK_B
+ SLICE_16\[1\].RAM16.SLICE\[0\].RAM8.WORD\[6\].W.BYTE\[2\].B.WE0_WIRE VGND VGND VPWR
+ VPWR SLICE_16\[1\].RAM16.SLICE\[0\].RAM8.WORD\[6\].W.BYTE\[2\].B.GCLK sky130_fd_sc_hd__dlclkp_1
XSLICE_16\[1\].RAM16.SLICE\[0\].RAM8.WORD\[6\].W.BYTE\[2\].B.BIT\[3\].genblk1.STORAGE
+ DIBUF\[19\].X SLICE_16\[1\].RAM16.SLICE\[0\].RAM8.WORD\[6\].W.BYTE\[2\].B.GCLK VGND
+ VGND VPWR VPWR SLICE_16\[1\].RAM16.SLICE\[0\].RAM8.WORD\[6\].W.BYTE\[2\].B.Q_WIRE\[3\]
+ sky130_fd_sc_hd__dlxtp_1
XSLICE_16\[1\].RAM16.SLICE\[0\].RAM8.WORD\[0\].W.BYTE\[3\].B.BIT\[4\].genblk1.STORAGE
+ DIBUF\[28\].X SLICE_16\[1\].RAM16.SLICE\[0\].RAM8.WORD\[0\].W.BYTE\[3\].B.GCLK VGND
+ VGND VPWR VPWR SLICE_16\[1\].RAM16.SLICE\[0\].RAM8.WORD\[0\].W.BYTE\[3\].B.Q_WIRE\[4\]
+ sky130_fd_sc_hd__dlxtp_1
XSLICE_16\[0\].RAM16.SLICE\[0\].RAM8.WORD\[1\].W.BYTE\[1\].B.BIT\[0\].OBUF0 SLICE_16\[0\].RAM16.SLICE\[0\].RAM8.WORD\[1\].W.BYTE\[1\].B.Q_WIRE\[0\]
+ SLICE_16\[0\].RAM16.SLICE\[0\].RAM8.WORD\[1\].W.BYTE\[1\].B.SEL0_B VGND VGND VPWR
+ VPWR SLICE_16\[0\].RAM16.BYTE\[1\].FLOATBUF0\[8\].Z sky130_fd_sc_hd__ebufn_2
XSLICE_16\[1\].RAM16.SLICE\[0\].RAM8.WORD\[4\].W.BYTE\[0\].B.BIT\[2\].genblk1.STORAGE
+ DIBUF\[2\].X SLICE_16\[1\].RAM16.SLICE\[0\].RAM8.WORD\[4\].W.BYTE\[0\].B.GCLK VGND
+ VGND VPWR VPWR SLICE_16\[1\].RAM16.SLICE\[0\].RAM8.WORD\[4\].W.BYTE\[0\].B.Q_WIRE\[2\]
+ sky130_fd_sc_hd__dlxtp_1
XSLICE_16\[1\].RAM16.SLICE\[0\].RAM8.WORD\[0\].W.BYTE\[2\].B.BIT\[7\].OBUF0 SLICE_16\[1\].RAM16.SLICE\[0\].RAM8.WORD\[0\].W.BYTE\[2\].B.Q_WIRE\[7\]
+ SLICE_16\[1\].RAM16.SLICE\[0\].RAM8.WORD\[0\].W.BYTE\[2\].B.SEL0_B VGND VGND VPWR
+ VPWR SLICE_16\[1\].RAM16.BYTE\[2\].FLOATBUF0\[23\].Z sky130_fd_sc_hd__ebufn_2
Xtap_15_2 VGND VPWR sky130_fd_sc_hd__tapvpwrvgnd_1
XSLICE_16\[0\].RAM16.SLICE\[0\].RAM8.WORD\[3\].W.CLKBUF SLICE_16\[0\].RAM16.SLICE\[0\].RAM8.CLKBUF.X
+ VGND VGND VPWR VPWR SLICE_16\[0\].RAM16.SLICE\[0\].RAM8.WORD\[3\].W.BYTE\[0\].B.CLK
+ sky130_fd_sc_hd__clkbuf_4
XSLICE_16\[0\].RAM16.SLICE\[0\].RAM8.WORD\[6\].W.BYTE\[1\].B.genblk1.CLKINV SLICE_16\[0\].RAM16.SLICE\[0\].RAM8.WORD\[6\].W.BYTE\[0\].B.CLK
+ VGND VGND VPWR VPWR SLICE_16\[0\].RAM16.SLICE\[0\].RAM8.WORD\[6\].W.BYTE\[1\].B.CLK_B
+ sky130_fd_sc_hd__inv_1
XSLICE_16\[0\].RAM16.SLICE\[1\].RAM8.WORD\[2\].W.BYTE\[3\].B.BIT\[5\].genblk1.STORAGE
+ DIBUF\[29\].X SLICE_16\[0\].RAM16.SLICE\[1\].RAM8.WORD\[2\].W.BYTE\[3\].B.GCLK VGND
+ VGND VPWR VPWR SLICE_16\[0\].RAM16.SLICE\[1\].RAM8.WORD\[2\].W.BYTE\[3\].B.Q_WIRE\[5\]
+ sky130_fd_sc_hd__dlxtp_1
XSLICE_16\[0\].RAM16.SLICE\[1\].RAM8.WORD\[6\].W.BYTE\[0\].B.BIT\[3\].genblk1.STORAGE
+ DIBUF\[3\].X SLICE_16\[0\].RAM16.SLICE\[1\].RAM8.WORD\[6\].W.BYTE\[0\].B.GCLK VGND
+ VGND VPWR VPWR SLICE_16\[0\].RAM16.SLICE\[1\].RAM8.WORD\[6\].W.BYTE\[0\].B.Q_WIRE\[3\]
+ sky130_fd_sc_hd__dlxtp_1
XSLICE_16\[0\].RAM16.SLICE\[0\].RAM8.WORD\[1\].W.BYTE\[3\].B.BIT\[0\].genblk1.STORAGE
+ DIBUF\[24\].X SLICE_16\[0\].RAM16.SLICE\[0\].RAM8.WORD\[1\].W.BYTE\[3\].B.GCLK VGND
+ VGND VPWR VPWR SLICE_16\[0\].RAM16.SLICE\[0\].RAM8.WORD\[1\].W.BYTE\[3\].B.Q_WIRE\[0\]
+ sky130_fd_sc_hd__dlxtp_1
Xfill_0_17 VGND VGND VPWR VPWR sky130_fd_sc_hd__decap_12
Xtap_8_1 VGND VPWR sky130_fd_sc_hd__tapvpwrvgnd_1
XSLICE_16\[0\].RAM16.SLICE\[1\].RAM8.WORD\[0\].W.BYTE\[1\].B.BIT\[4\].genblk1.STORAGE
+ DIBUF\[12\].X SLICE_16\[0\].RAM16.SLICE\[1\].RAM8.WORD\[0\].W.BYTE\[1\].B.GCLK VGND
+ VGND VPWR VPWR SLICE_16\[0\].RAM16.SLICE\[1\].RAM8.WORD\[0\].W.BYTE\[1\].B.Q_WIRE\[4\]
+ sky130_fd_sc_hd__dlxtp_1
Xfill_43_6 VGND VPWR sky130_fd_sc_hd__tapvpwrvgnd_1
Xfill_36_5 VGND VPWR sky130_fd_sc_hd__tapvpwrvgnd_1
XSLICE_16\[1\].RAM16.SLICE\[1\].RAM8.WORD\[4\].W.BYTE\[1\].B.BIT\[5\].OBUF0 SLICE_16\[1\].RAM16.SLICE\[1\].RAM8.WORD\[4\].W.BYTE\[1\].B.Q_WIRE\[5\]
+ SLICE_16\[1\].RAM16.SLICE\[1\].RAM8.WORD\[4\].W.BYTE\[1\].B.SEL0_B VGND VGND VPWR
+ VPWR SLICE_16\[1\].RAM16.BYTE\[1\].FLOATBUF0\[13\].Z sky130_fd_sc_hd__ebufn_2
Xfill_29_4 VGND VPWR sky130_fd_sc_hd__tapvpwrvgnd_1
Xfill_46_135 VGND VPWR sky130_fd_sc_hd__tapvpwrvgnd_1
Xfill_46_124 VGND VGND VPWR VPWR sky130_fd_sc_hd__decap_12
Xfill_46_113 VGND VGND VPWR VPWR sky130_fd_sc_hd__decap_12
Xfill_46_102 VGND VPWR sky130_fd_sc_hd__tapvpwrvgnd_1
XSLICE_16\[0\].RAM16.SLICE\[1\].RAM8.WORD\[6\].W.BYTE\[0\].B.BIT\[6\].OBUF0 SLICE_16\[0\].RAM16.SLICE\[1\].RAM8.WORD\[6\].W.BYTE\[0\].B.Q_WIRE\[6\]
+ SLICE_16\[0\].RAM16.SLICE\[1\].RAM8.WORD\[6\].W.BYTE\[0\].B.SEL0_B VGND VGND VPWR
+ VPWR SLICE_16\[0\].RAM16.BYTE\[0\].FLOATBUF0\[6\].Z sky130_fd_sc_hd__ebufn_2
XSLICE_16\[0\].RAM16.SLICE\[0\].RAM8.WORD\[4\].W.BYTE\[2\].B.BIT\[0\].OBUF0 SLICE_16\[0\].RAM16.SLICE\[0\].RAM8.WORD\[4\].W.BYTE\[2\].B.Q_WIRE\[0\]
+ SLICE_16\[0\].RAM16.SLICE\[0\].RAM8.WORD\[4\].W.BYTE\[2\].B.SEL0_B VGND VGND VPWR
+ VPWR SLICE_16\[0\].RAM16.BYTE\[2\].FLOATBUF0\[16\].Z sky130_fd_sc_hd__ebufn_2
Xtap_10_18 VGND VPWR sky130_fd_sc_hd__tapvpwrvgnd_1
Xtap_10_29 VGND VPWR sky130_fd_sc_hd__tapvpwrvgnd_1
Xtap_35_26 VGND VPWR sky130_fd_sc_hd__tapvpwrvgnd_1
Xtap_35_15 VGND VPWR sky130_fd_sc_hd__tapvpwrvgnd_1
XSLICE_16\[1\].RAM16.SLICE\[0\].RAM8.WORD\[3\].W.BYTE\[3\].B.BIT\[7\].OBUF0 SLICE_16\[1\].RAM16.SLICE\[0\].RAM8.WORD\[3\].W.BYTE\[3\].B.Q_WIRE\[7\]
+ SLICE_16\[1\].RAM16.SLICE\[0\].RAM8.WORD\[3\].W.BYTE\[3\].B.SEL0_B VGND VGND VPWR
+ VPWR SLICE_16\[1\].RAM16.BYTE\[3\].FLOATBUF0\[31\].Z sky130_fd_sc_hd__ebufn_2
Xtap_1_8 VGND VPWR sky130_fd_sc_hd__tapvpwrvgnd_1
Xtap_6_30 VGND VPWR sky130_fd_sc_hd__tapvpwrvgnd_1
XSLICE_16\[1\].RAM16.BYTE\[1\].FLOATBUF0\[15\].__cell__ SLICE_16\[1\].RAM16.BYTE\[1\].FLOATBUF0\[10\].A
+ SLICE_16\[1\].RAM16.BYTE\[1\].FLOATBUF0\[10\].TE_B VGND VGND VPWR VPWR SLICE_16\[1\].RAM16.BYTE\[1\].FLOATBUF0\[15\].Z
+ sky130_fd_sc_hd__ebufn_2
XSLICE_16\[1\].RAM16.SLICE\[1\].RAM8.WORD\[7\].W.BYTE\[2\].B.BIT\[5\].OBUF0 SLICE_16\[1\].RAM16.SLICE\[1\].RAM8.WORD\[7\].W.BYTE\[2\].B.Q_WIRE\[5\]
+ SLICE_16\[1\].RAM16.SLICE\[1\].RAM8.WORD\[7\].W.BYTE\[2\].B.SEL0_B VGND VGND VPWR
+ VPWR SLICE_16\[1\].RAM16.BYTE\[2\].FLOATBUF0\[21\].Z sky130_fd_sc_hd__ebufn_2
XSLICE_16\[1\].RAM16.Do0_REG.OUTREG_BYTE\[3\].DIODE\[3\] SLICE_16\[1\].RAM16.BYTE\[3\].FLOATBUF0\[27\].Z
+ VGND VGND VPWR VPWR sky130_fd_sc_hd__diode_2
XSLICE_16\[1\].RAM16.SLICE\[1\].RAM8.WORD\[0\].W.BYTE\[0\].B.BIT\[7\].genblk1.STORAGE
+ DIBUF\[7\].X SLICE_16\[1\].RAM16.SLICE\[1\].RAM8.WORD\[0\].W.BYTE\[0\].B.GCLK VGND
+ VGND VPWR VPWR SLICE_16\[1\].RAM16.SLICE\[1\].RAM8.WORD\[0\].W.BYTE\[0\].B.Q_WIRE\[7\]
+ sky130_fd_sc_hd__dlxtp_1
XSLICE_16\[1\].RAM16.SLICE\[0\].RAM8.WORD\[7\].W.BYTE\[1\].B.BIT\[2\].genblk1.STORAGE
+ DIBUF\[10\].X SLICE_16\[1\].RAM16.SLICE\[0\].RAM8.WORD\[7\].W.BYTE\[1\].B.GCLK VGND
+ VGND VPWR VPWR SLICE_16\[1\].RAM16.SLICE\[0\].RAM8.WORD\[7\].W.BYTE\[1\].B.Q_WIRE\[2\]
+ sky130_fd_sc_hd__dlxtp_1
XSLICE_16\[0\].RAM16.SLICE\[1\].RAM8.WORD\[0\].W.BYTE\[0\].B.genblk1.CLKINV SLICE_16\[0\].RAM16.SLICE\[1\].RAM8.WORD\[0\].W.BYTE\[0\].B.CLK
+ VGND VGND VPWR VPWR SLICE_16\[0\].RAM16.SLICE\[1\].RAM8.WORD\[0\].W.BYTE\[0\].B.CLK_B
+ sky130_fd_sc_hd__inv_1
XSLICE_16\[1\].RAM16.SLICE\[0\].RAM8.WORD\[2\].W.BYTE\[1\].B.BIT\[4\].OBUF0 SLICE_16\[1\].RAM16.SLICE\[0\].RAM8.WORD\[2\].W.BYTE\[1\].B.Q_WIRE\[4\]
+ SLICE_16\[1\].RAM16.SLICE\[0\].RAM8.WORD\[2\].W.BYTE\[1\].B.SEL0_B VGND VGND VPWR
+ VPWR SLICE_16\[1\].RAM16.BYTE\[1\].FLOATBUF0\[12\].Z sky130_fd_sc_hd__ebufn_2
XSLICE_16\[1\].RAM16.SLICE\[0\].RAM8.WORD\[1\].W.BYTE\[2\].B.BIT\[3\].genblk1.STORAGE
+ DIBUF\[19\].X SLICE_16\[1\].RAM16.SLICE\[0\].RAM8.WORD\[1\].W.BYTE\[2\].B.GCLK VGND
+ VGND VPWR VPWR SLICE_16\[1\].RAM16.SLICE\[0\].RAM8.WORD\[1\].W.BYTE\[2\].B.Q_WIRE\[3\]
+ sky130_fd_sc_hd__dlxtp_1
XSLICE_16\[0\].RAM16.SLICE\[1\].RAM8.WORD\[3\].W.BYTE\[2\].B.BIT\[4\].genblk1.STORAGE
+ DIBUF\[20\].X SLICE_16\[0\].RAM16.SLICE\[1\].RAM8.WORD\[3\].W.BYTE\[2\].B.GCLK VGND
+ VGND VPWR VPWR SLICE_16\[0\].RAM16.SLICE\[1\].RAM8.WORD\[3\].W.BYTE\[2\].B.Q_WIRE\[4\]
+ sky130_fd_sc_hd__dlxtp_1
XSLICE_16\[0\].RAM16.SLICE\[0\].RAM8.WORD\[7\].W.BYTE\[3\].B.BIT\[0\].OBUF0 SLICE_16\[0\].RAM16.SLICE\[0\].RAM8.WORD\[7\].W.BYTE\[3\].B.Q_WIRE\[0\]
+ SLICE_16\[0\].RAM16.SLICE\[0\].RAM8.WORD\[7\].W.BYTE\[3\].B.SEL0_B VGND VGND VPWR
+ VPWR SLICE_16\[0\].RAM16.BYTE\[3\].FLOATBUF0\[24\].Z sky130_fd_sc_hd__ebufn_2
Xfill_41_3 VGND VPWR sky130_fd_sc_hd__tapvpwrvgnd_1
XSLICE_16\[0\].RAM16.SLICE\[1\].RAM8.WORD\[1\].W.BYTE\[0\].B.BIT\[3\].genblk1.STORAGE
+ DIBUF\[3\].X SLICE_16\[0\].RAM16.SLICE\[1\].RAM8.WORD\[1\].W.BYTE\[0\].B.GCLK VGND
+ VGND VPWR VPWR SLICE_16\[0\].RAM16.SLICE\[1\].RAM8.WORD\[1\].W.BYTE\[0\].B.Q_WIRE\[3\]
+ sky130_fd_sc_hd__dlxtp_1
Xfill_34_2 VGND VGND VPWR VPWR sky130_fd_sc_hd__fill_2
Xfill_27_1 VGND VGND VPWR VPWR sky130_fd_sc_hd__decap_4
Xfill_19_102 VGND VGND VPWR VPWR sky130_fd_sc_hd__decap_3
XSLICE_16\[0\].RAM16.SLICE\[0\].RAM8.WORD\[4\].W.BYTE\[0\].B.BIT\[5\].OBUF0 SLICE_16\[0\].RAM16.SLICE\[0\].RAM8.WORD\[4\].W.BYTE\[0\].B.Q_WIRE\[5\]
+ SLICE_16\[0\].RAM16.SLICE\[0\].RAM8.WORD\[4\].W.BYTE\[0\].B.SEL0_B VGND VGND VPWR
+ VPWR SLICE_16\[0\].RAM16.BYTE\[0\].FLOATBUF0\[5\].Z sky130_fd_sc_hd__ebufn_2
XSLICE_16\[1\].RAM16.SLICE\[1\].RAM8.WORD\[6\].W.BYTE\[0\].B.BIT\[2\].OBUF0 SLICE_16\[1\].RAM16.SLICE\[1\].RAM8.WORD\[6\].W.BYTE\[0\].B.Q_WIRE\[2\]
+ SLICE_16\[1\].RAM16.SLICE\[1\].RAM8.WORD\[6\].W.BYTE\[0\].B.SEL0_B VGND VGND VPWR
+ VPWR SLICE_16\[1\].RAM16.BYTE\[0\].FLOATBUF0\[2\].Z sky130_fd_sc_hd__ebufn_2
XSLICE_16\[1\].RAM16.SLICE\[1\].RAM8.WORD\[5\].W.BYTE\[0\].B.SEL0INV SLICE_16\[1\].RAM16.SLICE\[1\].RAM8.WORD\[5\].W.BYTE\[0\].B.SEL0
+ VGND VGND VPWR VPWR SLICE_16\[1\].RAM16.SLICE\[1\].RAM8.WORD\[5\].W.BYTE\[0\].B.SEL0_B
+ sky130_fd_sc_hd__inv_1
Xfill_18_25 VGND VPWR sky130_fd_sc_hd__tapvpwrvgnd_1
Xfill_18_14 VGND VGND VPWR VPWR sky130_fd_sc_hd__decap_12
XSLICE_16\[0\].RAM16.BYTE\[3\].FLOATBUF0\[29\].__cell__ SLICE_16\[0\].RAM16.BYTE\[3\].FLOATBUF0\[24\].A
+ SLICE_16\[0\].RAM16.BYTE\[3\].FLOATBUF0\[24\].TE_B VGND VGND VPWR VPWR SLICE_16\[0\].RAM16.BYTE\[3\].FLOATBUF0\[29\].Z
+ sky130_fd_sc_hd__ebufn_2
XSLICE_16\[1\].RAM16.SLICE\[0\].RAM8.WORD\[5\].W.BYTE\[2\].B.BIT\[4\].OBUF0 SLICE_16\[1\].RAM16.SLICE\[0\].RAM8.WORD\[5\].W.BYTE\[2\].B.Q_WIRE\[4\]
+ SLICE_16\[1\].RAM16.SLICE\[0\].RAM8.WORD\[5\].W.BYTE\[2\].B.SEL0_B VGND VGND VPWR
+ VPWR SLICE_16\[1\].RAM16.BYTE\[2\].FLOATBUF0\[20\].Z sky130_fd_sc_hd__ebufn_2
XSLICE_16\[0\].RAM16.SLICE\[1\].RAM8.WORD\[3\].W.BYTE\[1\].B.genblk1.CLKINV SLICE_16\[0\].RAM16.SLICE\[1\].RAM8.WORD\[3\].W.BYTE\[0\].B.CLK
+ VGND VGND VPWR VPWR SLICE_16\[0\].RAM16.SLICE\[1\].RAM8.WORD\[3\].W.BYTE\[1\].B.CLK_B
+ sky130_fd_sc_hd__inv_1
XSLICE_16\[1\].RAM16.SLICE\[0\].RAM8.WORD\[7\].W.SEL0BUF SLICE_16\[1\].RAM16.SLICE\[0\].RAM8.DEC0.SEL\[7\]
+ VGND VGND VPWR VPWR SLICE_16\[1\].RAM16.SLICE\[0\].RAM8.WORD\[7\].W.BYTE\[0\].B.SEL0
+ sky130_fd_sc_hd__clkbuf_2
XSLICE_16\[1\].RAM16.Do0_REG.OUTREG_BYTE\[2\].Do_FF\[4\] SLICE_16\[1\].RAM16.Do0_REG.CLKBUF\[2\]
+ SLICE_16\[1\].RAM16.BYTE\[2\].FLOATBUF0\[20\].Z VGND VGND VPWR VPWR Do0MUX.A1\[20\]
+ sky130_fd_sc_hd__dfxtp_1
Xfill_20_8 VGND VGND VPWR VPWR sky130_fd_sc_hd__decap_12
XSLICE_16\[0\].RAM16.SLICE\[1\].RAM8.WORD\[3\].W.BYTE\[1\].B.SEL0INV SLICE_16\[0\].RAM16.SLICE\[1\].RAM8.WORD\[3\].W.BYTE\[0\].B.SEL0
+ VGND VGND VPWR VPWR SLICE_16\[0\].RAM16.SLICE\[1\].RAM8.WORD\[3\].W.BYTE\[1\].B.SEL0_B
+ sky130_fd_sc_hd__inv_1
XSLICE_16\[0\].RAM16.SLICE\[0\].RAM8.WORD\[7\].W.BYTE\[1\].B.BIT\[5\].OBUF0 SLICE_16\[0\].RAM16.SLICE\[0\].RAM8.WORD\[7\].W.BYTE\[1\].B.Q_WIRE\[5\]
+ SLICE_16\[0\].RAM16.SLICE\[0\].RAM8.WORD\[7\].W.BYTE\[1\].B.SEL0_B VGND VGND VPWR
+ VPWR SLICE_16\[0\].RAM16.BYTE\[1\].FLOATBUF0\[13\].Z sky130_fd_sc_hd__ebufn_2
XSLICE_16\[1\].RAM16.CLKBUF.__cell__ CLK VGND VGND VPWR VPWR SLICE_16\[1\].RAM16.CLKBUF.X
+ sky130_fd_sc_hd__clkbuf_4
XSLICE_16\[1\].RAM16.SLICE\[1\].RAM8.WORD\[3\].W.BYTE\[1\].B.BIT\[7\].genblk1.STORAGE
+ DIBUF\[15\].X SLICE_16\[1\].RAM16.SLICE\[1\].RAM8.WORD\[3\].W.BYTE\[1\].B.GCLK VGND
+ VGND VPWR VPWR SLICE_16\[1\].RAM16.SLICE\[1\].RAM8.WORD\[3\].W.BYTE\[1\].B.Q_WIRE\[7\]
+ sky130_fd_sc_hd__dlxtp_1
XSLICE_16\[1\].RAM16.SLICE\[0\].RAM8.WORD\[4\].W.BYTE\[3\].B.BIT\[3\].genblk1.STORAGE
+ DIBUF\[27\].X SLICE_16\[1\].RAM16.SLICE\[0\].RAM8.WORD\[4\].W.BYTE\[3\].B.GCLK VGND
+ VGND VPWR VPWR SLICE_16\[1\].RAM16.SLICE\[0\].RAM8.WORD\[4\].W.BYTE\[3\].B.Q_WIRE\[3\]
+ sky130_fd_sc_hd__dlxtp_1
XSLICE_16\[1\].RAM16.SLICE\[0\].RAM8.WORD\[4\].W.BYTE\[0\].B.BIT\[1\].OBUF0 SLICE_16\[1\].RAM16.SLICE\[0\].RAM8.WORD\[4\].W.BYTE\[0\].B.Q_WIRE\[1\]
+ SLICE_16\[1\].RAM16.SLICE\[0\].RAM8.WORD\[4\].W.BYTE\[0\].B.SEL0_B VGND VGND VPWR
+ VPWR SLICE_16\[1\].RAM16.BYTE\[0\].FLOATBUF0\[1\].Z sky130_fd_sc_hd__ebufn_2
Xtap_16_28 VGND VPWR sky130_fd_sc_hd__tapvpwrvgnd_1
Xtap_16_17 VGND VPWR sky130_fd_sc_hd__tapvpwrvgnd_1
XSLICE_16\[0\].RAM16.SLICE\[1\].RAM8.WORD\[1\].W.BYTE\[2\].B.BIT\[0\].OBUF0 SLICE_16\[0\].RAM16.SLICE\[1\].RAM8.WORD\[1\].W.BYTE\[2\].B.Q_WIRE\[0\]
+ SLICE_16\[0\].RAM16.SLICE\[1\].RAM8.WORD\[1\].W.BYTE\[2\].B.SEL0_B VGND VGND VPWR
+ VPWR SLICE_16\[0\].RAM16.BYTE\[2\].FLOATBUF0\[16\].Z sky130_fd_sc_hd__ebufn_2
Xtap_32_27 VGND VPWR sky130_fd_sc_hd__tapvpwrvgnd_1
Xtap_32_16 VGND VPWR sky130_fd_sc_hd__tapvpwrvgnd_1
XSLICE_16\[1\].RAM16.SLICE\[1\].RAM8.WORD\[0\].W.BYTE\[3\].B.BIT\[7\].OBUF0 SLICE_16\[1\].RAM16.SLICE\[1\].RAM8.WORD\[0\].W.BYTE\[3\].B.Q_WIRE\[7\]
+ SLICE_16\[1\].RAM16.SLICE\[1\].RAM8.WORD\[0\].W.BYTE\[3\].B.SEL0_B VGND VGND VPWR
+ VPWR SLICE_16\[1\].RAM16.BYTE\[3\].FLOATBUF0\[31\].Z sky130_fd_sc_hd__ebufn_2
XSLICE_16\[1\].RAM16.SLICE\[0\].RAM8.DEC0.AND4 SLICE_16\[1\].RAM16.SLICE\[0\].RAM8.DEC0.A_buf\[0\]
+ SLICE_16\[1\].RAM16.SLICE\[0\].RAM8.DEC0.A_buf\[1\] SLICE_16\[1\].RAM16.SLICE\[0\].RAM8.DEC0.A_buf\[2\]
+ SLICE_16\[1\].RAM16.SLICE\[0\].RAM8.DEC0.EN_buf VGND VGND VPWR VPWR SLICE_16\[1\].RAM16.SLICE\[0\].RAM8.DEC0.SEL\[4\]
+ sky130_fd_sc_hd__and4bb_2
XSLICE_16\[1\].RAM16.SLICE\[0\].RAM8.WORD\[2\].W.BYTE\[1\].B.BIT\[2\].genblk1.STORAGE
+ DIBUF\[10\].X SLICE_16\[1\].RAM16.SLICE\[0\].RAM8.WORD\[2\].W.BYTE\[1\].B.GCLK VGND
+ VGND VPWR VPWR SLICE_16\[1\].RAM16.SLICE\[0\].RAM8.WORD\[2\].W.BYTE\[1\].B.Q_WIRE\[2\]
+ sky130_fd_sc_hd__dlxtp_1
XSLICE_16\[0\].RAM16.SLICE\[1\].RAM8.WORD\[6\].W.BYTE\[3\].B.BIT\[4\].genblk1.STORAGE
+ DIBUF\[28\].X SLICE_16\[0\].RAM16.SLICE\[1\].RAM8.WORD\[6\].W.BYTE\[3\].B.GCLK VGND
+ VGND VPWR VPWR SLICE_16\[0\].RAM16.SLICE\[1\].RAM8.WORD\[6\].W.BYTE\[3\].B.Q_WIRE\[4\]
+ sky130_fd_sc_hd__dlxtp_1
XSLICE_16\[0\].RAM16.SLICE\[1\].RAM8.WORD\[6\].W.BYTE\[2\].B.genblk1.CLKINV SLICE_16\[0\].RAM16.SLICE\[1\].RAM8.WORD\[6\].W.BYTE\[0\].B.CLK
+ VGND VGND VPWR VPWR SLICE_16\[0\].RAM16.SLICE\[1\].RAM8.WORD\[6\].W.BYTE\[2\].B.CLK_B
+ sky130_fd_sc_hd__inv_1
Xtap_47_5 VGND VPWR sky130_fd_sc_hd__tapvpwrvgnd_1
Xfill_20_26 VGND VGND VPWR VPWR sky130_fd_sc_hd__decap_12
Xfill_20_15 VGND VPWR sky130_fd_sc_hd__tapvpwrvgnd_1
XSLICE_16\[0\].RAM16.SLICE\[1\].RAM8.WORD\[4\].W.BYTE\[1\].B.BIT\[3\].genblk1.STORAGE
+ DIBUF\[11\].X SLICE_16\[0\].RAM16.SLICE\[1\].RAM8.WORD\[4\].W.BYTE\[1\].B.GCLK VGND
+ VGND VPWR VPWR SLICE_16\[0\].RAM16.SLICE\[1\].RAM8.WORD\[4\].W.BYTE\[1\].B.Q_WIRE\[3\]
+ sky130_fd_sc_hd__dlxtp_1
Xfill_20_59 VGND VGND VPWR VPWR sky130_fd_sc_hd__decap_12
Xfill_20_48 VGND VPWR sky130_fd_sc_hd__tapvpwrvgnd_1
Xfill_20_37 VGND VGND VPWR VPWR sky130_fd_sc_hd__decap_12
Xtap_3_20 VGND VPWR sky130_fd_sc_hd__tapvpwrvgnd_1
Xtap_3_31 VGND VPWR sky130_fd_sc_hd__tapvpwrvgnd_1
Xfill_45_56 VGND VGND VPWR VPWR sky130_fd_sc_hd__decap_12
Xfill_45_45 VGND VPWR sky130_fd_sc_hd__tapvpwrvgnd_1
Xfill_45_34 VGND VGND VPWR VPWR sky130_fd_sc_hd__decap_12
Xfill_45_23 VGND VGND VPWR VPWR sky130_fd_sc_hd__decap_12
Xfill_45_12 VGND VPWR sky130_fd_sc_hd__tapvpwrvgnd_1
XSLICE_16\[0\].RAM16.SLICE\[0\].RAM8.WORD\[5\].W.BYTE\[2\].B.genblk1.CG SLICE_16\[0\].RAM16.SLICE\[0\].RAM8.WORD\[5\].W.BYTE\[2\].B.CLK_B
+ SLICE_16\[0\].RAM16.SLICE\[0\].RAM8.WORD\[5\].W.BYTE\[2\].B.WE0_WIRE VGND VGND VPWR
+ VPWR SLICE_16\[0\].RAM16.SLICE\[0\].RAM8.WORD\[5\].W.BYTE\[2\].B.GCLK sky130_fd_sc_hd__dlclkp_1
Xfill_45_89 VGND VGND VPWR VPWR sky130_fd_sc_hd__decap_12
Xfill_45_78 VGND VPWR sky130_fd_sc_hd__tapvpwrvgnd_1
Xfill_45_67 VGND VGND VPWR VPWR sky130_fd_sc_hd__decap_12
XSLICE_16\[1\].RAM16.SLICE\[0\].RAM8.WORD\[7\].W.BYTE\[1\].B.BIT\[1\].OBUF0 SLICE_16\[1\].RAM16.SLICE\[0\].RAM8.WORD\[7\].W.BYTE\[1\].B.Q_WIRE\[1\]
+ SLICE_16\[1\].RAM16.SLICE\[0\].RAM8.WORD\[7\].W.BYTE\[1\].B.SEL0_B VGND VGND VPWR
+ VPWR SLICE_16\[1\].RAM16.BYTE\[1\].FLOATBUF0\[9\].Z sky130_fd_sc_hd__ebufn_2
XSLICE_16\[0\].RAM16.BYTE\[2\].FLOATBUF0\[20\].__cell__ SLICE_16\[0\].RAM16.BYTE\[2\].FLOATBUF0\[16\].A
+ SLICE_16\[0\].RAM16.BYTE\[2\].FLOATBUF0\[16\].TE_B VGND VGND VPWR VPWR SLICE_16\[0\].RAM16.BYTE\[2\].FLOATBUF0\[20\].Z
+ sky130_fd_sc_hd__ebufn_2
XSLICE_16\[0\].RAM16.SLICE\[1\].RAM8.WORD\[4\].W.BYTE\[3\].B.BIT\[0\].OBUF0 SLICE_16\[0\].RAM16.SLICE\[1\].RAM8.WORD\[4\].W.BYTE\[3\].B.Q_WIRE\[0\]
+ SLICE_16\[0\].RAM16.SLICE\[1\].RAM8.WORD\[4\].W.BYTE\[3\].B.SEL0_B VGND VGND VPWR
+ VPWR SLICE_16\[0\].RAM16.BYTE\[3\].FLOATBUF0\[24\].Z sky130_fd_sc_hd__ebufn_2
XSLICE_16\[0\].RAM16.SLICE\[1\].RAM8.WORD\[1\].W.BYTE\[3\].B.CGAND SLICE_16\[0\].RAM16.SLICE\[1\].RAM8.WORD\[1\].W.BYTE\[0\].B.SEL0
+ SLICE_16\[0\].RAM16.SLICE\[1\].RAM8.WE0_buf\[3\] VGND VGND VPWR VPWR SLICE_16\[0\].RAM16.SLICE\[1\].RAM8.WORD\[1\].W.BYTE\[3\].B.WE0_WIRE
+ sky130_fd_sc_hd__and2_1
Xfill_19_90 VGND VPWR sky130_fd_sc_hd__tapvpwrvgnd_1
Xfill_11_4 VGND VPWR sky130_fd_sc_hd__tapvpwrvgnd_1
XSLICE_16\[0\].RAM16.SLICE\[1\].RAM8.WORD\[1\].W.BYTE\[0\].B.BIT\[5\].OBUF0 SLICE_16\[0\].RAM16.SLICE\[1\].RAM8.WORD\[1\].W.BYTE\[0\].B.Q_WIRE\[5\]
+ SLICE_16\[0\].RAM16.SLICE\[1\].RAM8.WORD\[1\].W.BYTE\[0\].B.SEL0_B VGND VGND VPWR
+ VPWR SLICE_16\[0\].RAM16.BYTE\[0\].FLOATBUF0\[5\].Z sky130_fd_sc_hd__ebufn_2
Xtap_27_27 VGND VPWR sky130_fd_sc_hd__tapvpwrvgnd_1
Xtap_27_16 VGND VPWR sky130_fd_sc_hd__tapvpwrvgnd_1
XSLICE_16\[1\].RAM16.SLICE\[0\].RAM8.WORD\[2\].W.BYTE\[1\].B.genblk1.CG SLICE_16\[1\].RAM16.SLICE\[0\].RAM8.WORD\[2\].W.BYTE\[1\].B.CLK_B
+ SLICE_16\[1\].RAM16.SLICE\[0\].RAM8.WORD\[2\].W.BYTE\[1\].B.WE0_WIRE VGND VGND VPWR
+ VPWR SLICE_16\[1\].RAM16.SLICE\[0\].RAM8.WORD\[2\].W.BYTE\[1\].B.GCLK sky130_fd_sc_hd__dlclkp_1
XSLICE_16\[0\].RAM16.Do0_REG.OUTREG_BYTE\[1\].DIODE\[4\] SLICE_16\[0\].RAM16.BYTE\[1\].FLOATBUF0\[12\].Z
+ VGND VGND VPWR VPWR sky130_fd_sc_hd__diode_2
XSLICE_16\[0\].RAM16.SLICE\[0\].RAM8.WORD\[5\].W.SEL0BUF SLICE_16\[0\].RAM16.SLICE\[0\].RAM8.DEC0.SEL\[5\]
+ VGND VGND VPWR VPWR SLICE_16\[0\].RAM16.SLICE\[0\].RAM8.WORD\[5\].W.BYTE\[0\].B.SEL0
+ sky130_fd_sc_hd__clkbuf_2
Xtap_38_1 VGND VPWR sky130_fd_sc_hd__tapvpwrvgnd_1
XSLICE_16\[1\].RAM16.SLICE\[1\].RAM8.WORD\[6\].W.BYTE\[2\].B.BIT\[7\].genblk1.STORAGE
+ DIBUF\[23\].X SLICE_16\[1\].RAM16.SLICE\[1\].RAM8.WORD\[6\].W.BYTE\[2\].B.GCLK VGND
+ VGND VPWR VPWR SLICE_16\[1\].RAM16.SLICE\[1\].RAM8.WORD\[6\].W.BYTE\[2\].B.Q_WIRE\[7\]
+ sky130_fd_sc_hd__dlxtp_1
XSLICE_16\[1\].RAM16.SLICE\[1\].RAM8.WORD\[4\].W.BYTE\[0\].B.BIT\[6\].genblk1.STORAGE
+ DIBUF\[6\].X SLICE_16\[1\].RAM16.SLICE\[1\].RAM8.WORD\[4\].W.BYTE\[0\].B.GCLK VGND
+ VGND VPWR VPWR SLICE_16\[1\].RAM16.SLICE\[1\].RAM8.WORD\[4\].W.BYTE\[0\].B.Q_WIRE\[6\]
+ sky130_fd_sc_hd__dlxtp_1
XSLICE_16\[0\].RAM16.SLICE\[0\].RAM8.WORD\[0\].W.BYTE\[2\].B.BIT\[7\].OBUF0 SLICE_16\[0\].RAM16.SLICE\[0\].RAM8.WORD\[0\].W.BYTE\[2\].B.Q_WIRE\[7\]
+ SLICE_16\[0\].RAM16.SLICE\[0\].RAM8.WORD\[0\].W.BYTE\[2\].B.SEL0_B VGND VGND VPWR
+ VPWR SLICE_16\[0\].RAM16.BYTE\[2\].FLOATBUF0\[23\].Z sky130_fd_sc_hd__ebufn_2
XDo0MUX.M\[0\].DIODE_A1MUX\[7\] Do0MUX.A1\[7\] VGND VGND VPWR VPWR sky130_fd_sc_hd__diode_2
XSLICE_16\[1\].RAM16.SLICE\[1\].RAM8.WORD\[2\].W.BYTE\[2\].B.BIT\[4\].OBUF0 SLICE_16\[1\].RAM16.SLICE\[1\].RAM8.WORD\[2\].W.BYTE\[2\].B.Q_WIRE\[4\]
+ SLICE_16\[1\].RAM16.SLICE\[1\].RAM8.WORD\[2\].W.BYTE\[2\].B.SEL0_B VGND VGND VPWR
+ VPWR SLICE_16\[1\].RAM16.BYTE\[2\].FLOATBUF0\[20\].Z sky130_fd_sc_hd__ebufn_2
XSLICE_16\[1\].RAM16.SLICE\[0\].RAM8.WORD\[5\].W.BYTE\[2\].B.BIT\[2\].genblk1.STORAGE
+ DIBUF\[18\].X SLICE_16\[1\].RAM16.SLICE\[0\].RAM8.WORD\[5\].W.BYTE\[2\].B.GCLK VGND
+ VGND VPWR VPWR SLICE_16\[1\].RAM16.SLICE\[0\].RAM8.WORD\[5\].W.BYTE\[2\].B.Q_WIRE\[2\]
+ sky130_fd_sc_hd__dlxtp_1
XSLICE_16\[1\].RAM16.SLICE\[0\].RAM8.WORD\[3\].W.BYTE\[0\].B.BIT\[1\].genblk1.STORAGE
+ DIBUF\[1\].X SLICE_16\[1\].RAM16.SLICE\[0\].RAM8.WORD\[3\].W.BYTE\[0\].B.GCLK VGND
+ VGND VPWR VPWR SLICE_16\[1\].RAM16.SLICE\[0\].RAM8.WORD\[3\].W.BYTE\[0\].B.Q_WIRE\[1\]
+ sky130_fd_sc_hd__dlxtp_1
XSLICE_16\[0\].RAM16.SLICE\[1\].RAM8.WORD\[7\].W.BYTE\[2\].B.BIT\[3\].genblk1.STORAGE
+ DIBUF\[19\].X SLICE_16\[0\].RAM16.SLICE\[1\].RAM8.WORD\[7\].W.BYTE\[2\].B.GCLK VGND
+ VGND VPWR VPWR SLICE_16\[0\].RAM16.SLICE\[1\].RAM8.WORD\[7\].W.BYTE\[2\].B.Q_WIRE\[3\]
+ sky130_fd_sc_hd__dlxtp_1
XSLICE_16\[0\].RAM16.SLICE\[1\].RAM8.WORD\[1\].W.BYTE\[3\].B.BIT\[4\].genblk1.STORAGE
+ DIBUF\[28\].X SLICE_16\[0\].RAM16.SLICE\[1\].RAM8.WORD\[1\].W.BYTE\[3\].B.GCLK VGND
+ VGND VPWR VPWR SLICE_16\[0\].RAM16.SLICE\[1\].RAM8.WORD\[1\].W.BYTE\[3\].B.Q_WIRE\[4\]
+ sky130_fd_sc_hd__dlxtp_1
XSLICE_16\[0\].RAM16.SLICE\[1\].RAM8.WORD\[4\].W.BYTE\[1\].B.BIT\[5\].OBUF0 SLICE_16\[0\].RAM16.SLICE\[1\].RAM8.WORD\[4\].W.BYTE\[1\].B.Q_WIRE\[5\]
+ SLICE_16\[0\].RAM16.SLICE\[1\].RAM8.WORD\[4\].W.BYTE\[1\].B.SEL0_B VGND VGND VPWR
+ VPWR SLICE_16\[0\].RAM16.BYTE\[1\].FLOATBUF0\[13\].Z sky130_fd_sc_hd__ebufn_2
XSLICE_16\[0\].RAM16.SLICE\[1\].RAM8.WORD\[5\].W.BYTE\[0\].B.BIT\[2\].genblk1.STORAGE
+ DIBUF\[2\].X SLICE_16\[0\].RAM16.SLICE\[1\].RAM8.WORD\[5\].W.BYTE\[0\].B.GCLK VGND
+ VGND VPWR VPWR SLICE_16\[0\].RAM16.SLICE\[1\].RAM8.WORD\[5\].W.BYTE\[0\].B.Q_WIRE\[2\]
+ sky130_fd_sc_hd__dlxtp_1
XSLICE_16\[0\].RAM16.SLICE\[0\].RAM8.WORD\[5\].W.BYTE\[0\].B.CGAND SLICE_16\[0\].RAM16.SLICE\[0\].RAM8.WORD\[5\].W.BYTE\[0\].B.SEL0
+ SLICE_16\[0\].RAM16.SLICE\[0\].RAM8.WE0_buf\[0\] VGND VGND VPWR VPWR SLICE_16\[0\].RAM16.SLICE\[0\].RAM8.WORD\[5\].W.BYTE\[0\].B.WE0_WIRE
+ sky130_fd_sc_hd__and2_1
XSLICE_16\[1\].RAM16.SLICE\[1\].RAM8.WORD\[1\].W.BYTE\[1\].B.SEL0INV SLICE_16\[1\].RAM16.SLICE\[1\].RAM8.WORD\[1\].W.BYTE\[0\].B.SEL0
+ VGND VGND VPWR VPWR SLICE_16\[1\].RAM16.SLICE\[1\].RAM8.WORD\[1\].W.BYTE\[1\].B.SEL0_B
+ sky130_fd_sc_hd__inv_1
Xfill_21_91 VGND VGND VPWR VPWR sky130_fd_sc_hd__decap_12
Xfill_21_80 VGND VGND VPWR VPWR sky130_fd_sc_hd__decap_12
XSLICE_16\[0\].RAM16.Do0_REG.OUTREG_BYTE\[0\].Do_FF\[5\] SLICE_16\[0\].RAM16.Do0_REG.CLKBUF\[0\]
+ SLICE_16\[0\].RAM16.BYTE\[0\].FLOATBUF0\[5\].Z VGND VGND VPWR VPWR Do0MUX.A0\[5\]
+ sky130_fd_sc_hd__dfxtp_1
Xtap_13_29 VGND VPWR sky130_fd_sc_hd__tapvpwrvgnd_1
Xtap_13_18 VGND VPWR sky130_fd_sc_hd__tapvpwrvgnd_1
Xfill_7_3 VGND VGND VPWR VPWR sky130_fd_sc_hd__decap_6
XSLICE_16\[1\].RAM16.SLICE\[1\].RAM8.WORD\[1\].W.BYTE\[0\].B.BIT\[1\].OBUF0 SLICE_16\[1\].RAM16.SLICE\[1\].RAM8.WORD\[1\].W.BYTE\[0\].B.Q_WIRE\[1\]
+ SLICE_16\[1\].RAM16.SLICE\[1\].RAM8.WORD\[1\].W.BYTE\[0\].B.SEL0_B VGND VGND VPWR
+ VPWR SLICE_16\[1\].RAM16.BYTE\[0\].FLOATBUF0\[1\].Z sky130_fd_sc_hd__ebufn_2
Xtap_31_8 VGND VPWR sky130_fd_sc_hd__tapvpwrvgnd_1
XSLICE_16\[0\].RAM16.SLICE\[0\].RAM8.WORD\[3\].W.BYTE\[3\].B.BIT\[7\].OBUF0 SLICE_16\[0\].RAM16.SLICE\[0\].RAM8.WORD\[3\].W.BYTE\[3\].B.Q_WIRE\[7\]
+ SLICE_16\[0\].RAM16.SLICE\[0\].RAM8.WORD\[3\].W.BYTE\[3\].B.SEL0_B VGND VGND VPWR
+ VPWR SLICE_16\[0\].RAM16.BYTE\[3\].FLOATBUF0\[31\].Z sky130_fd_sc_hd__ebufn_2
Xtap_38_26 VGND VPWR sky130_fd_sc_hd__tapvpwrvgnd_1
Xtap_38_15 VGND VPWR sky130_fd_sc_hd__tapvpwrvgnd_1
XSLICE_16\[1\].RAM16.SLICE\[1\].RAM8.WORD\[5\].W.BYTE\[3\].B.BIT\[4\].OBUF0 SLICE_16\[1\].RAM16.SLICE\[1\].RAM8.WORD\[5\].W.BYTE\[3\].B.Q_WIRE\[4\]
+ SLICE_16\[1\].RAM16.SLICE\[1\].RAM8.WORD\[5\].W.BYTE\[3\].B.SEL0_B VGND VGND VPWR
+ VPWR SLICE_16\[1\].RAM16.BYTE\[3\].FLOATBUF0\[28\].Z sky130_fd_sc_hd__ebufn_2
Xtap_24_7 VGND VPWR sky130_fd_sc_hd__tapvpwrvgnd_1
Xtap_17_6 VGND VPWR sky130_fd_sc_hd__tapvpwrvgnd_1
Xtap_0_21 VGND VPWR sky130_fd_sc_hd__tapvpwrvgnd_1
Xtap_0_10 VGND VPWR sky130_fd_sc_hd__tapvpwrvgnd_1
Xtap_9_30 VGND VPWR sky130_fd_sc_hd__tapvpwrvgnd_1
Xfill_42_79 VGND VGND VPWR VPWR sky130_fd_sc_hd__decap_12
Xfill_42_68 VGND VGND VPWR VPWR sky130_fd_sc_hd__decap_12
Xfill_42_57 VGND VPWR sky130_fd_sc_hd__tapvpwrvgnd_1
Xfill_42_46 VGND VGND VPWR VPWR sky130_fd_sc_hd__decap_12
Xfill_42_35 VGND VGND VPWR VPWR sky130_fd_sc_hd__decap_12
Xfill_42_24 VGND VPWR sky130_fd_sc_hd__tapvpwrvgnd_1
Xfill_42_13 VGND VGND VPWR VPWR sky130_fd_sc_hd__decap_12
XSLICE_16\[1\].RAM16.SLICE\[1\].RAM8.WORD\[7\].W.BYTE\[1\].B.genblk1.CG SLICE_16\[1\].RAM16.SLICE\[1\].RAM8.WORD\[7\].W.BYTE\[1\].B.CLK_B
+ SLICE_16\[1\].RAM16.SLICE\[1\].RAM8.WORD\[7\].W.BYTE\[1\].B.WE0_WIRE VGND VGND VPWR
+ VPWR SLICE_16\[1\].RAM16.SLICE\[1\].RAM8.WORD\[7\].W.BYTE\[1\].B.GCLK sky130_fd_sc_hd__dlclkp_1
XSLICE_16\[1\].RAM16.SLICE\[0\].RAM8.WORD\[0\].W.BYTE\[2\].B.BIT\[3\].OBUF0 SLICE_16\[1\].RAM16.SLICE\[0\].RAM8.WORD\[0\].W.BYTE\[2\].B.Q_WIRE\[3\]
+ SLICE_16\[1\].RAM16.SLICE\[0\].RAM8.WORD\[0\].W.BYTE\[2\].B.SEL0_B VGND VGND VPWR
+ VPWR SLICE_16\[1\].RAM16.BYTE\[2\].FLOATBUF0\[19\].Z sky130_fd_sc_hd__ebufn_2
XSLICE_16\[0\].RAM16.SLICE\[1\].RAM8.WORD\[7\].W.BYTE\[2\].B.BIT\[5\].OBUF0 SLICE_16\[0\].RAM16.SLICE\[1\].RAM8.WORD\[7\].W.BYTE\[2\].B.Q_WIRE\[5\]
+ SLICE_16\[0\].RAM16.SLICE\[1\].RAM8.WORD\[7\].W.BYTE\[2\].B.SEL0_B VGND VGND VPWR
+ VPWR SLICE_16\[0\].RAM16.BYTE\[2\].FLOATBUF0\[21\].Z sky130_fd_sc_hd__ebufn_2
XSLICE_16\[1\].RAM16.SLICE\[0\].RAM8.WORD\[0\].W.BYTE\[3\].B.DIODE_CLK SLICE_16\[1\].RAM16.SLICE\[0\].RAM8.WORD\[0\].W.BYTE\[0\].B.CLK
+ VGND VGND VPWR VPWR sky130_fd_sc_hd__diode_2
Xfill_38_9 VGND VGND VPWR VPWR sky130_fd_sc_hd__decap_6
XSLICE_16\[0\].RAM16.SLICE\[0\].RAM8.WORD\[2\].W.BYTE\[1\].B.BIT\[4\].OBUF0 SLICE_16\[0\].RAM16.SLICE\[0\].RAM8.WORD\[2\].W.BYTE\[1\].B.Q_WIRE\[4\]
+ SLICE_16\[0\].RAM16.SLICE\[0\].RAM8.WORD\[2\].W.BYTE\[1\].B.SEL0_B VGND VGND VPWR
+ VPWR SLICE_16\[0\].RAM16.BYTE\[1\].FLOATBUF0\[12\].Z sky130_fd_sc_hd__ebufn_2
XSLICE_16\[1\].RAM16.SLICE\[1\].RAM8.WORD\[7\].W.BYTE\[1\].B.BIT\[6\].genblk1.STORAGE
+ DIBUF\[14\].X SLICE_16\[1\].RAM16.SLICE\[1\].RAM8.WORD\[7\].W.BYTE\[1\].B.GCLK VGND
+ VGND VPWR VPWR SLICE_16\[1\].RAM16.SLICE\[1\].RAM8.WORD\[7\].W.BYTE\[1\].B.Q_WIRE\[6\]
+ sky130_fd_sc_hd__dlxtp_1
XSLICE_16\[1\].RAM16.SLICE\[1\].RAM8.WORD\[4\].W.BYTE\[1\].B.BIT\[1\].OBUF0 SLICE_16\[1\].RAM16.SLICE\[1\].RAM8.WORD\[4\].W.BYTE\[1\].B.Q_WIRE\[1\]
+ SLICE_16\[1\].RAM16.SLICE\[1\].RAM8.WORD\[4\].W.BYTE\[1\].B.SEL0_B VGND VGND VPWR
+ VPWR SLICE_16\[1\].RAM16.BYTE\[1\].FLOATBUF0\[9\].Z sky130_fd_sc_hd__ebufn_2
XSLICE_16\[1\].RAM16.SLICE\[1\].RAM8.WORD\[1\].W.BYTE\[2\].B.BIT\[7\].genblk1.STORAGE
+ DIBUF\[23\].X SLICE_16\[1\].RAM16.SLICE\[1\].RAM8.WORD\[1\].W.BYTE\[2\].B.GCLK VGND
+ VGND VPWR VPWR SLICE_16\[1\].RAM16.SLICE\[1\].RAM8.WORD\[1\].W.BYTE\[2\].B.Q_WIRE\[7\]
+ sky130_fd_sc_hd__dlxtp_1
XSLICE_16\[1\].RAM16.SLICE\[0\].RAM8.WORD\[6\].W.BYTE\[1\].B.BIT\[1\].genblk1.STORAGE
+ DIBUF\[9\].X SLICE_16\[1\].RAM16.SLICE\[0\].RAM8.WORD\[6\].W.BYTE\[1\].B.GCLK VGND
+ VGND VPWR VPWR SLICE_16\[1\].RAM16.SLICE\[0\].RAM8.WORD\[6\].W.BYTE\[1\].B.Q_WIRE\[1\]
+ sky130_fd_sc_hd__dlxtp_1
XSLICE_16\[1\].RAM16.SLICE\[0\].RAM8.WORD\[0\].W.BYTE\[2\].B.BIT\[2\].genblk1.STORAGE
+ DIBUF\[18\].X SLICE_16\[1\].RAM16.SLICE\[0\].RAM8.WORD\[0\].W.BYTE\[2\].B.GCLK VGND
+ VGND VPWR VPWR SLICE_16\[1\].RAM16.SLICE\[0\].RAM8.WORD\[0\].W.BYTE\[2\].B.Q_WIRE\[2\]
+ sky130_fd_sc_hd__dlxtp_1
XSLICE_16\[0\].RAM16.SLICE\[0\].RAM8.WORD\[3\].W.BYTE\[2\].B.DIODE_CLK SLICE_16\[0\].RAM16.SLICE\[0\].RAM8.WORD\[3\].W.BYTE\[0\].B.CLK
+ VGND VGND VPWR VPWR sky130_fd_sc_hd__diode_2
XSLICE_16\[1\].RAM16.SLICE\[0\].RAM8.WORD\[4\].W.BYTE\[0\].B.genblk1.CLKINV SLICE_16\[1\].RAM16.SLICE\[0\].RAM8.WORD\[4\].W.BYTE\[0\].B.CLK
+ VGND VGND VPWR VPWR SLICE_16\[1\].RAM16.SLICE\[0\].RAM8.WORD\[4\].W.BYTE\[0\].B.CLK_B
+ sky130_fd_sc_hd__inv_1
Xtap_24_28 VGND VPWR sky130_fd_sc_hd__tapvpwrvgnd_1
Xtap_24_17 VGND VPWR sky130_fd_sc_hd__tapvpwrvgnd_1
XSLICE_16\[0\].RAM16.SLICE\[1\].RAM8.WORD\[6\].W.BYTE\[0\].B.BIT\[2\].OBUF0 SLICE_16\[0\].RAM16.SLICE\[1\].RAM8.WORD\[6\].W.BYTE\[0\].B.Q_WIRE\[2\]
+ SLICE_16\[0\].RAM16.SLICE\[1\].RAM8.WORD\[6\].W.BYTE\[0\].B.SEL0_B VGND VGND VPWR
+ VPWR SLICE_16\[0\].RAM16.BYTE\[0\].FLOATBUF0\[2\].Z sky130_fd_sc_hd__ebufn_2
Xfill_5_0 VGND VPWR sky130_fd_sc_hd__tapvpwrvgnd_1
XSLICE_16\[0\].RAM16.SLICE\[1\].RAM8.WORD\[2\].W.BYTE\[2\].B.BIT\[3\].genblk1.STORAGE
+ DIBUF\[19\].X SLICE_16\[0\].RAM16.SLICE\[1\].RAM8.WORD\[2\].W.BYTE\[2\].B.GCLK VGND
+ VGND VPWR VPWR SLICE_16\[0\].RAM16.SLICE\[1\].RAM8.WORD\[2\].W.BYTE\[2\].B.Q_WIRE\[3\]
+ sky130_fd_sc_hd__dlxtp_1
Xtap_40_27 VGND VPWR sky130_fd_sc_hd__tapvpwrvgnd_1
Xtap_40_16 VGND VPWR sky130_fd_sc_hd__tapvpwrvgnd_1
XSLICE_16\[1\].RAM16.SLICE\[0\].RAM8.WORD\[3\].W.BYTE\[3\].B.BIT\[3\].OBUF0 SLICE_16\[1\].RAM16.SLICE\[0\].RAM8.WORD\[3\].W.BYTE\[3\].B.Q_WIRE\[3\]
+ SLICE_16\[1\].RAM16.SLICE\[0\].RAM8.WORD\[3\].W.BYTE\[3\].B.SEL0_B VGND VGND VPWR
+ VPWR SLICE_16\[1\].RAM16.BYTE\[3\].FLOATBUF0\[27\].Z sky130_fd_sc_hd__ebufn_2
XSLICE_16\[0\].RAM16.SLICE\[1\].RAM8.WORD\[0\].W.BYTE\[0\].B.BIT\[2\].genblk1.STORAGE
+ DIBUF\[2\].X SLICE_16\[0\].RAM16.SLICE\[1\].RAM8.WORD\[0\].W.BYTE\[0\].B.GCLK VGND
+ VGND VPWR VPWR SLICE_16\[0\].RAM16.SLICE\[1\].RAM8.WORD\[0\].W.BYTE\[0\].B.Q_WIRE\[2\]
+ sky130_fd_sc_hd__dlxtp_1
XSLICE_16\[1\].RAM16.Do0_REG.OUTREG_BYTE\[0\].DIODE\[0\] SLICE_16\[1\].RAM16.BYTE\[0\].FLOATBUF0\[0\].Z
+ VGND VGND VPWR VPWR sky130_fd_sc_hd__diode_2
Xtap_15_3 VGND VPWR sky130_fd_sc_hd__tapvpwrvgnd_1
XSLICE_16\[0\].RAM16.SLICE\[0\].RAM8.WORD\[5\].W.BYTE\[2\].B.BIT\[4\].OBUF0 SLICE_16\[0\].RAM16.SLICE\[0\].RAM8.WORD\[5\].W.BYTE\[2\].B.Q_WIRE\[4\]
+ SLICE_16\[0\].RAM16.SLICE\[0\].RAM8.WORD\[5\].W.BYTE\[2\].B.SEL0_B VGND VGND VPWR
+ VPWR SLICE_16\[0\].RAM16.BYTE\[2\].FLOATBUF0\[20\].Z sky130_fd_sc_hd__ebufn_2
Xtap_8_2 VGND VPWR sky130_fd_sc_hd__tapvpwrvgnd_1
XSLICE_16\[1\].RAM16.WEBUF\[3\].__cell__ SLICE_16\[0\].RAM16.WE0\[3\] VGND VGND VPWR
+ VPWR SLICE_16\[1\].RAM16.SLICE\[0\].RAM8.WE0\[3\] sky130_fd_sc_hd__clkbuf_2
XSLICE_16\[1\].RAM16.SLICE\[1\].RAM8.WORD\[7\].W.BYTE\[2\].B.BIT\[1\].OBUF0 SLICE_16\[1\].RAM16.SLICE\[1\].RAM8.WORD\[7\].W.BYTE\[2\].B.Q_WIRE\[1\]
+ SLICE_16\[1\].RAM16.SLICE\[1\].RAM8.WORD\[7\].W.BYTE\[2\].B.SEL0_B VGND VGND VPWR
+ VPWR SLICE_16\[1\].RAM16.BYTE\[2\].FLOATBUF0\[17\].Z sky130_fd_sc_hd__ebufn_2
Xfill_0_18 VGND VPWR sky130_fd_sc_hd__tapvpwrvgnd_1
XSLICE_16\[1\].RAM16.SLICE\[1\].RAM8.WORD\[2\].W.CLKBUF SLICE_16\[1\].RAM16.SLICE\[1\].RAM8.CLKBUF.X
+ VGND VGND VPWR VPWR SLICE_16\[1\].RAM16.SLICE\[1\].RAM8.WORD\[2\].W.BYTE\[0\].B.CLK
+ sky130_fd_sc_hd__clkbuf_4
Xfill_46_103 VGND VGND VPWR VPWR sky130_fd_sc_hd__decap_12
Xfill_43_7 VGND VGND VPWR VPWR sky130_fd_sc_hd__decap_12
Xfill_36_6 VGND VGND VPWR VPWR sky130_fd_sc_hd__fill_2
XSLICE_16\[1\].RAM16.SLICE\[0\].RAM8.WORD\[7\].W.BYTE\[1\].B.genblk1.CLKINV SLICE_16\[1\].RAM16.SLICE\[0\].RAM8.WORD\[7\].W.BYTE\[0\].B.CLK
+ VGND VGND VPWR VPWR SLICE_16\[1\].RAM16.SLICE\[0\].RAM8.WORD\[7\].W.BYTE\[1\].B.CLK_B
+ sky130_fd_sc_hd__inv_1
Xfill_29_5 VGND VGND VPWR VPWR sky130_fd_sc_hd__decap_6
XSLICE_16\[1\].RAM16.SLICE\[0\].RAM8.WORD\[2\].W.BYTE\[1\].B.BIT\[0\].OBUF0 SLICE_16\[1\].RAM16.SLICE\[0\].RAM8.WORD\[2\].W.BYTE\[1\].B.Q_WIRE\[0\]
+ SLICE_16\[1\].RAM16.SLICE\[0\].RAM8.WORD\[2\].W.BYTE\[1\].B.SEL0_B VGND VGND VPWR
+ VPWR SLICE_16\[1\].RAM16.BYTE\[1\].FLOATBUF0\[8\].Z sky130_fd_sc_hd__ebufn_2
Xfill_46_136 VGND VGND VPWR VPWR sky130_fd_sc_hd__decap_12
Xfill_46_125 VGND VGND VPWR VPWR sky130_fd_sc_hd__decap_12
Xfill_46_114 VGND VPWR sky130_fd_sc_hd__tapvpwrvgnd_1
Xtap_10_19 VGND VPWR sky130_fd_sc_hd__tapvpwrvgnd_1
XSLICE_16\[0\].RAM16.SLICE\[0\].RAM8.WORD\[4\].W.BYTE\[0\].B.BIT\[1\].OBUF0 SLICE_16\[0\].RAM16.SLICE\[0\].RAM8.WORD\[4\].W.BYTE\[0\].B.Q_WIRE\[1\]
+ SLICE_16\[0\].RAM16.SLICE\[0\].RAM8.WORD\[4\].W.BYTE\[0\].B.SEL0_B VGND VGND VPWR
+ VPWR SLICE_16\[0\].RAM16.BYTE\[0\].FLOATBUF0\[1\].Z sky130_fd_sc_hd__ebufn_2
XSLICE_16\[1\].RAM16.SLICE\[1\].RAM8.WORD\[4\].W.BYTE\[3\].B.BIT\[7\].genblk1.STORAGE
+ DIBUF\[31\].X SLICE_16\[1\].RAM16.SLICE\[1\].RAM8.WORD\[4\].W.BYTE\[3\].B.GCLK VGND
+ VGND VPWR VPWR SLICE_16\[1\].RAM16.SLICE\[1\].RAM8.WORD\[4\].W.BYTE\[3\].B.Q_WIRE\[7\]
+ sky130_fd_sc_hd__dlxtp_1
Xtap_35_27 VGND VPWR sky130_fd_sc_hd__tapvpwrvgnd_1
Xtap_35_16 VGND VPWR sky130_fd_sc_hd__tapvpwrvgnd_1
Xtap_1_9 VGND VPWR sky130_fd_sc_hd__tapvpwrvgnd_1
XSLICE_16\[0\].RAM16.SLICE\[1\].RAM8.WORD\[0\].W.BYTE\[3\].B.BIT\[7\].OBUF0 SLICE_16\[0\].RAM16.SLICE\[1\].RAM8.WORD\[0\].W.BYTE\[3\].B.Q_WIRE\[7\]
+ SLICE_16\[0\].RAM16.SLICE\[1\].RAM8.WORD\[0\].W.BYTE\[3\].B.SEL0_B VGND VGND VPWR
+ VPWR SLICE_16\[0\].RAM16.BYTE\[3\].FLOATBUF0\[31\].Z sky130_fd_sc_hd__ebufn_2
XSLICE_16\[1\].RAM16.SLICE\[1\].RAM8.WORD\[2\].W.BYTE\[1\].B.BIT\[6\].genblk1.STORAGE
+ DIBUF\[14\].X SLICE_16\[1\].RAM16.SLICE\[1\].RAM8.WORD\[2\].W.BYTE\[1\].B.GCLK VGND
+ VGND VPWR VPWR SLICE_16\[1\].RAM16.SLICE\[1\].RAM8.WORD\[2\].W.BYTE\[1\].B.Q_WIRE\[6\]
+ sky130_fd_sc_hd__dlxtp_1
XSLICE_16\[1\].RAM16.SLICE\[0\].RAM8.WORD\[7\].W.BYTE\[3\].B.CGAND SLICE_16\[1\].RAM16.SLICE\[0\].RAM8.WORD\[7\].W.BYTE\[0\].B.SEL0
+ SLICE_16\[1\].RAM16.SLICE\[0\].RAM8.WE0_buf\[3\] VGND VGND VPWR VPWR SLICE_16\[1\].RAM16.SLICE\[0\].RAM8.WORD\[7\].W.BYTE\[3\].B.WE0_WIRE
+ sky130_fd_sc_hd__and2_1
XSLICE_16\[0\].RAM16.SLICE\[0\].RAM8.WORD\[1\].W.BYTE\[1\].B.genblk1.CG SLICE_16\[0\].RAM16.SLICE\[0\].RAM8.WORD\[1\].W.BYTE\[1\].B.CLK_B
+ SLICE_16\[0\].RAM16.SLICE\[0\].RAM8.WORD\[1\].W.BYTE\[1\].B.WE0_WIRE VGND VGND VPWR
+ VPWR SLICE_16\[0\].RAM16.SLICE\[0\].RAM8.WORD\[1\].W.BYTE\[1\].B.GCLK sky130_fd_sc_hd__dlclkp_1
XSLICE_16\[1\].RAM16.SLICE\[0\].RAM8.WORD\[7\].W.BYTE\[0\].B.BIT\[0\].genblk1.STORAGE
+ DIBUF\[0\].X SLICE_16\[1\].RAM16.SLICE\[0\].RAM8.WORD\[7\].W.BYTE\[0\].B.GCLK VGND
+ VGND VPWR VPWR SLICE_16\[1\].RAM16.SLICE\[0\].RAM8.WORD\[7\].W.BYTE\[0\].B.Q_WIRE\[0\]
+ sky130_fd_sc_hd__dlxtp_1
XSLICE_16\[1\].RAM16.SLICE\[0\].RAM8.WORD\[6\].W.SEL0BUF SLICE_16\[1\].RAM16.SLICE\[0\].RAM8.DEC0.SEL\[6\]
+ VGND VGND VPWR VPWR SLICE_16\[1\].RAM16.SLICE\[0\].RAM8.WORD\[6\].W.BYTE\[0\].B.SEL0
+ sky130_fd_sc_hd__clkbuf_2
XSLICE_16\[1\].RAM16.SLICE\[0\].RAM8.WORD\[3\].W.BYTE\[3\].B.BIT\[2\].genblk1.STORAGE
+ DIBUF\[26\].X SLICE_16\[1\].RAM16.SLICE\[0\].RAM8.WORD\[3\].W.BYTE\[3\].B.GCLK VGND
+ VGND VPWR VPWR SLICE_16\[1\].RAM16.SLICE\[0\].RAM8.WORD\[3\].W.BYTE\[3\].B.Q_WIRE\[2\]
+ sky130_fd_sc_hd__dlxtp_1
XSLICE_16\[1\].RAM16.SLICE\[0\].RAM8.WORD\[1\].W.BYTE\[1\].B.BIT\[1\].genblk1.STORAGE
+ DIBUF\[9\].X SLICE_16\[1\].RAM16.SLICE\[0\].RAM8.WORD\[1\].W.BYTE\[1\].B.GCLK VGND
+ VGND VPWR VPWR SLICE_16\[1\].RAM16.SLICE\[0\].RAM8.WORD\[1\].W.BYTE\[1\].B.Q_WIRE\[1\]
+ sky130_fd_sc_hd__dlxtp_1
Xtap_6_20 VGND VPWR sky130_fd_sc_hd__tapvpwrvgnd_1
Xtap_6_31 VGND VPWR sky130_fd_sc_hd__tapvpwrvgnd_1
XSLICE_16\[1\].RAM16.SLICE\[1\].RAM8.WORD\[7\].W.BYTE\[0\].B.BIT\[6\].OBUF0 SLICE_16\[1\].RAM16.SLICE\[1\].RAM8.WORD\[7\].W.BYTE\[0\].B.Q_WIRE\[6\]
+ SLICE_16\[1\].RAM16.SLICE\[1\].RAM8.WORD\[7\].W.BYTE\[0\].B.SEL0_B VGND VGND VPWR
+ VPWR SLICE_16\[1\].RAM16.BYTE\[0\].FLOATBUF0\[6\].Z sky130_fd_sc_hd__ebufn_2
XSLICE_16\[1\].RAM16.SLICE\[1\].RAM8.WORD\[2\].W.BYTE\[3\].B.DIODE_CLK SLICE_16\[1\].RAM16.SLICE\[1\].RAM8.WORD\[2\].W.BYTE\[0\].B.CLK
+ VGND VGND VPWR VPWR sky130_fd_sc_hd__diode_2
XSLICE_16\[1\].RAM16.SLICE\[0\].RAM8.WORD\[5\].W.BYTE\[2\].B.BIT\[0\].OBUF0 SLICE_16\[1\].RAM16.SLICE\[0\].RAM8.WORD\[5\].W.BYTE\[2\].B.Q_WIRE\[0\]
+ SLICE_16\[1\].RAM16.SLICE\[0\].RAM8.WORD\[5\].W.BYTE\[2\].B.SEL0_B VGND VGND VPWR
+ VPWR SLICE_16\[1\].RAM16.BYTE\[2\].FLOATBUF0\[16\].Z sky130_fd_sc_hd__ebufn_2
XSLICE_16\[0\].RAM16.SLICE\[1\].RAM8.WORD\[5\].W.BYTE\[3\].B.BIT\[3\].genblk1.STORAGE
+ DIBUF\[27\].X SLICE_16\[0\].RAM16.SLICE\[1\].RAM8.WORD\[5\].W.BYTE\[3\].B.GCLK VGND
+ VGND VPWR VPWR SLICE_16\[0\].RAM16.SLICE\[1\].RAM8.WORD\[5\].W.BYTE\[3\].B.Q_WIRE\[3\]
+ sky130_fd_sc_hd__dlxtp_1
Xtap_13_0 VGND VPWR sky130_fd_sc_hd__tapvpwrvgnd_1
XSLICE_16\[0\].RAM16.SLICE\[1\].RAM8.WORD\[3\].W.BYTE\[1\].B.BIT\[2\].genblk1.STORAGE
+ DIBUF\[10\].X SLICE_16\[0\].RAM16.SLICE\[1\].RAM8.WORD\[3\].W.BYTE\[1\].B.GCLK VGND
+ VGND VPWR VPWR SLICE_16\[0\].RAM16.SLICE\[1\].RAM8.WORD\[3\].W.BYTE\[1\].B.Q_WIRE\[2\]
+ sky130_fd_sc_hd__dlxtp_1
XSLICE_16\[0\].RAM16.SLICE\[1\].RAM8.WORD\[3\].W.BYTE\[0\].B.SEL0INV SLICE_16\[0\].RAM16.SLICE\[1\].RAM8.WORD\[3\].W.BYTE\[0\].B.SEL0
+ VGND VGND VPWR VPWR SLICE_16\[0\].RAM16.SLICE\[1\].RAM8.WORD\[3\].W.BYTE\[0\].B.SEL0_B
+ sky130_fd_sc_hd__inv_1
XSLICE_16\[1\].RAM16.BYTE\[0\].FLOATBUF0\[4\].__cell__ SLICE_16\[1\].RAM16.BYTE\[0\].FLOATBUF0\[0\].A
+ SLICE_16\[1\].RAM16.BYTE\[0\].FLOATBUF0\[0\].TE_B VGND VGND VPWR VPWR SLICE_16\[1\].RAM16.BYTE\[0\].FLOATBUF0\[4\].Z
+ sky130_fd_sc_hd__ebufn_2
XSLICE_16\[0\].RAM16.SLICE\[1\].RAM8.WORD\[5\].W.BYTE\[2\].B.DIODE_CLK SLICE_16\[0\].RAM16.SLICE\[1\].RAM8.WORD\[5\].W.BYTE\[0\].B.CLK
+ VGND VGND VPWR VPWR sky130_fd_sc_hd__diode_2
XSLICE_16\[0\].RAM16.SLICE\[0\].RAM8.WORD\[7\].W.BYTE\[1\].B.BIT\[1\].OBUF0 SLICE_16\[0\].RAM16.SLICE\[0\].RAM8.WORD\[7\].W.BYTE\[1\].B.Q_WIRE\[1\]
+ SLICE_16\[0\].RAM16.SLICE\[0\].RAM8.WORD\[7\].W.BYTE\[1\].B.SEL0_B VGND VGND VPWR
+ VPWR SLICE_16\[0\].RAM16.BYTE\[1\].FLOATBUF0\[9\].Z sky130_fd_sc_hd__ebufn_2
Xfill_41_4 VGND VGND VPWR VPWR sky130_fd_sc_hd__decap_12
XSLICE_16\[0\].RAM16.SLICE\[0\].RAM8.WORD\[6\].W.BYTE\[0\].B.BIT\[7\].genblk1.STORAGE
+ DIBUF\[7\].X SLICE_16\[0\].RAM16.SLICE\[0\].RAM8.WORD\[6\].W.BYTE\[0\].B.GCLK VGND
+ VGND VPWR VPWR SLICE_16\[0\].RAM16.SLICE\[0\].RAM8.WORD\[6\].W.BYTE\[0\].B.Q_WIRE\[7\]
+ sky130_fd_sc_hd__dlxtp_1
XDo0MUX.M\[3\].MUX\[0\] Do0MUX.A0\[24\] Do0MUX.A1\[24\] Do0MUX.SEL\[3\] VGND VGND
+ VPWR VPWR Do0[24] sky130_fd_sc_hd__mux2_1
Xfill_34_3 VGND VPWR sky130_fd_sc_hd__tapvpwrvgnd_1
Xfill_27_2 VGND VPWR sky130_fd_sc_hd__tapvpwrvgnd_1
Xfill_19_103 VGND VPWR sky130_fd_sc_hd__tapvpwrvgnd_1
XSLICE_16\[1\].RAM16.SLICE\[1\].RAM8.WORD\[1\].W.BYTE\[0\].B.genblk1.CLKINV SLICE_16\[1\].RAM16.SLICE\[1\].RAM8.WORD\[1\].W.BYTE\[0\].B.CLK
+ VGND VGND VPWR VPWR SLICE_16\[1\].RAM16.SLICE\[1\].RAM8.WORD\[1\].W.BYTE\[0\].B.CLK_B
+ sky130_fd_sc_hd__inv_1
XSLICE_16\[1\].RAM16.SLICE\[1\].RAM8.WORD\[0\].W.BYTE\[3\].B.BIT\[3\].OBUF0 SLICE_16\[1\].RAM16.SLICE\[1\].RAM8.WORD\[0\].W.BYTE\[3\].B.Q_WIRE\[3\]
+ SLICE_16\[1\].RAM16.SLICE\[1\].RAM8.WORD\[0\].W.BYTE\[3\].B.SEL0_B VGND VGND VPWR
+ VPWR SLICE_16\[1\].RAM16.BYTE\[3\].FLOATBUF0\[27\].Z sky130_fd_sc_hd__ebufn_2
Xfill_18_26 VGND VPWR sky130_fd_sc_hd__tapvpwrvgnd_1
Xfill_18_15 VGND VPWR sky130_fd_sc_hd__tapvpwrvgnd_1
XSLICE_16\[1\].RAM16.SLICE\[0\].RAM8.WORD\[5\].W.BYTE\[0\].B.BIT\[5\].OBUF0 SLICE_16\[1\].RAM16.SLICE\[0\].RAM8.WORD\[5\].W.BYTE\[0\].B.Q_WIRE\[5\]
+ SLICE_16\[1\].RAM16.SLICE\[0\].RAM8.WORD\[5\].W.BYTE\[0\].B.SEL0_B VGND VGND VPWR
+ VPWR SLICE_16\[1\].RAM16.BYTE\[0\].FLOATBUF0\[5\].Z sky130_fd_sc_hd__ebufn_2
XSLICE_16\[0\].RAM16.SLICE\[1\].RAM8.WORD\[2\].W.BYTE\[2\].B.BIT\[4\].OBUF0 SLICE_16\[0\].RAM16.SLICE\[1\].RAM8.WORD\[2\].W.BYTE\[2\].B.Q_WIRE\[4\]
+ SLICE_16\[0\].RAM16.SLICE\[1\].RAM8.WORD\[2\].W.BYTE\[2\].B.SEL0_B VGND VGND VPWR
+ VPWR SLICE_16\[0\].RAM16.BYTE\[2\].FLOATBUF0\[20\].Z sky130_fd_sc_hd__ebufn_2
XDo0MUX.M\[2\].MUX\[2\] Do0MUX.A0\[18\] Do0MUX.A1\[18\] Do0MUX.SEL\[2\] VGND VGND
+ VPWR VPWR Do0[18] sky130_fd_sc_hd__mux2_1
XDo0MUX.SEL0BUF\[2\] A0BUF\[4\].X VGND VGND VPWR VPWR Do0MUX.SEL\[2\] sky130_fd_sc_hd__clkbuf_2
XSLICE_16\[1\].RAM16.SLICE\[1\].RAM8.WORD\[5\].W.BYTE\[2\].B.BIT\[6\].genblk1.STORAGE
+ DIBUF\[22\].X SLICE_16\[1\].RAM16.SLICE\[1\].RAM8.WORD\[5\].W.BYTE\[2\].B.GCLK VGND
+ VGND VPWR VPWR SLICE_16\[1\].RAM16.SLICE\[1\].RAM8.WORD\[5\].W.BYTE\[2\].B.Q_WIRE\[6\]
+ sky130_fd_sc_hd__dlxtp_1
XSLICE_16\[0\].RAM16.SLICE\[1\].RAM8.WORD\[6\].W.BYTE\[1\].B.genblk1.CG SLICE_16\[0\].RAM16.SLICE\[1\].RAM8.WORD\[6\].W.BYTE\[1\].B.CLK_B
+ SLICE_16\[0\].RAM16.SLICE\[1\].RAM8.WORD\[6\].W.BYTE\[1\].B.WE0_WIRE VGND VGND VPWR
+ VPWR SLICE_16\[0\].RAM16.SLICE\[1\].RAM8.WORD\[6\].W.BYTE\[1\].B.GCLK sky130_fd_sc_hd__dlclkp_1
XSLICE_16\[1\].RAM16.BYTE\[3\].FLOATBUF0\[30\].__cell__ SLICE_16\[1\].RAM16.BYTE\[3\].FLOATBUF0\[24\].A
+ SLICE_16\[1\].RAM16.BYTE\[3\].FLOATBUF0\[24\].TE_B VGND VGND VPWR VPWR SLICE_16\[1\].RAM16.BYTE\[3\].FLOATBUF0\[30\].Z
+ sky130_fd_sc_hd__ebufn_2
XSLICE_16\[1\].RAM16.SLICE\[1\].RAM8.WORD\[3\].W.BYTE\[0\].B.BIT\[5\].genblk1.STORAGE
+ DIBUF\[5\].X SLICE_16\[1\].RAM16.SLICE\[1\].RAM8.WORD\[3\].W.BYTE\[0\].B.GCLK VGND
+ VGND VPWR VPWR SLICE_16\[1\].RAM16.SLICE\[1\].RAM8.WORD\[3\].W.BYTE\[0\].B.Q_WIRE\[5\]
+ sky130_fd_sc_hd__dlxtp_1
XSLICE_16\[1\].RAM16.SLICE\[0\].RAM8.WORD\[4\].W.BYTE\[2\].B.BIT\[1\].genblk1.STORAGE
+ DIBUF\[17\].X SLICE_16\[1\].RAM16.SLICE\[0\].RAM8.WORD\[4\].W.BYTE\[2\].B.GCLK VGND
+ VGND VPWR VPWR SLICE_16\[1\].RAM16.SLICE\[0\].RAM8.WORD\[4\].W.BYTE\[2\].B.Q_WIRE\[1\]
+ sky130_fd_sc_hd__dlxtp_1
Xfill_20_9 VGND VPWR sky130_fd_sc_hd__tapvpwrvgnd_1
XSLICE_16\[1\].RAM16.SLICE\[0\].RAM8.WORD\[2\].W.BYTE\[0\].B.BIT\[0\].genblk1.STORAGE
+ DIBUF\[0\].X SLICE_16\[1\].RAM16.SLICE\[0\].RAM8.WORD\[2\].W.BYTE\[0\].B.GCLK VGND
+ VGND VPWR VPWR SLICE_16\[1\].RAM16.SLICE\[0\].RAM8.WORD\[2\].W.BYTE\[0\].B.Q_WIRE\[0\]
+ sky130_fd_sc_hd__dlxtp_1
XSLICE_16\[0\].RAM16.SLICE\[1\].RAM8.WORD\[6\].W.BYTE\[2\].B.BIT\[2\].genblk1.STORAGE
+ DIBUF\[18\].X SLICE_16\[0\].RAM16.SLICE\[1\].RAM8.WORD\[6\].W.BYTE\[2\].B.GCLK VGND
+ VGND VPWR VPWR SLICE_16\[0\].RAM16.SLICE\[1\].RAM8.WORD\[6\].W.BYTE\[2\].B.Q_WIRE\[2\]
+ sky130_fd_sc_hd__dlxtp_1
XSLICE_16\[0\].RAM16.FBUFENBUF0\[3\].__cell__ DEC0.SEL\[0\] VGND VGND VPWR VPWR SLICE_16\[0\].RAM16.BYTE\[3\].FLOATBUF0\[24\].TE_B
+ sky130_fd_sc_hd__clkbuf_2
XSLICE_16\[0\].RAM16.SLICE\[1\].RAM8.WORD\[0\].W.BYTE\[3\].B.BIT\[3\].genblk1.STORAGE
+ DIBUF\[27\].X SLICE_16\[0\].RAM16.SLICE\[1\].RAM8.WORD\[0\].W.BYTE\[3\].B.GCLK VGND
+ VGND VPWR VPWR SLICE_16\[0\].RAM16.SLICE\[1\].RAM8.WORD\[0\].W.BYTE\[3\].B.Q_WIRE\[3\]
+ sky130_fd_sc_hd__dlxtp_1
XSLICE_16\[1\].RAM16.SLICE\[1\].RAM8.WORD\[4\].W.BYTE\[1\].B.genblk1.CLKINV SLICE_16\[1\].RAM16.SLICE\[1\].RAM8.WORD\[4\].W.BYTE\[0\].B.CLK
+ VGND VGND VPWR VPWR SLICE_16\[1\].RAM16.SLICE\[1\].RAM8.WORD\[4\].W.BYTE\[1\].B.CLK_B
+ sky130_fd_sc_hd__inv_1
XSLICE_16\[0\].RAM16.SLICE\[1\].RAM8.WORD\[4\].W.BYTE\[0\].B.BIT\[1\].genblk1.STORAGE
+ DIBUF\[1\].X SLICE_16\[0\].RAM16.SLICE\[1\].RAM8.WORD\[4\].W.BYTE\[0\].B.GCLK VGND
+ VGND VPWR VPWR SLICE_16\[0\].RAM16.SLICE\[1\].RAM8.WORD\[4\].W.BYTE\[0\].B.Q_WIRE\[1\]
+ sky130_fd_sc_hd__dlxtp_1
XSLICE_16\[0\].RAM16.SLICE\[0\].RAM8.WORD\[4\].W.SEL0BUF SLICE_16\[0\].RAM16.SLICE\[0\].RAM8.DEC0.SEL\[4\]
+ VGND VGND VPWR VPWR SLICE_16\[0\].RAM16.SLICE\[0\].RAM8.WORD\[4\].W.BYTE\[0\].B.SEL0
+ sky130_fd_sc_hd__clkbuf_2
Xfill_32_0 VGND VPWR sky130_fd_sc_hd__tapvpwrvgnd_1
Xtap_16_29 VGND VPWR sky130_fd_sc_hd__tapvpwrvgnd_1
Xtap_16_18 VGND VPWR sky130_fd_sc_hd__tapvpwrvgnd_1
XSLICE_16\[0\].RAM16.SLICE\[1\].RAM8.WORD\[1\].W.BYTE\[0\].B.BIT\[1\].OBUF0 SLICE_16\[0\].RAM16.SLICE\[1\].RAM8.WORD\[1\].W.BYTE\[0\].B.Q_WIRE\[1\]
+ SLICE_16\[0\].RAM16.SLICE\[1\].RAM8.WORD\[1\].W.BYTE\[0\].B.SEL0_B VGND VGND VPWR
+ VPWR SLICE_16\[0\].RAM16.BYTE\[0\].FLOATBUF0\[1\].Z sky130_fd_sc_hd__ebufn_2
XDo0MUX.M\[1\].MUX\[4\] Do0MUX.A0\[12\] Do0MUX.A1\[12\] Do0MUX.SEL\[1\] VGND VGND
+ VPWR VPWR Do0[12] sky130_fd_sc_hd__mux2_1
Xtap_32_28 VGND VPWR sky130_fd_sc_hd__tapvpwrvgnd_1
Xtap_32_17 VGND VPWR sky130_fd_sc_hd__tapvpwrvgnd_1
XSLICE_16\[1\].RAM16.SLICE\[0\].RAM8.DEC0.AND5 SLICE_16\[1\].RAM16.SLICE\[0\].RAM8.DEC0.A_buf\[1\]
+ SLICE_16\[1\].RAM16.SLICE\[0\].RAM8.DEC0.A_buf\[0\] SLICE_16\[1\].RAM16.SLICE\[0\].RAM8.DEC0.A_buf\[2\]
+ SLICE_16\[1\].RAM16.SLICE\[0\].RAM8.DEC0.EN_buf VGND VGND VPWR VPWR SLICE_16\[1\].RAM16.SLICE\[0\].RAM8.DEC0.SEL\[5\]
+ sky130_fd_sc_hd__and4b_2
XSLICE_16\[0\].RAM16.SLICE\[1\].RAM8.WORD\[5\].W.BYTE\[3\].B.BIT\[4\].OBUF0 SLICE_16\[0\].RAM16.SLICE\[1\].RAM8.WORD\[5\].W.BYTE\[3\].B.Q_WIRE\[4\]
+ SLICE_16\[0\].RAM16.SLICE\[1\].RAM8.WORD\[5\].W.BYTE\[3\].B.SEL0_B VGND VGND VPWR
+ VPWR SLICE_16\[0\].RAM16.BYTE\[3\].FLOATBUF0\[28\].Z sky130_fd_sc_hd__ebufn_2
Xtap_47_6 VGND VPWR sky130_fd_sc_hd__tapvpwrvgnd_1
XSLICE_16\[1\].RAM16.SLICE\[1\].RAM8.WORD\[3\].W.BYTE\[0\].B.genblk1.CG SLICE_16\[1\].RAM16.SLICE\[1\].RAM8.WORD\[3\].W.BYTE\[0\].B.CLK_B
+ SLICE_16\[1\].RAM16.SLICE\[1\].RAM8.WORD\[3\].W.BYTE\[0\].B.WE0_WIRE VGND VGND VPWR
+ VPWR SLICE_16\[1\].RAM16.SLICE\[1\].RAM8.WORD\[3\].W.BYTE\[0\].B.GCLK sky130_fd_sc_hd__dlclkp_1
Xfill_20_49 VGND VGND VPWR VPWR sky130_fd_sc_hd__decap_12
Xfill_20_38 VGND VGND VPWR VPWR sky130_fd_sc_hd__decap_12
Xfill_20_27 VGND VPWR sky130_fd_sc_hd__tapvpwrvgnd_1
Xfill_20_16 VGND VGND VPWR VPWR sky130_fd_sc_hd__decap_12
Xtap_3_10 VGND VPWR sky130_fd_sc_hd__tapvpwrvgnd_1
Xtap_3_21 VGND VPWR sky130_fd_sc_hd__tapvpwrvgnd_1
XSLICE_16\[0\].RAM16.SLICE\[0\].RAM8.WORD\[1\].W.BYTE\[0\].B.BIT\[7\].genblk1.STORAGE
+ DIBUF\[7\].X SLICE_16\[0\].RAM16.SLICE\[0\].RAM8.WORD\[1\].W.BYTE\[0\].B.GCLK VGND
+ VGND VPWR VPWR SLICE_16\[0\].RAM16.SLICE\[0\].RAM8.WORD\[1\].W.BYTE\[0\].B.Q_WIRE\[7\]
+ sky130_fd_sc_hd__dlxtp_1
Xtap_3_32 VGND VPWR sky130_fd_sc_hd__tapvpwrvgnd_1
Xfill_45_79 VGND VGND VPWR VPWR sky130_fd_sc_hd__decap_12
Xfill_45_68 VGND VGND VPWR VPWR sky130_fd_sc_hd__decap_12
Xfill_45_57 VGND VPWR sky130_fd_sc_hd__tapvpwrvgnd_1
Xfill_45_46 VGND VGND VPWR VPWR sky130_fd_sc_hd__decap_12
Xfill_45_35 VGND VGND VPWR VPWR sky130_fd_sc_hd__decap_12
Xfill_45_24 VGND VPWR sky130_fd_sc_hd__tapvpwrvgnd_1
Xfill_45_13 VGND VGND VPWR VPWR sky130_fd_sc_hd__decap_12
XSLICE_16\[0\].RAM16.SLICE\[0\].RAM8.WORD\[0\].W.BYTE\[2\].B.BIT\[3\].OBUF0 SLICE_16\[0\].RAM16.SLICE\[0\].RAM8.WORD\[0\].W.BYTE\[2\].B.Q_WIRE\[3\]
+ SLICE_16\[0\].RAM16.SLICE\[0\].RAM8.WORD\[0\].W.BYTE\[2\].B.SEL0_B VGND VGND VPWR
+ VPWR SLICE_16\[0\].RAM16.BYTE\[2\].FLOATBUF0\[19\].Z sky130_fd_sc_hd__ebufn_2
XSLICE_16\[1\].RAM16.SLICE\[1\].RAM8.WORD\[7\].W.BYTE\[2\].B.genblk1.CLKINV SLICE_16\[1\].RAM16.SLICE\[1\].RAM8.WORD\[7\].W.BYTE\[0\].B.CLK
+ VGND VGND VPWR VPWR SLICE_16\[1\].RAM16.SLICE\[1\].RAM8.WORD\[7\].W.BYTE\[2\].B.CLK_B
+ sky130_fd_sc_hd__inv_1
XSLICE_16\[1\].RAM16.SLICE\[1\].RAM8.WORD\[2\].W.BYTE\[2\].B.BIT\[0\].OBUF0 SLICE_16\[1\].RAM16.SLICE\[1\].RAM8.WORD\[2\].W.BYTE\[2\].B.Q_WIRE\[0\]
+ SLICE_16\[1\].RAM16.SLICE\[1\].RAM8.WORD\[2\].W.BYTE\[2\].B.SEL0_B VGND VGND VPWR
+ VPWR SLICE_16\[1\].RAM16.BYTE\[2\].FLOATBUF0\[16\].Z sky130_fd_sc_hd__ebufn_2
XDo0MUX.M\[0\].MUX\[6\] Do0MUX.A0\[6\] Do0MUX.A1\[6\] Do0MUX.SEL\[0\] VGND VGND VPWR
+ VPWR Do0[6] sky130_fd_sc_hd__mux2_1
XSLICE_16\[1\].RAM16.SLICE\[1\].RAM8.WORD\[1\].W.BYTE\[0\].B.SEL0INV SLICE_16\[1\].RAM16.SLICE\[1\].RAM8.WORD\[1\].W.BYTE\[0\].B.SEL0
+ VGND VGND VPWR VPWR SLICE_16\[1\].RAM16.SLICE\[1\].RAM8.WORD\[1\].W.BYTE\[0\].B.SEL0_B
+ sky130_fd_sc_hd__inv_1
Xfill_19_91 VGND VGND VPWR VPWR sky130_fd_sc_hd__decap_12
Xfill_19_80 VGND VGND VPWR VPWR sky130_fd_sc_hd__decap_12
XSLICE_16\[0\].RAM16.SLICE\[1\].RAM8.WORD\[4\].W.BYTE\[1\].B.BIT\[1\].OBUF0 SLICE_16\[0\].RAM16.SLICE\[1\].RAM8.WORD\[4\].W.BYTE\[1\].B.Q_WIRE\[1\]
+ SLICE_16\[0\].RAM16.SLICE\[1\].RAM8.WORD\[4\].W.BYTE\[1\].B.SEL0_B VGND VGND VPWR
+ VPWR SLICE_16\[0\].RAM16.BYTE\[1\].FLOATBUF0\[9\].Z sky130_fd_sc_hd__ebufn_2
Xfill_11_5 VGND VGND VPWR VPWR sky130_fd_sc_hd__decap_6
XDo0MUX.M\[2\].DIODE_A1MUX\[23\] Do0MUX.A1\[23\] VGND VGND VPWR VPWR sky130_fd_sc_hd__diode_2
XDo0MUX.M\[1\].DIODE_A0MUX\[9\] Do0MUX.A0\[9\] VGND VGND VPWR VPWR sky130_fd_sc_hd__diode_2
XSLICE_16\[1\].RAM16.SLICE\[1\].RAM8.WORD\[6\].W.BYTE\[1\].B.BIT\[5\].genblk1.STORAGE
+ DIBUF\[13\].X SLICE_16\[1\].RAM16.SLICE\[1\].RAM8.WORD\[6\].W.BYTE\[1\].B.GCLK VGND
+ VGND VPWR VPWR SLICE_16\[1\].RAM16.SLICE\[1\].RAM8.WORD\[6\].W.BYTE\[1\].B.Q_WIRE\[5\]
+ sky130_fd_sc_hd__dlxtp_1
XSLICE_16\[1\].RAM16.SLICE\[0\].RAM8.WORD\[3\].W.BYTE\[2\].B.CGAND SLICE_16\[1\].RAM16.SLICE\[0\].RAM8.WORD\[3\].W.BYTE\[0\].B.SEL0
+ SLICE_16\[1\].RAM16.SLICE\[0\].RAM8.WE0_buf\[2\] VGND VGND VPWR VPWR SLICE_16\[1\].RAM16.SLICE\[0\].RAM8.WORD\[3\].W.BYTE\[2\].B.WE0_WIRE
+ sky130_fd_sc_hd__and2_1
XSLICE_16\[0\].RAM16.BYTE\[1\].FLOATBUF0\[12\].__cell__ SLICE_16\[0\].RAM16.BYTE\[1\].FLOATBUF0\[10\].A
+ SLICE_16\[0\].RAM16.BYTE\[1\].FLOATBUF0\[10\].TE_B VGND VGND VPWR VPWR SLICE_16\[0\].RAM16.BYTE\[1\].FLOATBUF0\[12\].Z
+ sky130_fd_sc_hd__ebufn_2
XSLICE_16\[1\].RAM16.SLICE\[1\].RAM8.WORD\[0\].W.BYTE\[2\].B.BIT\[6\].genblk1.STORAGE
+ DIBUF\[22\].X SLICE_16\[1\].RAM16.SLICE\[1\].RAM8.WORD\[0\].W.BYTE\[2\].B.GCLK VGND
+ VGND VPWR VPWR SLICE_16\[1\].RAM16.SLICE\[1\].RAM8.WORD\[0\].W.BYTE\[2\].B.Q_WIRE\[6\]
+ sky130_fd_sc_hd__dlxtp_1
XSLICE_16\[1\].RAM16.SLICE\[0\].RAM8.WORD\[7\].W.BYTE\[3\].B.BIT\[1\].genblk1.STORAGE
+ DIBUF\[25\].X SLICE_16\[1\].RAM16.SLICE\[0\].RAM8.WORD\[7\].W.BYTE\[3\].B.GCLK VGND
+ VGND VPWR VPWR SLICE_16\[1\].RAM16.SLICE\[0\].RAM8.WORD\[7\].W.BYTE\[3\].B.Q_WIRE\[1\]
+ sky130_fd_sc_hd__dlxtp_1
Xtap_27_28 VGND VPWR sky130_fd_sc_hd__tapvpwrvgnd_1
Xtap_27_17 VGND VPWR sky130_fd_sc_hd__tapvpwrvgnd_1
XSLICE_16\[0\].RAM16.SLICE\[0\].RAM8.WORD\[3\].W.BYTE\[3\].B.BIT\[3\].OBUF0 SLICE_16\[0\].RAM16.SLICE\[0\].RAM8.WORD\[3\].W.BYTE\[3\].B.Q_WIRE\[3\]
+ SLICE_16\[0\].RAM16.SLICE\[0\].RAM8.WORD\[3\].W.BYTE\[3\].B.SEL0_B VGND VGND VPWR
+ VPWR SLICE_16\[0\].RAM16.BYTE\[3\].FLOATBUF0\[27\].Z sky130_fd_sc_hd__ebufn_2
XSLICE_16\[0\].RAM16.SLICE\[0\].RAM8.WORD\[4\].W.BYTE\[0\].B.genblk1.CLKINV SLICE_16\[0\].RAM16.SLICE\[0\].RAM8.WORD\[4\].W.BYTE\[0\].B.CLK
+ VGND VGND VPWR VPWR SLICE_16\[0\].RAM16.SLICE\[0\].RAM8.WORD\[4\].W.BYTE\[0\].B.CLK_B
+ sky130_fd_sc_hd__inv_1
XSLICE_16\[1\].RAM16.SLICE\[0\].RAM8.WORD\[5\].W.BYTE\[1\].B.BIT\[0\].genblk1.STORAGE
+ DIBUF\[8\].X SLICE_16\[1\].RAM16.SLICE\[0\].RAM8.WORD\[5\].W.BYTE\[1\].B.GCLK VGND
+ VGND VPWR VPWR SLICE_16\[1\].RAM16.SLICE\[0\].RAM8.WORD\[5\].W.BYTE\[1\].B.Q_WIRE\[0\]
+ sky130_fd_sc_hd__dlxtp_1
XSLICE_16\[1\].RAM16.SLICE\[1\].RAM8.WORD\[5\].W.BYTE\[3\].B.BIT\[0\].OBUF0 SLICE_16\[1\].RAM16.SLICE\[1\].RAM8.WORD\[5\].W.BYTE\[3\].B.Q_WIRE\[0\]
+ SLICE_16\[1\].RAM16.SLICE\[1\].RAM8.WORD\[5\].W.BYTE\[3\].B.SEL0_B VGND VGND VPWR
+ VPWR SLICE_16\[1\].RAM16.BYTE\[3\].FLOATBUF0\[24\].Z sky130_fd_sc_hd__ebufn_2
XSLICE_16\[0\].RAM16.SLICE\[1\].RAM8.WORD\[7\].W.BYTE\[1\].B.BIT\[1\].genblk1.STORAGE
+ DIBUF\[9\].X SLICE_16\[0\].RAM16.SLICE\[1\].RAM8.WORD\[7\].W.BYTE\[1\].B.GCLK VGND
+ VGND VPWR VPWR SLICE_16\[0\].RAM16.SLICE\[1\].RAM8.WORD\[7\].W.BYTE\[1\].B.Q_WIRE\[1\]
+ sky130_fd_sc_hd__dlxtp_1
XSLICE_16\[0\].RAM16.SLICE\[1\].RAM8.WORD\[1\].W.BYTE\[2\].B.BIT\[2\].genblk1.STORAGE
+ DIBUF\[18\].X SLICE_16\[0\].RAM16.SLICE\[1\].RAM8.WORD\[1\].W.BYTE\[2\].B.GCLK VGND
+ VGND VPWR VPWR SLICE_16\[0\].RAM16.SLICE\[1\].RAM8.WORD\[1\].W.BYTE\[2\].B.Q_WIRE\[2\]
+ sky130_fd_sc_hd__dlxtp_1
Xtap_38_2 VGND VPWR sky130_fd_sc_hd__tapvpwrvgnd_1
XDo0MUX.M\[3\].DIODE_A1MUX\[27\] Do0MUX.A1\[27\] VGND VGND VPWR VPWR sky130_fd_sc_hd__diode_2
XSLICE_16\[1\].RAM16.SLICE\[1\].RAM8.WORD\[2\].W.BYTE\[0\].B.BIT\[5\].OBUF0 SLICE_16\[1\].RAM16.SLICE\[1\].RAM8.WORD\[2\].W.BYTE\[0\].B.Q_WIRE\[5\]
+ SLICE_16\[1\].RAM16.SLICE\[1\].RAM8.WORD\[2\].W.BYTE\[0\].B.SEL0_B VGND VGND VPWR
+ VPWR SLICE_16\[1\].RAM16.BYTE\[0\].FLOATBUF0\[5\].Z sky130_fd_sc_hd__ebufn_2
XSLICE_16\[0\].RAM16.SLICE\[1\].RAM8.WORD\[7\].W.BYTE\[2\].B.BIT\[1\].OBUF0 SLICE_16\[0\].RAM16.SLICE\[1\].RAM8.WORD\[7\].W.BYTE\[2\].B.Q_WIRE\[1\]
+ SLICE_16\[0\].RAM16.SLICE\[1\].RAM8.WORD\[7\].W.BYTE\[2\].B.SEL0_B VGND VGND VPWR
+ VPWR SLICE_16\[0\].RAM16.BYTE\[2\].FLOATBUF0\[17\].Z sky130_fd_sc_hd__ebufn_2
XSLICE_16\[0\].RAM16.SLICE\[0\].RAM8.WORD\[2\].W.BYTE\[1\].B.BIT\[0\].OBUF0 SLICE_16\[0\].RAM16.SLICE\[0\].RAM8.WORD\[2\].W.BYTE\[1\].B.Q_WIRE\[0\]
+ SLICE_16\[0\].RAM16.SLICE\[0\].RAM8.WORD\[2\].W.BYTE\[1\].B.SEL0_B VGND VGND VPWR
+ VPWR SLICE_16\[0\].RAM16.BYTE\[1\].FLOATBUF0\[8\].Z sky130_fd_sc_hd__ebufn_2
XSLICE_16\[0\].RAM16.SLICE\[0\].RAM8.WORD\[4\].W.BYTE\[1\].B.BIT\[7\].genblk1.STORAGE
+ DIBUF\[15\].X SLICE_16\[0\].RAM16.SLICE\[0\].RAM8.WORD\[4\].W.BYTE\[1\].B.GCLK VGND
+ VGND VPWR VPWR SLICE_16\[0\].RAM16.SLICE\[0\].RAM8.WORD\[4\].W.BYTE\[1\].B.Q_WIRE\[7\]
+ sky130_fd_sc_hd__dlxtp_1
XSLICE_16\[1\].RAM16.SLICE\[0\].RAM8.WORD\[1\].W.BYTE\[2\].B.BIT\[7\].OBUF0 SLICE_16\[1\].RAM16.SLICE\[0\].RAM8.WORD\[1\].W.BYTE\[2\].B.Q_WIRE\[7\]
+ SLICE_16\[1\].RAM16.SLICE\[0\].RAM8.WORD\[1\].W.BYTE\[2\].B.SEL0_B VGND VGND VPWR
+ VPWR SLICE_16\[1\].RAM16.BYTE\[2\].FLOATBUF0\[23\].Z sky130_fd_sc_hd__ebufn_2
Xfill_21_92 VGND VGND VPWR VPWR sky130_fd_sc_hd__decap_12
Xfill_21_81 VGND VPWR sky130_fd_sc_hd__tapvpwrvgnd_1
Xfill_21_70 VGND VGND VPWR VPWR sky130_fd_sc_hd__decap_12
XSLICE_16\[0\].RAM16.SLICE\[0\].RAM8.WORD\[7\].W.BYTE\[1\].B.genblk1.CLKINV SLICE_16\[0\].RAM16.SLICE\[0\].RAM8.WORD\[7\].W.BYTE\[0\].B.CLK
+ VGND VGND VPWR VPWR SLICE_16\[0\].RAM16.SLICE\[0\].RAM8.WORD\[7\].W.BYTE\[1\].B.CLK_B
+ sky130_fd_sc_hd__inv_1
Xfill_7_4 VGND VPWR sky130_fd_sc_hd__tapvpwrvgnd_1
Xtap_13_19 VGND VPWR sky130_fd_sc_hd__tapvpwrvgnd_1
Xtap_38_27 VGND VPWR sky130_fd_sc_hd__tapvpwrvgnd_1
Xtap_38_16 VGND VPWR sky130_fd_sc_hd__tapvpwrvgnd_1
XSLICE_16\[1\].RAM16.SLICE\[1\].RAM8.WORD\[4\].W.BYTE\[1\].B.CGAND SLICE_16\[1\].RAM16.SLICE\[1\].RAM8.WORD\[4\].W.BYTE\[0\].B.SEL0
+ SLICE_16\[1\].RAM16.SLICE\[1\].RAM8.WE0_buf\[1\] VGND VGND VPWR VPWR SLICE_16\[1\].RAM16.SLICE\[1\].RAM8.WORD\[4\].W.BYTE\[1\].B.WE0_WIRE
+ sky130_fd_sc_hd__and2_1
Xtap_31_9 VGND VPWR sky130_fd_sc_hd__tapvpwrvgnd_1
XSLICE_16\[1\].RAM16.SLICE\[1\].RAM8.WORD\[5\].W.BYTE\[1\].B.BIT\[5\].OBUF0 SLICE_16\[1\].RAM16.SLICE\[1\].RAM8.WORD\[5\].W.BYTE\[1\].B.Q_WIRE\[5\]
+ SLICE_16\[1\].RAM16.SLICE\[1\].RAM8.WORD\[5\].W.BYTE\[1\].B.SEL0_B VGND VGND VPWR
+ VPWR SLICE_16\[1\].RAM16.BYTE\[1\].FLOATBUF0\[13\].Z sky130_fd_sc_hd__ebufn_2
Xtap_24_8 VGND VPWR sky130_fd_sc_hd__tapvpwrvgnd_1
Xtap_17_7 VGND VPWR sky130_fd_sc_hd__tapvpwrvgnd_1
Xtap_0_22 VGND VPWR sky130_fd_sc_hd__tapvpwrvgnd_1
Xtap_0_11 VGND VPWR sky130_fd_sc_hd__tapvpwrvgnd_1
XSLICE_16\[1\].RAM16.SLICE\[1\].RAM8.WORD\[3\].W.BYTE\[3\].B.BIT\[6\].genblk1.STORAGE
+ DIBUF\[30\].X SLICE_16\[1\].RAM16.SLICE\[1\].RAM8.WORD\[3\].W.BYTE\[3\].B.GCLK VGND
+ VGND VPWR VPWR SLICE_16\[1\].RAM16.SLICE\[1\].RAM8.WORD\[3\].W.BYTE\[3\].B.Q_WIRE\[6\]
+ sky130_fd_sc_hd__dlxtp_1
Xtap_9_20 VGND VPWR sky130_fd_sc_hd__tapvpwrvgnd_1
Xtap_9_31 VGND VPWR sky130_fd_sc_hd__tapvpwrvgnd_1
Xfill_42_69 VGND VPWR sky130_fd_sc_hd__tapvpwrvgnd_1
Xfill_42_58 VGND VGND VPWR VPWR sky130_fd_sc_hd__decap_12
Xfill_42_47 VGND VGND VPWR VPWR sky130_fd_sc_hd__decap_12
Xfill_42_36 VGND VPWR sky130_fd_sc_hd__tapvpwrvgnd_1
Xfill_42_25 VGND VGND VPWR VPWR sky130_fd_sc_hd__decap_12
Xfill_42_14 VGND VGND VPWR VPWR sky130_fd_sc_hd__decap_12
XSLICE_16\[1\].RAM16.SLICE\[1\].RAM8.WORD\[7\].W.BYTE\[0\].B.BIT\[4\].genblk1.STORAGE
+ DIBUF\[4\].X SLICE_16\[1\].RAM16.SLICE\[1\].RAM8.WORD\[7\].W.BYTE\[0\].B.GCLK VGND
+ VGND VPWR VPWR SLICE_16\[1\].RAM16.SLICE\[1\].RAM8.WORD\[7\].W.BYTE\[0\].B.Q_WIRE\[4\]
+ sky130_fd_sc_hd__dlxtp_1
XSLICE_16\[1\].RAM16.SLICE\[1\].RAM8.WORD\[1\].W.BYTE\[1\].B.BIT\[5\].genblk1.STORAGE
+ DIBUF\[13\].X SLICE_16\[1\].RAM16.SLICE\[1\].RAM8.WORD\[1\].W.BYTE\[1\].B.GCLK VGND
+ VGND VPWR VPWR SLICE_16\[1\].RAM16.SLICE\[1\].RAM8.WORD\[1\].W.BYTE\[1\].B.Q_WIRE\[5\]
+ sky130_fd_sc_hd__dlxtp_1
XSLICE_16\[1\].RAM16.SLICE\[0\].RAM8.WORD\[0\].W.BYTE\[0\].B.BIT\[4\].OBUF0 SLICE_16\[1\].RAM16.SLICE\[0\].RAM8.WORD\[0\].W.BYTE\[0\].B.Q_WIRE\[4\]
+ SLICE_16\[1\].RAM16.SLICE\[0\].RAM8.WORD\[0\].W.BYTE\[0\].B.SEL0_B VGND VGND VPWR
+ VPWR SLICE_16\[1\].RAM16.BYTE\[0\].FLOATBUF0\[4\].Z sky130_fd_sc_hd__ebufn_2
XSLICE_16\[0\].RAM16.SLICE\[1\].RAM8.WORD\[7\].W.BYTE\[0\].B.BIT\[6\].OBUF0 SLICE_16\[0\].RAM16.SLICE\[1\].RAM8.WORD\[7\].W.BYTE\[0\].B.Q_WIRE\[6\]
+ SLICE_16\[0\].RAM16.SLICE\[1\].RAM8.WORD\[7\].W.BYTE\[0\].B.SEL0_B VGND VGND VPWR
+ VPWR SLICE_16\[0\].RAM16.BYTE\[0\].FLOATBUF0\[6\].Z sky130_fd_sc_hd__ebufn_2
XSLICE_16\[0\].RAM16.SLICE\[0\].RAM8.WORD\[5\].W.BYTE\[2\].B.BIT\[0\].OBUF0 SLICE_16\[0\].RAM16.SLICE\[0\].RAM8.WORD\[5\].W.BYTE\[2\].B.Q_WIRE\[0\]
+ SLICE_16\[0\].RAM16.SLICE\[0\].RAM8.WORD\[5\].W.BYTE\[2\].B.SEL0_B VGND VGND VPWR
+ VPWR SLICE_16\[0\].RAM16.BYTE\[2\].FLOATBUF0\[16\].Z sky130_fd_sc_hd__ebufn_2
Xtap_43_0 VGND VPWR sky130_fd_sc_hd__tapvpwrvgnd_1
XSLICE_16\[1\].RAM16.SLICE\[0\].RAM8.WORD\[5\].W.CLKBUF SLICE_16\[1\].RAM16.SLICE\[0\].RAM8.CLKBUF.X
+ VGND VGND VPWR VPWR SLICE_16\[1\].RAM16.SLICE\[0\].RAM8.WORD\[5\].W.BYTE\[0\].B.CLK
+ sky130_fd_sc_hd__clkbuf_4
XSLICE_16\[1\].RAM16.SLICE\[0\].RAM8.WORD\[4\].W.BYTE\[3\].B.BIT\[7\].OBUF0 SLICE_16\[1\].RAM16.SLICE\[0\].RAM8.WORD\[4\].W.BYTE\[3\].B.Q_WIRE\[7\]
+ SLICE_16\[1\].RAM16.SLICE\[0\].RAM8.WORD\[4\].W.BYTE\[3\].B.SEL0_B VGND VGND VPWR
+ VPWR SLICE_16\[1\].RAM16.BYTE\[3\].FLOATBUF0\[31\].Z sky130_fd_sc_hd__ebufn_2
XSLICE_16\[1\].RAM16.SLICE\[0\].RAM8.WORD\[2\].W.BYTE\[3\].B.BIT\[1\].genblk1.STORAGE
+ DIBUF\[25\].X SLICE_16\[1\].RAM16.SLICE\[0\].RAM8.WORD\[2\].W.BYTE\[3\].B.GCLK VGND
+ VGND VPWR VPWR SLICE_16\[1\].RAM16.SLICE\[0\].RAM8.WORD\[2\].W.BYTE\[3\].B.Q_WIRE\[1\]
+ sky130_fd_sc_hd__dlxtp_1
XDIBUF\[23\].__cell__ Di0[23] VGND VGND VPWR VPWR DIBUF\[23\].X sky130_fd_sc_hd__clkbuf_16
XSLICE_16\[1\].RAM16.SLICE\[0\].RAM8.WORD\[0\].W.BYTE\[1\].B.BIT\[0\].genblk1.STORAGE
+ DIBUF\[8\].X SLICE_16\[1\].RAM16.SLICE\[0\].RAM8.WORD\[0\].W.BYTE\[1\].B.GCLK VGND
+ VGND VPWR VPWR SLICE_16\[1\].RAM16.SLICE\[0\].RAM8.WORD\[0\].W.BYTE\[1\].B.Q_WIRE\[0\]
+ sky130_fd_sc_hd__dlxtp_1
XSLICE_16\[0\].RAM16.SLICE\[1\].RAM8.WORD\[4\].W.BYTE\[3\].B.BIT\[2\].genblk1.STORAGE
+ DIBUF\[26\].X SLICE_16\[0\].RAM16.SLICE\[1\].RAM8.WORD\[4\].W.BYTE\[3\].B.GCLK VGND
+ VGND VPWR VPWR SLICE_16\[0\].RAM16.SLICE\[1\].RAM8.WORD\[4\].W.BYTE\[3\].B.Q_WIRE\[2\]
+ sky130_fd_sc_hd__dlxtp_1
XSLICE_16\[0\].RAM16.SLICE\[1\].RAM8.WORD\[2\].W.BYTE\[1\].B.BIT\[1\].genblk1.STORAGE
+ DIBUF\[9\].X SLICE_16\[0\].RAM16.SLICE\[1\].RAM8.WORD\[2\].W.BYTE\[1\].B.GCLK VGND
+ VGND VPWR VPWR SLICE_16\[0\].RAM16.SLICE\[1\].RAM8.WORD\[2\].W.BYTE\[1\].B.Q_WIRE\[1\]
+ sky130_fd_sc_hd__dlxtp_1
XSLICE_16\[0\].RAM16.SLICE\[1\].RAM8.WORD\[6\].W.BYTE\[3\].B.CGAND SLICE_16\[0\].RAM16.SLICE\[1\].RAM8.WORD\[6\].W.BYTE\[0\].B.SEL0
+ SLICE_16\[0\].RAM16.SLICE\[1\].RAM8.WE0_buf\[3\] VGND VGND VPWR VPWR SLICE_16\[0\].RAM16.SLICE\[1\].RAM8.WORD\[6\].W.BYTE\[3\].B.WE0_WIRE
+ sky130_fd_sc_hd__and2_1
Xtap_24_29 VGND VPWR sky130_fd_sc_hd__tapvpwrvgnd_1
Xtap_24_18 VGND VPWR sky130_fd_sc_hd__tapvpwrvgnd_1
Xfill_5_1 VGND VGND VPWR VPWR sky130_fd_sc_hd__decap_4
XSLICE_16\[0\].RAM16.SLICE\[0\].RAM8.WORD\[7\].W.BYTE\[2\].B.BIT\[7\].genblk1.STORAGE
+ DIBUF\[23\].X SLICE_16\[0\].RAM16.SLICE\[0\].RAM8.WORD\[7\].W.BYTE\[2\].B.GCLK VGND
+ VGND VPWR VPWR SLICE_16\[0\].RAM16.SLICE\[0\].RAM8.WORD\[7\].W.BYTE\[2\].B.Q_WIRE\[7\]
+ sky130_fd_sc_hd__dlxtp_1
XSLICE_16\[0\].RAM16.SLICE\[1\].RAM8.WORD\[1\].W.BYTE\[0\].B.genblk1.CLKINV SLICE_16\[0\].RAM16.SLICE\[1\].RAM8.WORD\[1\].W.BYTE\[0\].B.CLK
+ VGND VGND VPWR VPWR SLICE_16\[0\].RAM16.SLICE\[1\].RAM8.WORD\[1\].W.BYTE\[0\].B.CLK_B
+ sky130_fd_sc_hd__inv_1
Xtap_40_28 VGND VPWR sky130_fd_sc_hd__tapvpwrvgnd_1
Xtap_40_17 VGND VPWR sky130_fd_sc_hd__tapvpwrvgnd_1
XSLICE_16\[1\].RAM16.Do0_REG.OUTREG_BYTE\[1\].DIODE\[4\] SLICE_16\[1\].RAM16.BYTE\[1\].FLOATBUF0\[12\].Z
+ VGND VGND VPWR VPWR sky130_fd_sc_hd__diode_2
XSLICE_16\[1\].RAM16.SLICE\[0\].RAM8.WORD\[5\].W.SEL0BUF SLICE_16\[1\].RAM16.SLICE\[0\].RAM8.DEC0.SEL\[5\]
+ VGND VGND VPWR VPWR SLICE_16\[1\].RAM16.SLICE\[0\].RAM8.WORD\[5\].W.BYTE\[0\].B.SEL0
+ sky130_fd_sc_hd__clkbuf_2
XSLICE_16\[1\].RAM16.SLICE\[0\].RAM8.WORD\[3\].W.BYTE\[1\].B.BIT\[4\].OBUF0 SLICE_16\[1\].RAM16.SLICE\[0\].RAM8.WORD\[3\].W.BYTE\[1\].B.Q_WIRE\[4\]
+ SLICE_16\[1\].RAM16.SLICE\[0\].RAM8.WORD\[3\].W.BYTE\[1\].B.SEL0_B VGND VGND VPWR
+ VPWR SLICE_16\[1\].RAM16.BYTE\[1\].FLOATBUF0\[12\].Z sky130_fd_sc_hd__ebufn_2
XSLICE_16\[0\].RAM16.SLICE\[0\].RAM8.WORD\[5\].W.BYTE\[0\].B.BIT\[6\].genblk1.STORAGE
+ DIBUF\[6\].X SLICE_16\[0\].RAM16.SLICE\[0\].RAM8.WORD\[5\].W.BYTE\[0\].B.GCLK VGND
+ VGND VPWR VPWR SLICE_16\[0\].RAM16.SLICE\[0\].RAM8.WORD\[5\].W.BYTE\[0\].B.Q_WIRE\[6\]
+ sky130_fd_sc_hd__dlxtp_1
XSLICE_16\[0\].RAM16.SLICE\[1\].RAM8.WORD\[0\].W.BYTE\[3\].B.BIT\[3\].OBUF0 SLICE_16\[0\].RAM16.SLICE\[1\].RAM8.WORD\[0\].W.BYTE\[3\].B.Q_WIRE\[3\]
+ SLICE_16\[0\].RAM16.SLICE\[1\].RAM8.WORD\[0\].W.BYTE\[3\].B.SEL0_B VGND VGND VPWR
+ VPWR SLICE_16\[0\].RAM16.BYTE\[3\].FLOATBUF0\[27\].Z sky130_fd_sc_hd__ebufn_2
Xtap_15_4 VGND VPWR sky130_fd_sc_hd__tapvpwrvgnd_1
XSLICE_16\[0\].RAM16.SLICE\[0\].RAM8.WORD\[5\].W.BYTE\[0\].B.BIT\[5\].OBUF0 SLICE_16\[0\].RAM16.SLICE\[0\].RAM8.WORD\[5\].W.BYTE\[0\].B.Q_WIRE\[5\]
+ SLICE_16\[0\].RAM16.SLICE\[0\].RAM8.WORD\[5\].W.BYTE\[0\].B.SEL0_B VGND VGND VPWR
+ VPWR SLICE_16\[0\].RAM16.BYTE\[0\].FLOATBUF0\[5\].Z sky130_fd_sc_hd__ebufn_2
Xtap_8_3 VGND VPWR sky130_fd_sc_hd__tapvpwrvgnd_1
XSLICE_16\[0\].RAM16.SLICE\[1\].RAM8.WORD\[2\].W.BYTE\[0\].B.genblk1.CG SLICE_16\[0\].RAM16.SLICE\[1\].RAM8.WORD\[2\].W.BYTE\[0\].B.CLK_B
+ SLICE_16\[0\].RAM16.SLICE\[1\].RAM8.WORD\[2\].W.BYTE\[0\].B.WE0_WIRE VGND VGND VPWR
+ VPWR SLICE_16\[0\].RAM16.SLICE\[1\].RAM8.WORD\[2\].W.BYTE\[0\].B.GCLK sky130_fd_sc_hd__dlclkp_1
XSLICE_16\[1\].RAM16.SLICE\[1\].RAM8.WORD\[7\].W.BYTE\[0\].B.BIT\[2\].OBUF0 SLICE_16\[1\].RAM16.SLICE\[1\].RAM8.WORD\[7\].W.BYTE\[0\].B.Q_WIRE\[2\]
+ SLICE_16\[1\].RAM16.SLICE\[1\].RAM8.WORD\[7\].W.BYTE\[0\].B.SEL0_B VGND VGND VPWR
+ VPWR SLICE_16\[1\].RAM16.BYTE\[0\].FLOATBUF0\[2\].Z sky130_fd_sc_hd__ebufn_2
Xfill_0_19 VGND VGND VPWR VPWR sky130_fd_sc_hd__decap_12
XSLICE_16\[1\].RAM16.SLICE\[1\].RAM8.WORD\[4\].W.BYTE\[3\].B.genblk1.CG SLICE_16\[1\].RAM16.SLICE\[1\].RAM8.WORD\[4\].W.BYTE\[3\].B.CLK_B
+ SLICE_16\[1\].RAM16.SLICE\[1\].RAM8.WORD\[4\].W.BYTE\[3\].B.WE0_WIRE VGND VGND VPWR
+ VPWR SLICE_16\[1\].RAM16.SLICE\[1\].RAM8.WORD\[4\].W.BYTE\[3\].B.GCLK sky130_fd_sc_hd__dlclkp_1
XSLICE_16\[0\].RAM16.Do0_REG.OUTREG_BYTE\[3\].DIODE\[1\] SLICE_16\[0\].RAM16.BYTE\[3\].FLOATBUF0\[25\].Z
+ VGND VGND VPWR VPWR sky130_fd_sc_hd__diode_2
Xfill_43_8 VGND VGND VPWR VPWR sky130_fd_sc_hd__decap_12
Xfill_46_137 VGND VGND VPWR VPWR sky130_fd_sc_hd__decap_12
Xfill_46_126 VGND VPWR sky130_fd_sc_hd__tapvpwrvgnd_1
Xfill_46_115 VGND VGND VPWR VPWR sky130_fd_sc_hd__decap_12
Xfill_46_104 VGND VGND VPWR VPWR sky130_fd_sc_hd__decap_12
Xfill_36_7 VGND VPWR sky130_fd_sc_hd__tapvpwrvgnd_1
XSLICE_16\[1\].RAM16.SLICE\[1\].RAM8.WORD\[4\].W.BYTE\[2\].B.BIT\[5\].genblk1.STORAGE
+ DIBUF\[21\].X SLICE_16\[1\].RAM16.SLICE\[1\].RAM8.WORD\[4\].W.BYTE\[2\].B.GCLK VGND
+ VGND VPWR VPWR SLICE_16\[1\].RAM16.SLICE\[1\].RAM8.WORD\[4\].W.BYTE\[2\].B.Q_WIRE\[5\]
+ sky130_fd_sc_hd__dlxtp_1
XSLICE_16\[0\].RAM16.SLICE\[1\].RAM8.WORD\[4\].W.BYTE\[1\].B.genblk1.CLKINV SLICE_16\[0\].RAM16.SLICE\[1\].RAM8.WORD\[4\].W.BYTE\[0\].B.CLK
+ VGND VGND VPWR VPWR SLICE_16\[0\].RAM16.SLICE\[1\].RAM8.WORD\[4\].W.BYTE\[1\].B.CLK_B
+ sky130_fd_sc_hd__inv_1
Xfill_43_90 VGND VPWR sky130_fd_sc_hd__tapvpwrvgnd_1
XSLICE_16\[1\].RAM16.SLICE\[1\].RAM8.WORD\[2\].W.BYTE\[0\].B.BIT\[4\].genblk1.STORAGE
+ DIBUF\[4\].X SLICE_16\[1\].RAM16.SLICE\[1\].RAM8.WORD\[2\].W.BYTE\[0\].B.GCLK VGND
+ VGND VPWR VPWR SLICE_16\[1\].RAM16.SLICE\[1\].RAM8.WORD\[2\].W.BYTE\[0\].B.Q_WIRE\[4\]
+ sky130_fd_sc_hd__dlxtp_1
XSLICE_16\[1\].RAM16.SLICE\[0\].RAM8.WORD\[6\].W.BYTE\[2\].B.BIT\[4\].OBUF0 SLICE_16\[1\].RAM16.SLICE\[0\].RAM8.WORD\[6\].W.BYTE\[2\].B.Q_WIRE\[4\]
+ SLICE_16\[1\].RAM16.SLICE\[0\].RAM8.WORD\[6\].W.BYTE\[2\].B.SEL0_B VGND VGND VPWR
+ VPWR SLICE_16\[1\].RAM16.BYTE\[2\].FLOATBUF0\[20\].Z sky130_fd_sc_hd__ebufn_2
XSLICE_16\[1\].RAM16.SLICE\[0\].RAM8.WORD\[3\].W.BYTE\[2\].B.BIT\[0\].genblk1.STORAGE
+ DIBUF\[16\].X SLICE_16\[1\].RAM16.SLICE\[0\].RAM8.WORD\[3\].W.BYTE\[2\].B.GCLK VGND
+ VGND VPWR VPWR SLICE_16\[1\].RAM16.SLICE\[0\].RAM8.WORD\[3\].W.BYTE\[2\].B.Q_WIRE\[0\]
+ sky130_fd_sc_hd__dlxtp_1
XSLICE_16\[0\].RAM16.SLICE\[1\].RAM8.WORD\[5\].W.BYTE\[2\].B.BIT\[1\].genblk1.STORAGE
+ DIBUF\[17\].X SLICE_16\[0\].RAM16.SLICE\[1\].RAM8.WORD\[5\].W.BYTE\[2\].B.GCLK VGND
+ VGND VPWR VPWR SLICE_16\[0\].RAM16.SLICE\[1\].RAM8.WORD\[5\].W.BYTE\[2\].B.Q_WIRE\[1\]
+ sky130_fd_sc_hd__dlxtp_1
XSLICE_16\[1\].RAM16.Do0_REG.OUTREG_BYTE\[0\].Do_FF\[5\] SLICE_16\[1\].RAM16.Do0_REG.CLKBUF\[0\]
+ SLICE_16\[1\].RAM16.BYTE\[0\].FLOATBUF0\[5\].Z VGND VGND VPWR VPWR Do0MUX.A1\[5\]
+ sky130_fd_sc_hd__dfxtp_1
Xtap_35_28 VGND VPWR sky130_fd_sc_hd__tapvpwrvgnd_1
Xtap_35_17 VGND VPWR sky130_fd_sc_hd__tapvpwrvgnd_1
XSLICE_16\[0\].RAM16.SLICE\[1\].RAM8.WORD\[3\].W.BYTE\[0\].B.BIT\[0\].genblk1.STORAGE
+ DIBUF\[0\].X SLICE_16\[0\].RAM16.SLICE\[1\].RAM8.WORD\[3\].W.BYTE\[0\].B.GCLK VGND
+ VGND VPWR VPWR SLICE_16\[0\].RAM16.SLICE\[1\].RAM8.WORD\[3\].W.BYTE\[0\].B.Q_WIRE\[0\]
+ sky130_fd_sc_hd__dlxtp_1
XDIBUF\[7\].__cell__ Di0[7] VGND VGND VPWR VPWR DIBUF\[7\].X sky130_fd_sc_hd__clkbuf_16
XSLICE_16\[0\].RAM16.SLICE\[0\].RAM8.WORD\[2\].W.BYTE\[0\].B.DIODE_CLK SLICE_16\[0\].RAM16.SLICE\[0\].RAM8.WORD\[2\].W.BYTE\[0\].B.CLK
+ VGND VGND VPWR VPWR sky130_fd_sc_hd__diode_2
Xtap_6_10 VGND VPWR sky130_fd_sc_hd__tapvpwrvgnd_1
Xtap_6_21 VGND VPWR sky130_fd_sc_hd__tapvpwrvgnd_1
Xtap_6_32 VGND VPWR sky130_fd_sc_hd__tapvpwrvgnd_1
XSLICE_16\[1\].RAM16.SLICE\[0\].RAM8.WORD\[5\].W.BYTE\[0\].B.BIT\[1\].OBUF0 SLICE_16\[1\].RAM16.SLICE\[0\].RAM8.WORD\[5\].W.BYTE\[0\].B.Q_WIRE\[1\]
+ SLICE_16\[1\].RAM16.SLICE\[0\].RAM8.WORD\[5\].W.BYTE\[0\].B.SEL0_B VGND VGND VPWR
+ VPWR SLICE_16\[1\].RAM16.BYTE\[0\].FLOATBUF0\[1\].Z sky130_fd_sc_hd__ebufn_2
Xtap_13_1 VGND VPWR sky130_fd_sc_hd__tapvpwrvgnd_1
XSLICE_16\[0\].RAM16.SLICE\[0\].RAM8.WORD\[1\].W.BYTE\[3\].B.CGAND SLICE_16\[0\].RAM16.SLICE\[0\].RAM8.WORD\[1\].W.BYTE\[0\].B.SEL0
+ SLICE_16\[0\].RAM16.SLICE\[0\].RAM8.WE0_buf\[3\] VGND VGND VPWR VPWR SLICE_16\[0\].RAM16.SLICE\[0\].RAM8.WORD\[1\].W.BYTE\[3\].B.WE0_WIRE
+ sky130_fd_sc_hd__and2_1
XSLICE_16\[0\].RAM16.SLICE\[1\].RAM8.WORD\[2\].W.BYTE\[2\].B.BIT\[0\].OBUF0 SLICE_16\[0\].RAM16.SLICE\[1\].RAM8.WORD\[2\].W.BYTE\[2\].B.Q_WIRE\[0\]
+ SLICE_16\[0\].RAM16.SLICE\[1\].RAM8.WORD\[2\].W.BYTE\[2\].B.SEL0_B VGND VGND VPWR
+ VPWR SLICE_16\[0\].RAM16.BYTE\[2\].FLOATBUF0\[16\].Z sky130_fd_sc_hd__ebufn_2
XSLICE_16\[1\].RAM16.SLICE\[1\].RAM8.WORD\[1\].W.BYTE\[3\].B.BIT\[7\].OBUF0 SLICE_16\[1\].RAM16.SLICE\[1\].RAM8.WORD\[1\].W.BYTE\[3\].B.Q_WIRE\[7\]
+ SLICE_16\[1\].RAM16.SLICE\[1\].RAM8.WORD\[1\].W.BYTE\[3\].B.SEL0_B VGND VGND VPWR
+ VPWR SLICE_16\[1\].RAM16.BYTE\[3\].FLOATBUF0\[31\].Z sky130_fd_sc_hd__ebufn_2
XSLICE_16\[0\].RAM16.Do0_REG.OUTREG_BYTE\[2\].Do_FF\[2\] SLICE_16\[0\].RAM16.Do0_REG.CLKBUF\[2\]
+ SLICE_16\[0\].RAM16.BYTE\[2\].FLOATBUF0\[18\].Z VGND VGND VPWR VPWR Do0MUX.A0\[18\]
+ sky130_fd_sc_hd__dfxtp_1
XSLICE_16\[0\].RAM16.SLICE\[1\].RAM8.WORD\[7\].W.BYTE\[2\].B.genblk1.CLKINV SLICE_16\[0\].RAM16.SLICE\[1\].RAM8.WORD\[7\].W.BYTE\[0\].B.CLK
+ VGND VGND VPWR VPWR SLICE_16\[0\].RAM16.SLICE\[1\].RAM8.WORD\[7\].W.BYTE\[2\].B.CLK_B
+ sky130_fd_sc_hd__inv_1
XSLICE_16\[0\].RAM16.SLICE\[0\].RAM8.WORD\[0\].W.BYTE\[0\].B.BIT\[6\].genblk1.STORAGE
+ DIBUF\[6\].X SLICE_16\[0\].RAM16.SLICE\[0\].RAM8.WORD\[0\].W.BYTE\[0\].B.GCLK VGND
+ VGND VPWR VPWR SLICE_16\[0\].RAM16.SLICE\[0\].RAM8.WORD\[0\].W.BYTE\[0\].B.Q_WIRE\[6\]
+ sky130_fd_sc_hd__dlxtp_1
XSLICE_16\[0\].RAM16.SLICE\[0\].RAM8.WORD\[2\].W.BYTE\[2\].B.BIT\[7\].genblk1.STORAGE
+ DIBUF\[23\].X SLICE_16\[0\].RAM16.SLICE\[0\].RAM8.WORD\[2\].W.BYTE\[2\].B.GCLK VGND
+ VGND VPWR VPWR SLICE_16\[0\].RAM16.SLICE\[0\].RAM8.WORD\[2\].W.BYTE\[2\].B.Q_WIRE\[7\]
+ sky130_fd_sc_hd__dlxtp_1
Xtap_6_0 VGND VPWR sky130_fd_sc_hd__tapvpwrvgnd_1
XSLICE_16\[0\].RAM16.SLICE\[0\].RAM8.WORD\[3\].W.SEL0BUF SLICE_16\[0\].RAM16.SLICE\[0\].RAM8.DEC0.SEL\[3\]
+ VGND VGND VPWR VPWR SLICE_16\[0\].RAM16.SLICE\[0\].RAM8.WORD\[3\].W.BYTE\[0\].B.SEL0
+ sky130_fd_sc_hd__clkbuf_2
Xfill_41_5 VGND VGND VPWR VPWR sky130_fd_sc_hd__decap_12
Xfill_34_4 VGND VGND VPWR VPWR sky130_fd_sc_hd__fill_2
XSLICE_16\[1\].RAM16.SLICE\[1\].RAM8.WORD\[0\].W.BYTE\[0\].B.CGAND SLICE_16\[1\].RAM16.SLICE\[1\].RAM8.WORD\[0\].W.BYTE\[0\].B.SEL0
+ SLICE_16\[1\].RAM16.SLICE\[1\].RAM8.WE0_buf\[0\] VGND VGND VPWR VPWR SLICE_16\[1\].RAM16.SLICE\[1\].RAM8.WORD\[0\].W.BYTE\[0\].B.WE0_WIRE
+ sky130_fd_sc_hd__and2_1
Xfill_27_3 VGND VPWR sky130_fd_sc_hd__tapvpwrvgnd_1
Xfill_19_104 VGND VGND VPWR VPWR sky130_fd_sc_hd__decap_6
XSLICE_16\[1\].RAM16.SLICE\[1\].RAM8.WORD\[7\].W.BYTE\[3\].B.BIT\[5\].genblk1.STORAGE
+ DIBUF\[29\].X SLICE_16\[1\].RAM16.SLICE\[1\].RAM8.WORD\[7\].W.BYTE\[3\].B.GCLK VGND
+ VGND VPWR VPWR SLICE_16\[1\].RAM16.SLICE\[1\].RAM8.WORD\[7\].W.BYTE\[3\].B.Q_WIRE\[5\]
+ sky130_fd_sc_hd__dlxtp_1
XSLICE_16\[1\].RAM16.SLICE\[1\].RAM8.WORD\[0\].W.BYTE\[1\].B.BIT\[4\].OBUF0 SLICE_16\[1\].RAM16.SLICE\[1\].RAM8.WORD\[0\].W.BYTE\[1\].B.Q_WIRE\[4\]
+ SLICE_16\[1\].RAM16.SLICE\[1\].RAM8.WORD\[0\].W.BYTE\[1\].B.SEL0_B VGND VGND VPWR
+ VPWR SLICE_16\[1\].RAM16.BYTE\[1\].FLOATBUF0\[12\].Z sky130_fd_sc_hd__ebufn_2
XSLICE_16\[0\].RAM16.SLICE\[1\].RAM8.WORD\[5\].W.BYTE\[3\].B.BIT\[0\].OBUF0 SLICE_16\[0\].RAM16.SLICE\[1\].RAM8.WORD\[5\].W.BYTE\[3\].B.Q_WIRE\[0\]
+ SLICE_16\[0\].RAM16.SLICE\[1\].RAM8.WORD\[5\].W.BYTE\[3\].B.SEL0_B VGND VGND VPWR
+ VPWR SLICE_16\[0\].RAM16.BYTE\[3\].FLOATBUF0\[24\].Z sky130_fd_sc_hd__ebufn_2
XWEBUF\[3\].__cell__ WE0[3] VGND VGND VPWR VPWR SLICE_16\[0\].RAM16.WE0\[3\] sky130_fd_sc_hd__clkbuf_2
XSLICE_16\[1\].RAM16.SLICE\[1\].RAM8.WORD\[5\].W.BYTE\[1\].B.BIT\[4\].genblk1.STORAGE
+ DIBUF\[12\].X SLICE_16\[1\].RAM16.SLICE\[1\].RAM8.WORD\[5\].W.BYTE\[1\].B.GCLK VGND
+ VGND VPWR VPWR SLICE_16\[1\].RAM16.SLICE\[1\].RAM8.WORD\[5\].W.BYTE\[1\].B.Q_WIRE\[4\]
+ sky130_fd_sc_hd__dlxtp_1
XSLICE_16\[1\].RAM16.SLICE\[0\].RAM8.WORD\[6\].W.BYTE\[3\].B.BIT\[0\].genblk1.STORAGE
+ DIBUF\[24\].X SLICE_16\[1\].RAM16.SLICE\[0\].RAM8.WORD\[6\].W.BYTE\[3\].B.GCLK VGND
+ VGND VPWR VPWR SLICE_16\[1\].RAM16.SLICE\[0\].RAM8.WORD\[6\].W.BYTE\[3\].B.Q_WIRE\[0\]
+ sky130_fd_sc_hd__dlxtp_1
Xfill_18_27 VGND VPWR sky130_fd_sc_hd__tapvpwrvgnd_1
Xfill_18_16 VGND VGND VPWR VPWR sky130_fd_sc_hd__decap_12
XSLICE_16\[0\].RAM16.SLICE\[1\].RAM8.WORD\[2\].W.BYTE\[0\].B.BIT\[5\].OBUF0 SLICE_16\[0\].RAM16.SLICE\[1\].RAM8.WORD\[2\].W.BYTE\[0\].B.Q_WIRE\[5\]
+ SLICE_16\[0\].RAM16.SLICE\[1\].RAM8.WORD\[2\].W.BYTE\[0\].B.SEL0_B VGND VGND VPWR
+ VPWR SLICE_16\[0\].RAM16.BYTE\[0\].FLOATBUF0\[5\].Z sky130_fd_sc_hd__ebufn_2
Xtap_11_30 VGND VPWR sky130_fd_sc_hd__tapvpwrvgnd_1
XSLICE_16\[0\].RAM16.SLICE\[1\].RAM8.WORD\[6\].W.BYTE\[1\].B.BIT\[0\].genblk1.STORAGE
+ DIBUF\[8\].X SLICE_16\[0\].RAM16.SLICE\[1\].RAM8.WORD\[6\].W.BYTE\[1\].B.GCLK VGND
+ VGND VPWR VPWR SLICE_16\[0\].RAM16.SLICE\[1\].RAM8.WORD\[6\].W.BYTE\[1\].B.Q_WIRE\[0\]
+ sky130_fd_sc_hd__dlxtp_1
XSLICE_16\[0\].RAM16.SLICE\[1\].RAM8.WORD\[0\].W.BYTE\[2\].B.BIT\[1\].genblk1.STORAGE
+ DIBUF\[17\].X SLICE_16\[0\].RAM16.SLICE\[1\].RAM8.WORD\[0\].W.BYTE\[2\].B.GCLK VGND
+ VGND VPWR VPWR SLICE_16\[0\].RAM16.SLICE\[1\].RAM8.WORD\[0\].W.BYTE\[2\].B.Q_WIRE\[1\]
+ sky130_fd_sc_hd__dlxtp_1
XSLICE_16\[0\].RAM16.SLICE\[0\].RAM8.WORD\[5\].W.BYTE\[3\].B.DIODE_CLK SLICE_16\[0\].RAM16.SLICE\[0\].RAM8.WORD\[5\].W.BYTE\[0\].B.CLK
+ VGND VGND VPWR VPWR sky130_fd_sc_hd__diode_2
XSLICE_16\[0\].RAM16.SLICE\[1\].RAM8.WORD\[2\].W.BYTE\[2\].B.CGAND SLICE_16\[0\].RAM16.SLICE\[1\].RAM8.WORD\[2\].W.BYTE\[0\].B.SEL0
+ SLICE_16\[0\].RAM16.SLICE\[1\].RAM8.WE0_buf\[2\] VGND VGND VPWR VPWR SLICE_16\[0\].RAM16.SLICE\[1\].RAM8.WORD\[2\].W.BYTE\[2\].B.WE0_WIRE
+ sky130_fd_sc_hd__and2_1
XSLICE_16\[1\].RAM16.SLICE\[1\].RAM8.WORD\[1\].W.BYTE\[1\].B.DIODE_CLK SLICE_16\[1\].RAM16.SLICE\[1\].RAM8.WORD\[1\].W.BYTE\[0\].B.CLK
+ VGND VGND VPWR VPWR sky130_fd_sc_hd__diode_2
XSLICE_16\[1\].RAM16.SLICE\[0\].RAM8.WORD\[7\].W.BYTE\[0\].B.DIODE_CLK SLICE_16\[1\].RAM16.SLICE\[0\].RAM8.WORD\[7\].W.BYTE\[0\].B.CLK
+ VGND VGND VPWR VPWR sky130_fd_sc_hd__diode_2
XSLICE_16\[0\].RAM16.SLICE\[0\].RAM8.WORD\[1\].W.BYTE\[2\].B.BIT\[7\].OBUF0 SLICE_16\[0\].RAM16.SLICE\[0\].RAM8.WORD\[1\].W.BYTE\[2\].B.Q_WIRE\[7\]
+ SLICE_16\[0\].RAM16.SLICE\[0\].RAM8.WORD\[1\].W.BYTE\[2\].B.SEL0_B VGND VGND VPWR
+ VPWR SLICE_16\[0\].RAM16.BYTE\[2\].FLOATBUF0\[23\].Z sky130_fd_sc_hd__ebufn_2
XSLICE_16\[0\].RAM16.SLICE\[0\].RAM8.WORD\[5\].W.BYTE\[3\].B.BIT\[7\].genblk1.STORAGE
+ DIBUF\[31\].X SLICE_16\[0\].RAM16.SLICE\[0\].RAM8.WORD\[5\].W.BYTE\[3\].B.GCLK VGND
+ VGND VPWR VPWR SLICE_16\[0\].RAM16.SLICE\[0\].RAM8.WORD\[5\].W.BYTE\[3\].B.Q_WIRE\[7\]
+ sky130_fd_sc_hd__dlxtp_1
XSLICE_16\[1\].RAM16.BYTE\[2\].FLOATBUF0\[22\].__cell__ SLICE_16\[1\].RAM16.BYTE\[2\].FLOATBUF0\[16\].A
+ SLICE_16\[1\].RAM16.BYTE\[2\].FLOATBUF0\[16\].TE_B VGND VGND VPWR VPWR SLICE_16\[1\].RAM16.BYTE\[2\].FLOATBUF0\[22\].Z
+ sky130_fd_sc_hd__ebufn_2
XSLICE_16\[1\].RAM16.SLICE\[1\].RAM8.WORD\[3\].W.BYTE\[2\].B.BIT\[4\].OBUF0 SLICE_16\[1\].RAM16.SLICE\[1\].RAM8.WORD\[3\].W.BYTE\[2\].B.Q_WIRE\[4\]
+ SLICE_16\[1\].RAM16.SLICE\[1\].RAM8.WORD\[3\].W.BYTE\[2\].B.SEL0_B VGND VGND VPWR
+ VPWR SLICE_16\[1\].RAM16.BYTE\[2\].FLOATBUF0\[20\].Z sky130_fd_sc_hd__ebufn_2
XSLICE_16\[0\].RAM16.SLICE\[0\].RAM8.WORD\[3\].W.BYTE\[1\].B.BIT\[6\].genblk1.STORAGE
+ DIBUF\[14\].X SLICE_16\[0\].RAM16.SLICE\[0\].RAM8.WORD\[3\].W.BYTE\[1\].B.GCLK VGND
+ VGND VPWR VPWR SLICE_16\[0\].RAM16.SLICE\[0\].RAM8.WORD\[3\].W.BYTE\[1\].B.Q_WIRE\[6\]
+ sky130_fd_sc_hd__dlxtp_1
Xfill_32_1 VGND VPWR sky130_fd_sc_hd__tapvpwrvgnd_1
XSLICE_16\[1\].RAM16.DEC0.AND0 SLICE_16\[1\].RAM16.A0BUF\[3\].X SLICE_16\[1\].RAM16.DEC0.EN
+ VGND VGND VPWR VPWR SLICE_16\[1\].RAM16.DEC0.SEL\[0\] sky130_fd_sc_hd__and2b_2
XSLICE_16\[1\].RAM16.SLICE\[0\].RAM8.DEC0.AND6 SLICE_16\[1\].RAM16.SLICE\[0\].RAM8.DEC0.A_buf\[0\]
+ SLICE_16\[1\].RAM16.SLICE\[0\].RAM8.DEC0.A_buf\[1\] SLICE_16\[1\].RAM16.SLICE\[0\].RAM8.DEC0.A_buf\[2\]
+ SLICE_16\[1\].RAM16.SLICE\[0\].RAM8.DEC0.EN_buf VGND VGND VPWR VPWR SLICE_16\[1\].RAM16.SLICE\[0\].RAM8.DEC0.SEL\[6\]
+ sky130_fd_sc_hd__and4b_2
Xfill_25_0 VGND VPWR sky130_fd_sc_hd__tapvpwrvgnd_1
Xtap_16_19 VGND VPWR sky130_fd_sc_hd__tapvpwrvgnd_1
Xtap_32_29 VGND VPWR sky130_fd_sc_hd__tapvpwrvgnd_1
Xtap_32_18 VGND VPWR sky130_fd_sc_hd__tapvpwrvgnd_1
XSLICE_16\[0\].RAM16.SLICE\[1\].RAM8.WORD\[5\].W.BYTE\[1\].B.BIT\[5\].OBUF0 SLICE_16\[0\].RAM16.SLICE\[1\].RAM8.WORD\[5\].W.BYTE\[1\].B.Q_WIRE\[5\]
+ SLICE_16\[0\].RAM16.SLICE\[1\].RAM8.WORD\[5\].W.BYTE\[1\].B.SEL0_B VGND VGND VPWR
+ VPWR SLICE_16\[0\].RAM16.BYTE\[1\].FLOATBUF0\[13\].Z sky130_fd_sc_hd__ebufn_2
XSLICE_16\[0\].RAM16.SLICE\[1\].RAM8.WORD\[4\].W.BYTE\[0\].B.DIODE_CLK SLICE_16\[0\].RAM16.SLICE\[1\].RAM8.WORD\[4\].W.BYTE\[0\].B.CLK
+ VGND VGND VPWR VPWR sky130_fd_sc_hd__diode_2
Xtap_47_7 VGND VPWR sky130_fd_sc_hd__tapvpwrvgnd_1
Xfill_20_39 VGND VPWR sky130_fd_sc_hd__tapvpwrvgnd_1
Xfill_20_28 VGND VGND VPWR VPWR sky130_fd_sc_hd__decap_12
Xfill_20_17 VGND VGND VPWR VPWR sky130_fd_sc_hd__decap_12
Xtap_3_11 VGND VPWR sky130_fd_sc_hd__tapvpwrvgnd_1
Xtap_3_22 VGND VPWR sky130_fd_sc_hd__tapvpwrvgnd_1
Xtap_3_33 VGND VPWR sky130_fd_sc_hd__tapvpwrvgnd_1
XDo0MUX.M\[1\].DIODE_A1MUX\[12\] Do0MUX.A1\[12\] VGND VGND VPWR VPWR sky130_fd_sc_hd__diode_2
Xfill_45_69 VGND VPWR sky130_fd_sc_hd__tapvpwrvgnd_1
Xfill_45_58 VGND VGND VPWR VPWR sky130_fd_sc_hd__decap_12
Xfill_45_47 VGND VGND VPWR VPWR sky130_fd_sc_hd__decap_12
Xfill_45_36 VGND VPWR sky130_fd_sc_hd__tapvpwrvgnd_1
Xfill_45_25 VGND VGND VPWR VPWR sky130_fd_sc_hd__decap_12
Xfill_45_14 VGND VGND VPWR VPWR sky130_fd_sc_hd__decap_12
XSLICE_16\[0\].RAM16.SLICE\[0\].RAM8.WORD\[0\].W.BYTE\[0\].B.BIT\[4\].OBUF0 SLICE_16\[0\].RAM16.SLICE\[0\].RAM8.WORD\[0\].W.BYTE\[0\].B.Q_WIRE\[4\]
+ SLICE_16\[0\].RAM16.SLICE\[0\].RAM8.WORD\[0\].W.BYTE\[0\].B.SEL0_B VGND VGND VPWR
+ VPWR SLICE_16\[0\].RAM16.BYTE\[0\].FLOATBUF0\[4\].Z sky130_fd_sc_hd__ebufn_2
XSLICE_16\[1\].RAM16.SLICE\[1\].RAM8.WORD\[2\].W.BYTE\[0\].B.BIT\[1\].OBUF0 SLICE_16\[1\].RAM16.SLICE\[1\].RAM8.WORD\[2\].W.BYTE\[0\].B.Q_WIRE\[1\]
+ SLICE_16\[1\].RAM16.SLICE\[1\].RAM8.WORD\[2\].W.BYTE\[0\].B.SEL0_B VGND VGND VPWR
+ VPWR SLICE_16\[1\].RAM16.BYTE\[0\].FLOATBUF0\[1\].Z sky130_fd_sc_hd__ebufn_2
XSLICE_16\[0\].RAM16.SLICE\[0\].RAM8.WORD\[4\].W.BYTE\[3\].B.BIT\[7\].OBUF0 SLICE_16\[0\].RAM16.SLICE\[0\].RAM8.WORD\[4\].W.BYTE\[3\].B.Q_WIRE\[7\]
+ SLICE_16\[0\].RAM16.SLICE\[0\].RAM8.WORD\[4\].W.BYTE\[3\].B.SEL0_B VGND VGND VPWR
+ VPWR SLICE_16\[0\].RAM16.BYTE\[3\].FLOATBUF0\[31\].Z sky130_fd_sc_hd__ebufn_2
XSLICE_16\[1\].RAM16.SLICE\[1\].RAM8.WORD\[6\].W.BYTE\[3\].B.BIT\[4\].OBUF0 SLICE_16\[1\].RAM16.SLICE\[1\].RAM8.WORD\[6\].W.BYTE\[3\].B.Q_WIRE\[4\]
+ SLICE_16\[1\].RAM16.SLICE\[1\].RAM8.WORD\[6\].W.BYTE\[3\].B.SEL0_B VGND VGND VPWR
+ VPWR SLICE_16\[1\].RAM16.BYTE\[3\].FLOATBUF0\[28\].Z sky130_fd_sc_hd__ebufn_2
XSLICE_16\[1\].RAM16.SLICE\[1\].RAM8.WORD\[6\].W.BYTE\[0\].B.BIT\[3\].genblk1.STORAGE
+ DIBUF\[3\].X SLICE_16\[1\].RAM16.SLICE\[1\].RAM8.WORD\[6\].W.BYTE\[0\].B.GCLK VGND
+ VGND VPWR VPWR SLICE_16\[1\].RAM16.SLICE\[1\].RAM8.WORD\[6\].W.BYTE\[0\].B.Q_WIRE\[3\]
+ sky130_fd_sc_hd__dlxtp_1
XSLICE_16\[1\].RAM16.SLICE\[1\].RAM8.WORD\[2\].W.BYTE\[3\].B.BIT\[5\].genblk1.STORAGE
+ DIBUF\[29\].X SLICE_16\[1\].RAM16.SLICE\[1\].RAM8.WORD\[2\].W.BYTE\[3\].B.GCLK VGND
+ VGND VPWR VPWR SLICE_16\[1\].RAM16.SLICE\[1\].RAM8.WORD\[2\].W.BYTE\[3\].B.Q_WIRE\[5\]
+ sky130_fd_sc_hd__dlxtp_1
XSLICE_16\[1\].RAM16.SLICE\[1\].RAM8.WORD\[0\].W.BYTE\[1\].B.BIT\[4\].genblk1.STORAGE
+ DIBUF\[12\].X SLICE_16\[1\].RAM16.SLICE\[1\].RAM8.WORD\[0\].W.BYTE\[1\].B.GCLK VGND
+ VGND VPWR VPWR SLICE_16\[1\].RAM16.SLICE\[1\].RAM8.WORD\[0\].W.BYTE\[1\].B.Q_WIRE\[4\]
+ sky130_fd_sc_hd__dlxtp_1
XSLICE_16\[1\].RAM16.SLICE\[0\].RAM8.WORD\[1\].W.BYTE\[3\].B.BIT\[0\].genblk1.STORAGE
+ DIBUF\[24\].X SLICE_16\[1\].RAM16.SLICE\[0\].RAM8.WORD\[1\].W.BYTE\[3\].B.GCLK VGND
+ VGND VPWR VPWR SLICE_16\[1\].RAM16.SLICE\[0\].RAM8.WORD\[1\].W.BYTE\[3\].B.Q_WIRE\[0\]
+ sky130_fd_sc_hd__dlxtp_1
Xfill_19_92 VGND VGND VPWR VPWR sky130_fd_sc_hd__decap_12
Xfill_19_81 VGND VPWR sky130_fd_sc_hd__tapvpwrvgnd_1
Xfill_19_70 VGND VGND VPWR VPWR sky130_fd_sc_hd__decap_12
XSLICE_16\[0\].RAM16.SLICE\[1\].RAM8.WORD\[3\].W.BYTE\[3\].B.genblk1.CG SLICE_16\[0\].RAM16.SLICE\[1\].RAM8.WORD\[3\].W.BYTE\[3\].B.CLK_B
+ SLICE_16\[0\].RAM16.SLICE\[1\].RAM8.WORD\[3\].W.BYTE\[3\].B.WE0_WIRE VGND VGND VPWR
+ VPWR SLICE_16\[0\].RAM16.SLICE\[1\].RAM8.WORD\[3\].W.BYTE\[3\].B.GCLK sky130_fd_sc_hd__dlclkp_1
XSLICE_16\[1\].RAM16.SLICE\[0\].RAM8.WORD\[1\].W.BYTE\[2\].B.BIT\[3\].OBUF0 SLICE_16\[1\].RAM16.SLICE\[0\].RAM8.WORD\[1\].W.BYTE\[2\].B.Q_WIRE\[3\]
+ SLICE_16\[1\].RAM16.SLICE\[0\].RAM8.WORD\[1\].W.BYTE\[2\].B.SEL0_B VGND VGND VPWR
+ VPWR SLICE_16\[1\].RAM16.BYTE\[2\].FLOATBUF0\[19\].Z sky130_fd_sc_hd__ebufn_2
XSLICE_16\[0\].RAM16.SLICE\[1\].RAM8.WORD\[3\].W.BYTE\[3\].B.BIT\[1\].genblk1.STORAGE
+ DIBUF\[25\].X SLICE_16\[0\].RAM16.SLICE\[1\].RAM8.WORD\[3\].W.BYTE\[3\].B.GCLK VGND
+ VGND VPWR VPWR SLICE_16\[0\].RAM16.SLICE\[1\].RAM8.WORD\[3\].W.BYTE\[3\].B.Q_WIRE\[1\]
+ sky130_fd_sc_hd__dlxtp_1
XDo0MUX.M\[2\].DIODE_A1MUX\[16\] Do0MUX.A1\[16\] VGND VGND VPWR VPWR sky130_fd_sc_hd__diode_2
XSLICE_16\[0\].RAM16.SLICE\[1\].RAM8.WORD\[1\].W.BYTE\[1\].B.BIT\[0\].genblk1.STORAGE
+ DIBUF\[8\].X SLICE_16\[0\].RAM16.SLICE\[1\].RAM8.WORD\[1\].W.BYTE\[1\].B.GCLK VGND
+ VGND VPWR VPWR SLICE_16\[0\].RAM16.SLICE\[1\].RAM8.WORD\[1\].W.BYTE\[1\].B.Q_WIRE\[0\]
+ sky130_fd_sc_hd__dlxtp_1
Xtap_27_29 VGND VPWR sky130_fd_sc_hd__tapvpwrvgnd_1
Xtap_27_18 VGND VPWR sky130_fd_sc_hd__tapvpwrvgnd_1
XSLICE_16\[0\].RAM16.SLICE\[0\].RAM8.WORD\[3\].W.BYTE\[1\].B.BIT\[4\].OBUF0 SLICE_16\[0\].RAM16.SLICE\[0\].RAM8.WORD\[3\].W.BYTE\[1\].B.Q_WIRE\[4\]
+ SLICE_16\[0\].RAM16.SLICE\[0\].RAM8.WORD\[3\].W.BYTE\[1\].B.SEL0_B VGND VGND VPWR
+ VPWR SLICE_16\[0\].RAM16.BYTE\[1\].FLOATBUF0\[12\].Z sky130_fd_sc_hd__ebufn_2
XSLICE_16\[1\].RAM16.SLICE\[1\].RAM8.WORD\[5\].W.BYTE\[1\].B.BIT\[1\].OBUF0 SLICE_16\[1\].RAM16.SLICE\[1\].RAM8.WORD\[5\].W.BYTE\[1\].B.Q_WIRE\[1\]
+ SLICE_16\[1\].RAM16.SLICE\[1\].RAM8.WORD\[5\].W.BYTE\[1\].B.SEL0_B VGND VGND VPWR
+ VPWR SLICE_16\[1\].RAM16.BYTE\[1\].FLOATBUF0\[9\].Z sky130_fd_sc_hd__ebufn_2
XSLICE_16\[0\].RAM16.SLICE\[0\].RAM8.WORD\[0\].W.BYTE\[3\].B.BIT\[7\].genblk1.STORAGE
+ DIBUF\[31\].X SLICE_16\[0\].RAM16.SLICE\[0\].RAM8.WORD\[0\].W.BYTE\[3\].B.GCLK VGND
+ VGND VPWR VPWR SLICE_16\[0\].RAM16.SLICE\[0\].RAM8.WORD\[0\].W.BYTE\[3\].B.Q_WIRE\[7\]
+ sky130_fd_sc_hd__dlxtp_1
XSLICE_16\[0\].RAM16.SLICE\[0\].RAM8.WORD\[6\].W.BYTE\[2\].B.BIT\[6\].genblk1.STORAGE
+ DIBUF\[22\].X SLICE_16\[0\].RAM16.SLICE\[0\].RAM8.WORD\[6\].W.BYTE\[2\].B.GCLK VGND
+ VGND VPWR VPWR SLICE_16\[0\].RAM16.SLICE\[0\].RAM8.WORD\[6\].W.BYTE\[2\].B.Q_WIRE\[6\]
+ sky130_fd_sc_hd__dlxtp_1
Xtap_38_3 VGND VPWR sky130_fd_sc_hd__tapvpwrvgnd_1
XSLICE_16\[0\].RAM16.SLICE\[1\].RAM8.WORD\[7\].W.BYTE\[3\].B.DIODE_CLK SLICE_16\[0\].RAM16.SLICE\[1\].RAM8.WORD\[7\].W.BYTE\[0\].B.CLK
+ VGND VGND VPWR VPWR sky130_fd_sc_hd__diode_2
XDIBUF\[13\].__cell__ Di0[13] VGND VGND VPWR VPWR DIBUF\[13\].X sky130_fd_sc_hd__clkbuf_16
XSLICE_16\[0\].RAM16.SLICE\[0\].RAM8.WORD\[4\].W.BYTE\[0\].B.BIT\[5\].genblk1.STORAGE
+ DIBUF\[5\].X SLICE_16\[0\].RAM16.SLICE\[0\].RAM8.WORD\[4\].W.BYTE\[0\].B.GCLK VGND
+ VGND VPWR VPWR SLICE_16\[0\].RAM16.SLICE\[0\].RAM8.WORD\[4\].W.BYTE\[0\].B.Q_WIRE\[5\]
+ sky130_fd_sc_hd__dlxtp_1
XSLICE_16\[1\].RAM16.SLICE\[1\].RAM8.WORD\[0\].W.BYTE\[2\].B.genblk1.CG SLICE_16\[1\].RAM16.SLICE\[1\].RAM8.WORD\[0\].W.BYTE\[2\].B.CLK_B
+ SLICE_16\[1\].RAM16.SLICE\[1\].RAM8.WORD\[0\].W.BYTE\[2\].B.WE0_WIRE VGND VGND VPWR
+ VPWR SLICE_16\[1\].RAM16.SLICE\[1\].RAM8.WORD\[0\].W.BYTE\[2\].B.GCLK sky130_fd_sc_hd__dlclkp_1
XSLICE_16\[1\].RAM16.SLICE\[0\].RAM8.WORD\[0\].W.BYTE\[0\].B.BIT\[0\].OBUF0 SLICE_16\[1\].RAM16.SLICE\[0\].RAM8.WORD\[0\].W.BYTE\[0\].B.Q_WIRE\[0\]
+ SLICE_16\[1\].RAM16.SLICE\[0\].RAM8.WORD\[0\].W.BYTE\[0\].B.SEL0_B VGND VGND VPWR
+ VPWR SLICE_16\[1\].RAM16.BYTE\[0\].FLOATBUF0\[0\].Z sky130_fd_sc_hd__ebufn_2
XSLICE_16\[0\].RAM16.SLICE\[1\].RAM8.WORD\[7\].W.BYTE\[0\].B.BIT\[2\].OBUF0 SLICE_16\[0\].RAM16.SLICE\[1\].RAM8.WORD\[7\].W.BYTE\[0\].B.Q_WIRE\[2\]
+ SLICE_16\[0\].RAM16.SLICE\[1\].RAM8.WORD\[7\].W.BYTE\[0\].B.SEL0_B VGND VGND VPWR
+ VPWR SLICE_16\[0\].RAM16.BYTE\[0\].FLOATBUF0\[2\].Z sky130_fd_sc_hd__ebufn_2
XSLICE_16\[1\].RAM16.SLICE\[0\].RAM8.WORD\[5\].W.BYTE\[0\].B.genblk1.CLKINV SLICE_16\[1\].RAM16.SLICE\[0\].RAM8.WORD\[5\].W.BYTE\[0\].B.CLK
+ VGND VGND VPWR VPWR SLICE_16\[1\].RAM16.SLICE\[0\].RAM8.WORD\[5\].W.BYTE\[0\].B.CLK_B
+ sky130_fd_sc_hd__inv_1
XSLICE_16\[1\].RAM16.SLICE\[0\].RAM8.WORD\[4\].W.BYTE\[3\].B.BIT\[3\].OBUF0 SLICE_16\[1\].RAM16.SLICE\[0\].RAM8.WORD\[4\].W.BYTE\[3\].B.Q_WIRE\[3\]
+ SLICE_16\[1\].RAM16.SLICE\[0\].RAM8.WORD\[4\].W.BYTE\[3\].B.SEL0_B VGND VGND VPWR
+ VPWR SLICE_16\[1\].RAM16.BYTE\[3\].FLOATBUF0\[27\].Z sky130_fd_sc_hd__ebufn_2
XSLICE_16\[0\].RAM16.SLICE\[1\].RAM8.CLKBUF.__cell__ SLICE_16\[0\].RAM16.CLKBUF.X
+ VGND VGND VPWR VPWR SLICE_16\[0\].RAM16.SLICE\[1\].RAM8.CLKBUF.X sky130_fd_sc_hd__clkbuf_2
Xfill_21_82 VGND VGND VPWR VPWR sky130_fd_sc_hd__decap_12
Xfill_21_71 VGND VGND VPWR VPWR sky130_fd_sc_hd__decap_12
Xfill_21_60 VGND VPWR sky130_fd_sc_hd__tapvpwrvgnd_1
Xfill_21_93 VGND VPWR sky130_fd_sc_hd__tapvpwrvgnd_1
XSLICE_16\[0\].RAM16.SLICE\[0\].RAM8.WORD\[6\].W.BYTE\[2\].B.BIT\[4\].OBUF0 SLICE_16\[0\].RAM16.SLICE\[0\].RAM8.WORD\[6\].W.BYTE\[2\].B.Q_WIRE\[4\]
+ SLICE_16\[0\].RAM16.SLICE\[0\].RAM8.WORD\[6\].W.BYTE\[2\].B.SEL0_B VGND VGND VPWR
+ VPWR SLICE_16\[0\].RAM16.BYTE\[2\].FLOATBUF0\[20\].Z sky130_fd_sc_hd__ebufn_2
Xfill_46_90 VGND VPWR sky130_fd_sc_hd__tapvpwrvgnd_1
XSLICE_16\[1\].RAM16.SLICE\[0\].RAM8.WORD\[7\].W.BYTE\[1\].B.genblk1.CG SLICE_16\[1\].RAM16.SLICE\[0\].RAM8.WORD\[7\].W.BYTE\[1\].B.CLK_B
+ SLICE_16\[1\].RAM16.SLICE\[0\].RAM8.WORD\[7\].W.BYTE\[1\].B.WE0_WIRE VGND VGND VPWR
+ VPWR SLICE_16\[1\].RAM16.SLICE\[0\].RAM8.WORD\[7\].W.BYTE\[1\].B.GCLK sky130_fd_sc_hd__dlclkp_1
Xfill_7_5 VGND VGND VPWR VPWR sky130_fd_sc_hd__decap_6
XSLICE_16\[1\].RAM16.SLICE\[1\].RAM8.WORD\[3\].W.BYTE\[2\].B.BIT\[4\].genblk1.STORAGE
+ DIBUF\[20\].X SLICE_16\[1\].RAM16.SLICE\[1\].RAM8.WORD\[3\].W.BYTE\[2\].B.GCLK VGND
+ VGND VPWR VPWR SLICE_16\[1\].RAM16.SLICE\[1\].RAM8.WORD\[3\].W.BYTE\[2\].B.Q_WIRE\[4\]
+ sky130_fd_sc_hd__dlxtp_1
XSLICE_16\[1\].RAM16.SLICE\[0\].RAM8.WORD\[4\].W.SEL0BUF SLICE_16\[1\].RAM16.SLICE\[0\].RAM8.DEC0.SEL\[4\]
+ VGND VGND VPWR VPWR SLICE_16\[1\].RAM16.SLICE\[0\].RAM8.WORD\[4\].W.BYTE\[0\].B.SEL0
+ sky130_fd_sc_hd__clkbuf_2
Xtap_38_28 VGND VPWR sky130_fd_sc_hd__tapvpwrvgnd_1
Xtap_38_17 VGND VPWR sky130_fd_sc_hd__tapvpwrvgnd_1
XSLICE_16\[1\].RAM16.SLICE\[1\].RAM8.WORD\[1\].W.BYTE\[0\].B.BIT\[3\].genblk1.STORAGE
+ DIBUF\[3\].X SLICE_16\[1\].RAM16.SLICE\[1\].RAM8.WORD\[1\].W.BYTE\[0\].B.GCLK VGND
+ VGND VPWR VPWR SLICE_16\[1\].RAM16.SLICE\[1\].RAM8.WORD\[1\].W.BYTE\[0\].B.Q_WIRE\[3\]
+ sky130_fd_sc_hd__dlxtp_1
Xtap_24_9 VGND VPWR sky130_fd_sc_hd__tapvpwrvgnd_1
XSLICE_16\[1\].RAM16.SLICE\[0\].RAM8.WORD\[3\].W.BYTE\[1\].B.BIT\[0\].OBUF0 SLICE_16\[1\].RAM16.SLICE\[0\].RAM8.WORD\[3\].W.BYTE\[1\].B.Q_WIRE\[0\]
+ SLICE_16\[1\].RAM16.SLICE\[0\].RAM8.WORD\[3\].W.BYTE\[1\].B.SEL0_B VGND VGND VPWR
+ VPWR SLICE_16\[1\].RAM16.BYTE\[1\].FLOATBUF0\[8\].Z sky130_fd_sc_hd__ebufn_2
Xtap_17_8 VGND VPWR sky130_fd_sc_hd__tapvpwrvgnd_1
Xtap_0_23 VGND VPWR sky130_fd_sc_hd__tapvpwrvgnd_1
Xtap_0_12 VGND VPWR sky130_fd_sc_hd__tapvpwrvgnd_1
Xfill_42_26 VGND VGND VPWR VPWR sky130_fd_sc_hd__decap_12
Xfill_42_15 VGND VPWR sky130_fd_sc_hd__tapvpwrvgnd_1
XSLICE_16\[0\].RAM16.SLICE\[1\].RAM8.WORD\[4\].W.BYTE\[2\].B.BIT\[0\].genblk1.STORAGE
+ DIBUF\[16\].X SLICE_16\[0\].RAM16.SLICE\[1\].RAM8.WORD\[4\].W.BYTE\[2\].B.GCLK VGND
+ VGND VPWR VPWR SLICE_16\[0\].RAM16.SLICE\[1\].RAM8.WORD\[4\].W.BYTE\[2\].B.Q_WIRE\[0\]
+ sky130_fd_sc_hd__dlxtp_1
Xtap_9_10 VGND VPWR sky130_fd_sc_hd__tapvpwrvgnd_1
Xtap_9_21 VGND VPWR sky130_fd_sc_hd__tapvpwrvgnd_1
Xtap_9_32 VGND VPWR sky130_fd_sc_hd__tapvpwrvgnd_1
Xfill_42_59 VGND VGND VPWR VPWR sky130_fd_sc_hd__decap_12
Xfill_42_48 VGND VPWR sky130_fd_sc_hd__tapvpwrvgnd_1
Xfill_42_37 VGND VGND VPWR VPWR sky130_fd_sc_hd__decap_12
XSLICE_16\[0\].RAM16.SLICE\[0\].RAM8.WORD\[5\].W.BYTE\[0\].B.BIT\[1\].OBUF0 SLICE_16\[0\].RAM16.SLICE\[0\].RAM8.WORD\[5\].W.BYTE\[0\].B.Q_WIRE\[1\]
+ SLICE_16\[0\].RAM16.SLICE\[0\].RAM8.WORD\[5\].W.BYTE\[0\].B.SEL0_B VGND VGND VPWR
+ VPWR SLICE_16\[0\].RAM16.BYTE\[0\].FLOATBUF0\[1\].Z sky130_fd_sc_hd__ebufn_2
Xtap_36_0 VGND VPWR sky130_fd_sc_hd__tapvpwrvgnd_1
XSLICE_16\[0\].RAM16.SLICE\[1\].RAM8.WORD\[1\].W.BYTE\[3\].B.BIT\[7\].OBUF0 SLICE_16\[0\].RAM16.SLICE\[1\].RAM8.WORD\[1\].W.BYTE\[3\].B.Q_WIRE\[7\]
+ SLICE_16\[0\].RAM16.SLICE\[1\].RAM8.WORD\[1\].W.BYTE\[3\].B.SEL0_B VGND VGND VPWR
+ VPWR SLICE_16\[0\].RAM16.BYTE\[3\].FLOATBUF0\[31\].Z sky130_fd_sc_hd__ebufn_2
XSLICE_16\[0\].RAM16.SLICE\[0\].RAM8.WORD\[1\].W.BYTE\[2\].B.BIT\[6\].genblk1.STORAGE
+ DIBUF\[22\].X SLICE_16\[0\].RAM16.SLICE\[0\].RAM8.WORD\[1\].W.BYTE\[2\].B.GCLK VGND
+ VGND VPWR VPWR SLICE_16\[0\].RAM16.SLICE\[0\].RAM8.WORD\[1\].W.BYTE\[2\].B.Q_WIRE\[6\]
+ sky130_fd_sc_hd__dlxtp_1
XSLICE_16\[0\].RAM16.SLICE\[0\].RAM8.WORD\[7\].W.BYTE\[1\].B.BIT\[5\].genblk1.STORAGE
+ DIBUF\[13\].X SLICE_16\[0\].RAM16.SLICE\[0\].RAM8.WORD\[7\].W.BYTE\[1\].B.GCLK VGND
+ VGND VPWR VPWR SLICE_16\[0\].RAM16.SLICE\[0\].RAM8.WORD\[7\].W.BYTE\[1\].B.Q_WIRE\[5\]
+ sky130_fd_sc_hd__dlxtp_1
XSLICE_16\[1\].RAM16.SLICE\[0\].RAM8.WORD\[6\].W.BYTE\[2\].B.BIT\[0\].OBUF0 SLICE_16\[1\].RAM16.SLICE\[0\].RAM8.WORD\[6\].W.BYTE\[2\].B.Q_WIRE\[0\]
+ SLICE_16\[1\].RAM16.SLICE\[0\].RAM8.WORD\[6\].W.BYTE\[2\].B.SEL0_B VGND VGND VPWR
+ VPWR SLICE_16\[1\].RAM16.BYTE\[2\].FLOATBUF0\[16\].Z sky130_fd_sc_hd__ebufn_2
Xtap_40_18 VGND VPWR sky130_fd_sc_hd__tapvpwrvgnd_1
Xtap_24_19 VGND VPWR sky130_fd_sc_hd__tapvpwrvgnd_1
Xfill_5_2 VGND VPWR sky130_fd_sc_hd__tapvpwrvgnd_1
Xtap_40_29 VGND VPWR sky130_fd_sc_hd__tapvpwrvgnd_1
XSLICE_16\[0\].RAM16.SLICE\[1\].RAM8.WORD\[0\].W.BYTE\[1\].B.BIT\[4\].OBUF0 SLICE_16\[0\].RAM16.SLICE\[1\].RAM8.WORD\[0\].W.BYTE\[1\].B.Q_WIRE\[4\]
+ SLICE_16\[0\].RAM16.SLICE\[1\].RAM8.WORD\[0\].W.BYTE\[1\].B.SEL0_B VGND VGND VPWR
+ VPWR SLICE_16\[0\].RAM16.BYTE\[1\].FLOATBUF0\[12\].Z sky130_fd_sc_hd__ebufn_2
Xtap_15_5 VGND VPWR sky130_fd_sc_hd__tapvpwrvgnd_1
XSLICE_16\[1\].RAM16.SLICE\[1\].RAM8.WORD\[6\].W.BYTE\[3\].B.BIT\[4\].genblk1.STORAGE
+ DIBUF\[28\].X SLICE_16\[1\].RAM16.SLICE\[1\].RAM8.WORD\[6\].W.BYTE\[3\].B.GCLK VGND
+ VGND VPWR VPWR SLICE_16\[1\].RAM16.SLICE\[1\].RAM8.WORD\[6\].W.BYTE\[3\].B.Q_WIRE\[4\]
+ sky130_fd_sc_hd__dlxtp_1
Xtap_14_30 VGND VPWR sky130_fd_sc_hd__tapvpwrvgnd_1
Xtap_8_4 VGND VPWR sky130_fd_sc_hd__tapvpwrvgnd_1
XDo0MUX.M\[0\].DIODE_A0MUX\[0\] Do0MUX.A0\[0\] VGND VGND VPWR VPWR sky130_fd_sc_hd__diode_2
XSLICE_16\[1\].RAM16.SLICE\[1\].RAM8.WORD\[4\].W.BYTE\[1\].B.BIT\[3\].genblk1.STORAGE
+ DIBUF\[11\].X SLICE_16\[1\].RAM16.SLICE\[1\].RAM8.WORD\[4\].W.BYTE\[1\].B.GCLK VGND
+ VGND VPWR VPWR SLICE_16\[1\].RAM16.SLICE\[1\].RAM8.WORD\[4\].W.BYTE\[1\].B.Q_WIRE\[3\]
+ sky130_fd_sc_hd__dlxtp_1
XSLICE_16\[1\].RAM16.SLICE\[1\].RAM8.WORD\[2\].W.BYTE\[0\].B.genblk1.CLKINV SLICE_16\[1\].RAM16.SLICE\[1\].RAM8.WORD\[2\].W.BYTE\[0\].B.CLK
+ VGND VGND VPWR VPWR SLICE_16\[1\].RAM16.SLICE\[1\].RAM8.WORD\[2\].W.BYTE\[0\].B.CLK_B
+ sky130_fd_sc_hd__inv_1
XSLICE_16\[1\].RAM16.SLICE\[1\].RAM8.WORD\[1\].W.BYTE\[3\].B.BIT\[3\].OBUF0 SLICE_16\[1\].RAM16.SLICE\[1\].RAM8.WORD\[1\].W.BYTE\[3\].B.Q_WIRE\[3\]
+ SLICE_16\[1\].RAM16.SLICE\[1\].RAM8.WORD\[1\].W.BYTE\[3\].B.SEL0_B VGND VGND VPWR
+ VPWR SLICE_16\[1\].RAM16.BYTE\[3\].FLOATBUF0\[27\].Z sky130_fd_sc_hd__ebufn_2
XSLICE_16\[0\].RAM16.SLICE\[1\].RAM8.WORD\[7\].W.BYTE\[3\].B.BIT\[0\].genblk1.STORAGE
+ DIBUF\[24\].X SLICE_16\[0\].RAM16.SLICE\[1\].RAM8.WORD\[7\].W.BYTE\[3\].B.GCLK VGND
+ VGND VPWR VPWR SLICE_16\[0\].RAM16.SLICE\[1\].RAM8.WORD\[7\].W.BYTE\[3\].B.Q_WIRE\[0\]
+ sky130_fd_sc_hd__dlxtp_1
XSLICE_16\[0\].RAM16.SLICE\[0\].RAM8.WORD\[2\].W.SEL0BUF SLICE_16\[0\].RAM16.SLICE\[0\].RAM8.DEC0.SEL\[2\]
+ VGND VGND VPWR VPWR SLICE_16\[0\].RAM16.SLICE\[0\].RAM8.WORD\[2\].W.BYTE\[0\].B.SEL0
+ sky130_fd_sc_hd__clkbuf_2
Xfill_43_9 VGND VPWR sky130_fd_sc_hd__tapvpwrvgnd_1
Xfill_36_8 VGND VGND VPWR VPWR sky130_fd_sc_hd__fill_2
Xfill_46_138 VGND VPWR sky130_fd_sc_hd__tapvpwrvgnd_1
Xfill_46_127 VGND VGND VPWR VPWR sky130_fd_sc_hd__decap_12
Xfill_46_116 VGND VGND VPWR VPWR sky130_fd_sc_hd__decap_12
Xfill_46_105 VGND VPWR sky130_fd_sc_hd__tapvpwrvgnd_1
Xfill_43_91 VGND VGND VPWR VPWR sky130_fd_sc_hd__decap_12
Xfill_43_80 VGND VGND VPWR VPWR sky130_fd_sc_hd__decap_12
XSLICE_16\[1\].RAM16.SLICE\[0\].RAM8.WORD\[6\].W.BYTE\[0\].B.BIT\[5\].OBUF0 SLICE_16\[1\].RAM16.SLICE\[0\].RAM8.WORD\[6\].W.BYTE\[0\].B.Q_WIRE\[5\]
+ SLICE_16\[1\].RAM16.SLICE\[0\].RAM8.WORD\[6\].W.BYTE\[0\].B.SEL0_B VGND VGND VPWR
+ VPWR SLICE_16\[1\].RAM16.BYTE\[0\].FLOATBUF0\[5\].Z sky130_fd_sc_hd__ebufn_2
XSLICE_16\[0\].RAM16.SLICE\[1\].RAM8.WORD\[3\].W.BYTE\[2\].B.BIT\[4\].OBUF0 SLICE_16\[0\].RAM16.SLICE\[1\].RAM8.WORD\[3\].W.BYTE\[2\].B.Q_WIRE\[4\]
+ SLICE_16\[0\].RAM16.SLICE\[1\].RAM8.WORD\[3\].W.BYTE\[2\].B.SEL0_B VGND VGND VPWR
+ VPWR SLICE_16\[0\].RAM16.BYTE\[2\].FLOATBUF0\[20\].Z sky130_fd_sc_hd__ebufn_2
Xtap_35_29 VGND VPWR sky130_fd_sc_hd__tapvpwrvgnd_1
Xtap_35_18 VGND VPWR sky130_fd_sc_hd__tapvpwrvgnd_1
XSLICE_16\[0\].RAM16.SLICE\[0\].RAM8.WORD\[4\].W.BYTE\[3\].B.BIT\[6\].genblk1.STORAGE
+ DIBUF\[30\].X SLICE_16\[0\].RAM16.SLICE\[0\].RAM8.WORD\[4\].W.BYTE\[3\].B.GCLK VGND
+ VGND VPWR VPWR SLICE_16\[0\].RAM16.SLICE\[0\].RAM8.WORD\[4\].W.BYTE\[3\].B.Q_WIRE\[6\]
+ sky130_fd_sc_hd__dlxtp_1
XSLICE_16\[1\].RAM16.SLICE\[1\].RAM8.WORD\[0\].W.BYTE\[1\].B.BIT\[0\].OBUF0 SLICE_16\[1\].RAM16.SLICE\[1\].RAM8.WORD\[0\].W.BYTE\[1\].B.Q_WIRE\[0\]
+ SLICE_16\[1\].RAM16.SLICE\[1\].RAM8.WORD\[0\].W.BYTE\[1\].B.SEL0_B VGND VGND VPWR
+ VPWR SLICE_16\[1\].RAM16.BYTE\[1\].FLOATBUF0\[8\].Z sky130_fd_sc_hd__ebufn_2
XSLICE_16\[0\].RAM16.BYTE\[0\].FLOATBUF0\[4\].__cell__ SLICE_16\[0\].RAM16.BYTE\[0\].FLOATBUF0\[0\].A
+ SLICE_16\[0\].RAM16.BYTE\[0\].FLOATBUF0\[0\].TE_B VGND VGND VPWR VPWR SLICE_16\[0\].RAM16.BYTE\[0\].FLOATBUF0\[4\].Z
+ sky130_fd_sc_hd__ebufn_2
XSLICE_16\[0\].RAM16.SLICE\[0\].RAM8.WORD\[2\].W.BYTE\[1\].B.BIT\[5\].genblk1.STORAGE
+ DIBUF\[13\].X SLICE_16\[0\].RAM16.SLICE\[0\].RAM8.WORD\[2\].W.BYTE\[1\].B.GCLK VGND
+ VGND VPWR VPWR SLICE_16\[0\].RAM16.SLICE\[0\].RAM8.WORD\[2\].W.BYTE\[1\].B.Q_WIRE\[5\]
+ sky130_fd_sc_hd__dlxtp_1
Xtap_6_11 VGND VPWR sky130_fd_sc_hd__tapvpwrvgnd_1
Xtap_6_22 VGND VPWR sky130_fd_sc_hd__tapvpwrvgnd_1
Xtap_6_33 VGND VPWR sky130_fd_sc_hd__tapvpwrvgnd_1
XSLICE_16\[1\].RAM16.SLICE\[1\].RAM8.WORD\[5\].W.BYTE\[1\].B.genblk1.CLKINV SLICE_16\[1\].RAM16.SLICE\[1\].RAM8.WORD\[5\].W.BYTE\[0\].B.CLK
+ VGND VGND VPWR VPWR SLICE_16\[1\].RAM16.SLICE\[1\].RAM8.WORD\[5\].W.BYTE\[1\].B.CLK_B
+ sky130_fd_sc_hd__inv_1
XSLICE_16\[0\].RAM16.Do0_REG.OUTREG_BYTE\[3\].Do_FF\[6\] SLICE_16\[0\].RAM16.Do0_REG.CLKBUF\[3\]
+ SLICE_16\[0\].RAM16.BYTE\[3\].FLOATBUF0\[30\].Z VGND VGND VPWR VPWR Do0MUX.A0\[30\]
+ sky130_fd_sc_hd__dfxtp_1
Xtap_13_2 VGND VPWR sky130_fd_sc_hd__tapvpwrvgnd_1
XSLICE_16\[0\].RAM16.SLICE\[1\].RAM8.WORD\[2\].W.BYTE\[0\].B.BIT\[1\].OBUF0 SLICE_16\[0\].RAM16.SLICE\[1\].RAM8.WORD\[2\].W.BYTE\[0\].B.Q_WIRE\[1\]
+ SLICE_16\[0\].RAM16.SLICE\[1\].RAM8.WORD\[2\].W.BYTE\[0\].B.SEL0_B VGND VGND VPWR
+ VPWR SLICE_16\[0\].RAM16.BYTE\[0\].FLOATBUF0\[1\].Z sky130_fd_sc_hd__ebufn_2
XSLICE_16\[0\].RAM16.SLICE\[1\].RAM8.WORD\[6\].W.BYTE\[3\].B.BIT\[4\].OBUF0 SLICE_16\[0\].RAM16.SLICE\[1\].RAM8.WORD\[6\].W.BYTE\[3\].B.Q_WIRE\[4\]
+ SLICE_16\[0\].RAM16.SLICE\[1\].RAM8.WORD\[6\].W.BYTE\[3\].B.SEL0_B VGND VGND VPWR
+ VPWR SLICE_16\[0\].RAM16.BYTE\[3\].FLOATBUF0\[28\].Z sky130_fd_sc_hd__ebufn_2
Xtap_6_1 VGND VPWR sky130_fd_sc_hd__tapvpwrvgnd_1
Xfill_41_6 VGND VPWR sky130_fd_sc_hd__tapvpwrvgnd_1
XSLICE_16\[1\].RAM16.SLICE\[1\].RAM8.WORD\[7\].W.BYTE\[2\].B.BIT\[3\].genblk1.STORAGE
+ DIBUF\[19\].X SLICE_16\[1\].RAM16.SLICE\[1\].RAM8.WORD\[7\].W.BYTE\[2\].B.GCLK VGND
+ VGND VPWR VPWR SLICE_16\[1\].RAM16.SLICE\[1\].RAM8.WORD\[7\].W.BYTE\[2\].B.Q_WIRE\[3\]
+ sky130_fd_sc_hd__dlxtp_1
Xfill_34_5 VGND VPWR sky130_fd_sc_hd__tapvpwrvgnd_1
XSLICE_16\[1\].RAM16.SLICE\[1\].RAM8.WORD\[1\].W.BYTE\[3\].B.BIT\[4\].genblk1.STORAGE
+ DIBUF\[28\].X SLICE_16\[1\].RAM16.SLICE\[1\].RAM8.WORD\[1\].W.BYTE\[3\].B.GCLK VGND
+ VGND VPWR VPWR SLICE_16\[1\].RAM16.SLICE\[1\].RAM8.WORD\[1\].W.BYTE\[3\].B.Q_WIRE\[4\]
+ sky130_fd_sc_hd__dlxtp_1
Xfill_27_4 VGND VGND VPWR VPWR sky130_fd_sc_hd__decap_4
XSLICE_16\[0\].RAM16.SLICE\[0\].RAM8.WORD\[1\].W.BYTE\[2\].B.BIT\[3\].OBUF0 SLICE_16\[0\].RAM16.SLICE\[0\].RAM8.WORD\[1\].W.BYTE\[2\].B.Q_WIRE\[3\]
+ SLICE_16\[0\].RAM16.SLICE\[0\].RAM8.WORD\[1\].W.BYTE\[2\].B.SEL0_B VGND VGND VPWR
+ VPWR SLICE_16\[0\].RAM16.BYTE\[2\].FLOATBUF0\[19\].Z sky130_fd_sc_hd__ebufn_2
XSLICE_16\[1\].RAM16.SLICE\[1\].RAM8.WORD\[5\].W.BYTE\[0\].B.BIT\[2\].genblk1.STORAGE
+ DIBUF\[2\].X SLICE_16\[1\].RAM16.SLICE\[1\].RAM8.WORD\[5\].W.BYTE\[0\].B.GCLK VGND
+ VGND VPWR VPWR SLICE_16\[1\].RAM16.SLICE\[1\].RAM8.WORD\[5\].W.BYTE\[0\].B.Q_WIRE\[2\]
+ sky130_fd_sc_hd__dlxtp_1
XSLICE_16\[1\].RAM16.SLICE\[1\].RAM8.WORD\[3\].W.BYTE\[2\].B.BIT\[0\].OBUF0 SLICE_16\[1\].RAM16.SLICE\[1\].RAM8.WORD\[3\].W.BYTE\[2\].B.Q_WIRE\[0\]
+ SLICE_16\[1\].RAM16.SLICE\[1\].RAM8.WORD\[3\].W.BYTE\[2\].B.SEL0_B VGND VGND VPWR
+ VPWR SLICE_16\[1\].RAM16.BYTE\[2\].FLOATBUF0\[16\].Z sky130_fd_sc_hd__ebufn_2
XSLICE_16\[0\].RAM16.SLICE\[0\].RAM8.WORD\[2\].W.CLKBUF SLICE_16\[0\].RAM16.SLICE\[0\].RAM8.CLKBUF.X
+ VGND VGND VPWR VPWR SLICE_16\[0\].RAM16.SLICE\[0\].RAM8.WORD\[2\].W.BYTE\[0\].B.CLK
+ sky130_fd_sc_hd__clkbuf_4
XSLICE_16\[0\].RAM16.SLICE\[0\].RAM8.WORD\[6\].W.BYTE\[1\].B.genblk1.CG SLICE_16\[0\].RAM16.SLICE\[0\].RAM8.WORD\[6\].W.BYTE\[1\].B.CLK_B
+ SLICE_16\[0\].RAM16.SLICE\[0\].RAM8.WORD\[6\].W.BYTE\[1\].B.WE0_WIRE VGND VGND VPWR
+ VPWR SLICE_16\[0\].RAM16.SLICE\[0\].RAM8.WORD\[6\].W.BYTE\[1\].B.GCLK sky130_fd_sc_hd__dlclkp_1
XSLICE_16\[0\].RAM16.SLICE\[1\].RAM8.WORD\[2\].W.BYTE\[3\].B.BIT\[0\].genblk1.STORAGE
+ DIBUF\[24\].X SLICE_16\[0\].RAM16.SLICE\[1\].RAM8.WORD\[2\].W.BYTE\[3\].B.GCLK VGND
+ VGND VPWR VPWR SLICE_16\[0\].RAM16.SLICE\[1\].RAM8.WORD\[2\].W.BYTE\[3\].B.Q_WIRE\[0\]
+ sky130_fd_sc_hd__dlxtp_1
Xfill_18_17 VGND VGND VPWR VPWR sky130_fd_sc_hd__decap_12
XSLICE_16\[0\].RAM16.SLICE\[1\].RAM8.WORD\[5\].W.BYTE\[1\].B.BIT\[1\].OBUF0 SLICE_16\[0\].RAM16.SLICE\[1\].RAM8.WORD\[5\].W.BYTE\[1\].B.Q_WIRE\[1\]
+ SLICE_16\[0\].RAM16.SLICE\[1\].RAM8.WORD\[5\].W.BYTE\[1\].B.SEL0_B VGND VGND VPWR
+ VPWR SLICE_16\[0\].RAM16.BYTE\[1\].FLOATBUF0\[9\].Z sky130_fd_sc_hd__ebufn_2
Xfill_18_28 VGND VPWR sky130_fd_sc_hd__tapvpwrvgnd_1
XSLICE_16\[0\].RAM16.SLICE\[0\].RAM8.WORD\[0\].W.BYTE\[0\].B.BIT\[0\].OBUF0 SLICE_16\[0\].RAM16.SLICE\[0\].RAM8.WORD\[0\].W.BYTE\[0\].B.Q_WIRE\[0\]
+ SLICE_16\[0\].RAM16.SLICE\[0\].RAM8.WORD\[0\].W.BYTE\[0\].B.SEL0_B VGND VGND VPWR
+ VPWR SLICE_16\[0\].RAM16.BYTE\[0\].FLOATBUF0\[0\].Z sky130_fd_sc_hd__ebufn_2
Xtap_11_20 VGND VPWR sky130_fd_sc_hd__tapvpwrvgnd_1
Xtap_11_31 VGND VPWR sky130_fd_sc_hd__tapvpwrvgnd_1
XSLICE_16\[0\].RAM16.SLICE\[0\].RAM8.WORD\[5\].W.BYTE\[0\].B.genblk1.CLKINV SLICE_16\[0\].RAM16.SLICE\[0\].RAM8.WORD\[5\].W.BYTE\[0\].B.CLK
+ VGND VGND VPWR VPWR SLICE_16\[0\].RAM16.SLICE\[0\].RAM8.WORD\[5\].W.BYTE\[0\].B.CLK_B
+ sky130_fd_sc_hd__inv_1
XSLICE_16\[0\].RAM16.SLICE\[0\].RAM8.WORD\[5\].W.BYTE\[2\].B.BIT\[5\].genblk1.STORAGE
+ DIBUF\[21\].X SLICE_16\[0\].RAM16.SLICE\[0\].RAM8.WORD\[5\].W.BYTE\[2\].B.GCLK VGND
+ VGND VPWR VPWR SLICE_16\[0\].RAM16.SLICE\[0\].RAM8.WORD\[5\].W.BYTE\[2\].B.Q_WIRE\[5\]
+ sky130_fd_sc_hd__dlxtp_1
XSLICE_16\[0\].RAM16.SLICE\[0\].RAM8.WORD\[3\].W.BYTE\[0\].B.BIT\[4\].genblk1.STORAGE
+ DIBUF\[4\].X SLICE_16\[0\].RAM16.SLICE\[0\].RAM8.WORD\[3\].W.BYTE\[0\].B.GCLK VGND
+ VGND VPWR VPWR SLICE_16\[0\].RAM16.SLICE\[0\].RAM8.WORD\[3\].W.BYTE\[0\].B.Q_WIRE\[4\]
+ sky130_fd_sc_hd__dlxtp_1
XSLICE_16\[0\].RAM16.SLICE\[0\].RAM8.WORD\[4\].W.BYTE\[3\].B.BIT\[3\].OBUF0 SLICE_16\[0\].RAM16.SLICE\[0\].RAM8.WORD\[4\].W.BYTE\[3\].B.Q_WIRE\[3\]
+ SLICE_16\[0\].RAM16.SLICE\[0\].RAM8.WORD\[4\].W.BYTE\[3\].B.SEL0_B VGND VGND VPWR
+ VPWR SLICE_16\[0\].RAM16.BYTE\[3\].FLOATBUF0\[27\].Z sky130_fd_sc_hd__ebufn_2
XSLICE_16\[1\].RAM16.Do0_REG.OUTREG_BYTE\[3\].DIODE\[1\] SLICE_16\[1\].RAM16.BYTE\[3\].FLOATBUF0\[25\].Z
+ VGND VGND VPWR VPWR sky130_fd_sc_hd__diode_2
XSLICE_16\[1\].RAM16.SLICE\[1\].RAM8.WORD\[6\].W.BYTE\[3\].B.BIT\[0\].OBUF0 SLICE_16\[1\].RAM16.SLICE\[1\].RAM8.WORD\[6\].W.BYTE\[3\].B.Q_WIRE\[0\]
+ SLICE_16\[1\].RAM16.SLICE\[1\].RAM8.WORD\[6\].W.BYTE\[3\].B.SEL0_B VGND VGND VPWR
+ VPWR SLICE_16\[1\].RAM16.BYTE\[3\].FLOATBUF0\[24\].Z sky130_fd_sc_hd__ebufn_2
XSLICE_16\[1\].RAM16.SLICE\[0\].RAM8.WORD\[3\].W.BYTE\[0\].B.genblk1.CG SLICE_16\[1\].RAM16.SLICE\[0\].RAM8.WORD\[3\].W.BYTE\[0\].B.CLK_B
+ SLICE_16\[1\].RAM16.SLICE\[0\].RAM8.WORD\[3\].W.BYTE\[0\].B.WE0_WIRE VGND VGND VPWR
+ VPWR SLICE_16\[1\].RAM16.SLICE\[0\].RAM8.WORD\[3\].W.BYTE\[0\].B.GCLK sky130_fd_sc_hd__dlclkp_1
XSLICE_16\[1\].RAM16.SLICE\[0\].RAM8.WORD\[4\].W.BYTE\[1\].B.CGAND SLICE_16\[1\].RAM16.SLICE\[0\].RAM8.WORD\[4\].W.BYTE\[0\].B.SEL0
+ SLICE_16\[1\].RAM16.SLICE\[0\].RAM8.WE0_buf\[1\] VGND VGND VPWR VPWR SLICE_16\[1\].RAM16.SLICE\[0\].RAM8.WORD\[4\].W.BYTE\[1\].B.WE0_WIRE
+ sky130_fd_sc_hd__and2_1
XSLICE_16\[1\].RAM16.SLICE\[1\].RAM8.WORD\[3\].W.BYTE\[0\].B.BIT\[5\].OBUF0 SLICE_16\[1\].RAM16.SLICE\[1\].RAM8.WORD\[3\].W.BYTE\[0\].B.Q_WIRE\[5\]
+ SLICE_16\[1\].RAM16.SLICE\[1\].RAM8.WORD\[3\].W.BYTE\[0\].B.SEL0_B VGND VGND VPWR
+ VPWR SLICE_16\[1\].RAM16.BYTE\[0\].FLOATBUF0\[5\].Z sky130_fd_sc_hd__ebufn_2
XSLICE_16\[1\].RAM16.BYTE\[1\].FLOATBUF0\[14\].__cell__ SLICE_16\[1\].RAM16.BYTE\[1\].FLOATBUF0\[10\].A
+ SLICE_16\[1\].RAM16.BYTE\[1\].FLOATBUF0\[10\].TE_B VGND VGND VPWR VPWR SLICE_16\[1\].RAM16.BYTE\[1\].FLOATBUF0\[14\].Z
+ sky130_fd_sc_hd__ebufn_2
Xfill_32_2 VGND VPWR sky130_fd_sc_hd__tapvpwrvgnd_1
Xtap_32_19 VGND VPWR sky130_fd_sc_hd__tapvpwrvgnd_1
XSLICE_16\[1\].RAM16.DEC0.AND1 SLICE_16\[1\].RAM16.A0BUF\[3\].X SLICE_16\[1\].RAM16.DEC0.EN
+ VGND VGND VPWR VPWR SLICE_16\[1\].RAM16.DEC0.SEL\[1\] sky130_fd_sc_hd__and2_2
XSLICE_16\[1\].RAM16.SLICE\[0\].RAM8.DEC0.AND7 SLICE_16\[1\].RAM16.SLICE\[0\].RAM8.DEC0.A_buf\[0\]
+ SLICE_16\[1\].RAM16.SLICE\[0\].RAM8.DEC0.A_buf\[1\] SLICE_16\[1\].RAM16.SLICE\[0\].RAM8.DEC0.A_buf\[2\]
+ SLICE_16\[1\].RAM16.SLICE\[0\].RAM8.DEC0.EN_buf VGND VGND VPWR VPWR SLICE_16\[1\].RAM16.SLICE\[0\].RAM8.DEC0.SEL\[7\]
+ sky130_fd_sc_hd__and4_2
Xfill_25_1 VGND VPWR sky130_fd_sc_hd__tapvpwrvgnd_1
Xfill_18_0 VGND VPWR sky130_fd_sc_hd__tapvpwrvgnd_1
XSLICE_16\[0\].RAM16.SLICE\[0\].RAM8.WORD\[3\].W.BYTE\[1\].B.BIT\[0\].OBUF0 SLICE_16\[0\].RAM16.SLICE\[0\].RAM8.WORD\[3\].W.BYTE\[1\].B.Q_WIRE\[0\]
+ SLICE_16\[0\].RAM16.SLICE\[0\].RAM8.WORD\[3\].W.BYTE\[1\].B.SEL0_B VGND VGND VPWR
+ VPWR SLICE_16\[0\].RAM16.BYTE\[1\].FLOATBUF0\[8\].Z sky130_fd_sc_hd__ebufn_2
Xtap_47_8 VGND VPWR sky130_fd_sc_hd__tapvpwrvgnd_1
XSLICE_16\[1\].RAM16.SLICE\[0\].RAM8.WORD\[2\].W.BYTE\[2\].B.BIT\[7\].OBUF0 SLICE_16\[1\].RAM16.SLICE\[0\].RAM8.WORD\[2\].W.BYTE\[2\].B.Q_WIRE\[7\]
+ SLICE_16\[1\].RAM16.SLICE\[0\].RAM8.WORD\[2\].W.BYTE\[2\].B.SEL0_B VGND VGND VPWR
+ VPWR SLICE_16\[1\].RAM16.BYTE\[2\].FLOATBUF0\[23\].Z sky130_fd_sc_hd__ebufn_2
Xfill_20_29 VGND VGND VPWR VPWR sky130_fd_sc_hd__decap_12
Xfill_20_18 VGND VPWR sky130_fd_sc_hd__tapvpwrvgnd_1
Xtap_3_12 VGND VPWR sky130_fd_sc_hd__tapvpwrvgnd_1
Xtap_3_23 VGND VPWR sky130_fd_sc_hd__tapvpwrvgnd_1
Xtap_3_34 VGND VPWR sky130_fd_sc_hd__tapvpwrvgnd_1
XSLICE_16\[1\].RAM16.SLICE\[1\].RAM8.WORD\[2\].W.BYTE\[2\].B.BIT\[3\].genblk1.STORAGE
+ DIBUF\[19\].X SLICE_16\[1\].RAM16.SLICE\[1\].RAM8.WORD\[2\].W.BYTE\[2\].B.GCLK VGND
+ VGND VPWR VPWR SLICE_16\[1\].RAM16.SLICE\[1\].RAM8.WORD\[2\].W.BYTE\[2\].B.Q_WIRE\[3\]
+ sky130_fd_sc_hd__dlxtp_1
XSLICE_16\[1\].RAM16.SLICE\[1\].RAM8.WORD\[0\].W.BYTE\[0\].B.BIT\[2\].genblk1.STORAGE
+ DIBUF\[2\].X SLICE_16\[1\].RAM16.SLICE\[1\].RAM8.WORD\[0\].W.BYTE\[0\].B.GCLK VGND
+ VGND VPWR VPWR SLICE_16\[1\].RAM16.SLICE\[1\].RAM8.WORD\[0\].W.BYTE\[0\].B.Q_WIRE\[2\]
+ sky130_fd_sc_hd__dlxtp_1
Xfill_45_59 VGND VGND VPWR VPWR sky130_fd_sc_hd__decap_12
Xfill_45_48 VGND VPWR sky130_fd_sc_hd__tapvpwrvgnd_1
Xfill_45_37 VGND VGND VPWR VPWR sky130_fd_sc_hd__decap_12
Xfill_45_26 VGND VGND VPWR VPWR sky130_fd_sc_hd__decap_12
Xfill_45_15 VGND VPWR sky130_fd_sc_hd__tapvpwrvgnd_1
Xfill_21_100 VGND VGND VPWR VPWR sky130_fd_sc_hd__decap_12
XSLICE_16\[0\].RAM16.SLICE\[0\].RAM8.WORD\[6\].W.BYTE\[3\].B.CGAND SLICE_16\[0\].RAM16.SLICE\[0\].RAM8.WORD\[6\].W.BYTE\[0\].B.SEL0
+ SLICE_16\[0\].RAM16.SLICE\[0\].RAM8.WE0_buf\[3\] VGND VGND VPWR VPWR SLICE_16\[0\].RAM16.SLICE\[0\].RAM8.WORD\[6\].W.BYTE\[3\].B.WE0_WIRE
+ sky130_fd_sc_hd__and2_1
XSLICE_16\[1\].RAM16.Do0_REG.OUTREG_BYTE\[2\].Do_FF\[2\] SLICE_16\[1\].RAM16.Do0_REG.CLKBUF\[2\]
+ SLICE_16\[1\].RAM16.BYTE\[2\].FLOATBUF0\[18\].Z VGND VGND VPWR VPWR Do0MUX.A1\[18\]
+ sky130_fd_sc_hd__dfxtp_1
XSLICE_16\[1\].RAM16.SLICE\[1\].RAM8.WORD\[6\].W.BYTE\[1\].B.BIT\[5\].OBUF0 SLICE_16\[1\].RAM16.SLICE\[1\].RAM8.WORD\[6\].W.BYTE\[1\].B.Q_WIRE\[5\]
+ SLICE_16\[1\].RAM16.SLICE\[1\].RAM8.WORD\[6\].W.BYTE\[1\].B.SEL0_B VGND VGND VPWR
+ VPWR SLICE_16\[1\].RAM16.BYTE\[1\].FLOATBUF0\[13\].Z sky130_fd_sc_hd__ebufn_2
XSLICE_16\[1\].RAM16.SLICE\[0\].RAM8.WORD\[1\].W.BYTE\[2\].B.DIODE_CLK SLICE_16\[1\].RAM16.SLICE\[0\].RAM8.WORD\[1\].W.BYTE\[0\].B.CLK
+ VGND VGND VPWR VPWR sky130_fd_sc_hd__diode_2
Xfill_19_93 VGND VPWR sky130_fd_sc_hd__tapvpwrvgnd_1
Xfill_19_82 VGND VGND VPWR VPWR sky130_fd_sc_hd__decap_12
Xfill_19_71 VGND VGND VPWR VPWR sky130_fd_sc_hd__decap_12
Xfill_19_60 VGND VPWR sky130_fd_sc_hd__tapvpwrvgnd_1
XSLICE_16\[1\].RAM16.SLICE\[0\].RAM8.WORD\[3\].W.SEL0BUF SLICE_16\[1\].RAM16.SLICE\[0\].RAM8.DEC0.SEL\[3\]
+ VGND VGND VPWR VPWR SLICE_16\[1\].RAM16.SLICE\[0\].RAM8.WORD\[3\].W.BYTE\[0\].B.SEL0
+ sky130_fd_sc_hd__clkbuf_2
XSLICE_16\[1\].RAM16.SLICE\[0\].RAM8.WORD\[1\].W.BYTE\[0\].B.BIT\[4\].OBUF0 SLICE_16\[1\].RAM16.SLICE\[0\].RAM8.WORD\[1\].W.BYTE\[0\].B.Q_WIRE\[4\]
+ SLICE_16\[1\].RAM16.SLICE\[0\].RAM8.WORD\[1\].W.BYTE\[0\].B.SEL0_B VGND VGND VPWR
+ VPWR SLICE_16\[1\].RAM16.BYTE\[0\].FLOATBUF0\[4\].Z sky130_fd_sc_hd__ebufn_2
XSLICE_16\[0\].RAM16.SLICE\[0\].RAM8.WORD\[6\].W.BYTE\[2\].B.BIT\[0\].OBUF0 SLICE_16\[0\].RAM16.SLICE\[0\].RAM8.WORD\[6\].W.BYTE\[2\].B.Q_WIRE\[0\]
+ SLICE_16\[0\].RAM16.SLICE\[0\].RAM8.WORD\[6\].W.BYTE\[2\].B.SEL0_B VGND VGND VPWR
+ VPWR SLICE_16\[0\].RAM16.BYTE\[2\].FLOATBUF0\[16\].Z sky130_fd_sc_hd__ebufn_2
XSLICE_16\[1\].RAM16.SLICE\[0\].RAM8.WORD\[5\].W.BYTE\[3\].B.BIT\[7\].OBUF0 SLICE_16\[1\].RAM16.SLICE\[0\].RAM8.WORD\[5\].W.BYTE\[3\].B.Q_WIRE\[7\]
+ SLICE_16\[1\].RAM16.SLICE\[0\].RAM8.WORD\[5\].W.BYTE\[3\].B.SEL0_B VGND VGND VPWR
+ VPWR SLICE_16\[1\].RAM16.BYTE\[3\].FLOATBUF0\[31\].Z sky130_fd_sc_hd__ebufn_2
XSLICE_16\[0\].RAM16.BYTE\[3\].FLOATBUF0\[28\].__cell__ SLICE_16\[0\].RAM16.BYTE\[3\].FLOATBUF0\[24\].A
+ SLICE_16\[0\].RAM16.BYTE\[3\].FLOATBUF0\[24\].TE_B VGND VGND VPWR VPWR SLICE_16\[0\].RAM16.BYTE\[3\].FLOATBUF0\[28\].Z
+ sky130_fd_sc_hd__ebufn_2
XSLICE_16\[0\].RAM16.SLICE\[0\].RAM8.WORD\[0\].W.BYTE\[2\].B.BIT\[5\].genblk1.STORAGE
+ DIBUF\[21\].X SLICE_16\[0\].RAM16.SLICE\[0\].RAM8.WORD\[0\].W.BYTE\[2\].B.GCLK VGND
+ VGND VPWR VPWR SLICE_16\[0\].RAM16.SLICE\[0\].RAM8.WORD\[0\].W.BYTE\[2\].B.Q_WIRE\[5\]
+ sky130_fd_sc_hd__dlxtp_1
XSLICE_16\[0\].RAM16.SLICE\[0\].RAM8.WORD\[4\].W.BYTE\[1\].B.DIODE_CLK SLICE_16\[0\].RAM16.SLICE\[0\].RAM8.WORD\[4\].W.BYTE\[0\].B.CLK
+ VGND VGND VPWR VPWR sky130_fd_sc_hd__diode_2
XSLICE_16\[0\].RAM16.SLICE\[0\].RAM8.WORD\[6\].W.BYTE\[1\].B.BIT\[4\].genblk1.STORAGE
+ DIBUF\[12\].X SLICE_16\[0\].RAM16.SLICE\[0\].RAM8.WORD\[6\].W.BYTE\[1\].B.GCLK VGND
+ VGND VPWR VPWR SLICE_16\[0\].RAM16.SLICE\[0\].RAM8.WORD\[6\].W.BYTE\[1\].B.Q_WIRE\[4\]
+ sky130_fd_sc_hd__dlxtp_1
XSLICE_16\[1\].RAM16.SLICE\[1\].RAM8.WORD\[5\].W.BYTE\[0\].B.CGAND SLICE_16\[1\].RAM16.SLICE\[1\].RAM8.WORD\[5\].W.BYTE\[0\].B.SEL0
+ SLICE_16\[1\].RAM16.SLICE\[1\].RAM8.WE0_buf\[0\] VGND VGND VPWR VPWR SLICE_16\[1\].RAM16.SLICE\[1\].RAM8.WORD\[5\].W.BYTE\[0\].B.WE0_WIRE
+ sky130_fd_sc_hd__and2_1
Xtap_27_19 VGND VPWR sky130_fd_sc_hd__tapvpwrvgnd_1
Xtap_38_4 VGND VPWR sky130_fd_sc_hd__tapvpwrvgnd_1
XSLICE_16\[1\].RAM16.SLICE\[1\].RAM8.WORD\[5\].W.BYTE\[3\].B.BIT\[3\].genblk1.STORAGE
+ DIBUF\[27\].X SLICE_16\[1\].RAM16.SLICE\[1\].RAM8.WORD\[5\].W.BYTE\[3\].B.GCLK VGND
+ VGND VPWR VPWR SLICE_16\[1\].RAM16.SLICE\[1\].RAM8.WORD\[5\].W.BYTE\[3\].B.Q_WIRE\[3\]
+ sky130_fd_sc_hd__dlxtp_1
XSLICE_16\[1\].RAM16.SLICE\[0\].RAM8.WORD\[4\].W.BYTE\[1\].B.BIT\[4\].OBUF0 SLICE_16\[1\].RAM16.SLICE\[0\].RAM8.WORD\[4\].W.BYTE\[1\].B.Q_WIRE\[4\]
+ SLICE_16\[1\].RAM16.SLICE\[0\].RAM8.WORD\[4\].W.BYTE\[1\].B.SEL0_B VGND VGND VPWR
+ VPWR SLICE_16\[1\].RAM16.BYTE\[1\].FLOATBUF0\[12\].Z sky130_fd_sc_hd__ebufn_2
XSLICE_16\[0\].RAM16.SLICE\[1\].RAM8.WORD\[1\].W.BYTE\[3\].B.BIT\[3\].OBUF0 SLICE_16\[0\].RAM16.SLICE\[1\].RAM8.WORD\[1\].W.BYTE\[3\].B.Q_WIRE\[3\]
+ SLICE_16\[0\].RAM16.SLICE\[1\].RAM8.WORD\[1\].W.BYTE\[3\].B.SEL0_B VGND VGND VPWR
+ VPWR SLICE_16\[0\].RAM16.BYTE\[3\].FLOATBUF0\[27\].Z sky130_fd_sc_hd__ebufn_2
XSLICE_16\[0\].RAM16.SLICE\[1\].RAM8.WORD\[2\].W.BYTE\[0\].B.genblk1.CLKINV SLICE_16\[0\].RAM16.SLICE\[1\].RAM8.WORD\[2\].W.BYTE\[0\].B.CLK
+ VGND VGND VPWR VPWR SLICE_16\[0\].RAM16.SLICE\[1\].RAM8.WORD\[2\].W.BYTE\[0\].B.CLK_B
+ sky130_fd_sc_hd__inv_1
XSLICE_16\[1\].RAM16.SLICE\[1\].RAM8.WORD\[3\].W.BYTE\[1\].B.BIT\[2\].genblk1.STORAGE
+ DIBUF\[10\].X SLICE_16\[1\].RAM16.SLICE\[1\].RAM8.WORD\[3\].W.BYTE\[1\].B.GCLK VGND
+ VGND VPWR VPWR SLICE_16\[1\].RAM16.SLICE\[1\].RAM8.WORD\[3\].W.BYTE\[1\].B.Q_WIRE\[2\]
+ sky130_fd_sc_hd__dlxtp_1
Xfill_21_94 VGND VGND VPWR VPWR sky130_fd_sc_hd__decap_12
Xfill_21_83 VGND VGND VPWR VPWR sky130_fd_sc_hd__decap_12
Xfill_21_72 VGND VPWR sky130_fd_sc_hd__tapvpwrvgnd_1
Xfill_21_61 VGND VGND VPWR VPWR sky130_fd_sc_hd__decap_12
Xfill_21_50 VGND VGND VPWR VPWR sky130_fd_sc_hd__decap_12
XSLICE_16\[0\].RAM16.SLICE\[1\].RAM8.WORD\[7\].W.BYTE\[2\].B.CGAND SLICE_16\[0\].RAM16.SLICE\[1\].RAM8.WORD\[7\].W.BYTE\[0\].B.SEL0
+ SLICE_16\[0\].RAM16.SLICE\[1\].RAM8.WE0_buf\[2\] VGND VGND VPWR VPWR SLICE_16\[0\].RAM16.SLICE\[1\].RAM8.WORD\[7\].W.BYTE\[2\].B.WE0_WIRE
+ sky130_fd_sc_hd__and2_1
XSLICE_16\[0\].RAM16.SLICE\[0\].RAM8.WORD\[6\].W.BYTE\[0\].B.BIT\[5\].OBUF0 SLICE_16\[0\].RAM16.SLICE\[0\].RAM8.WORD\[6\].W.BYTE\[0\].B.Q_WIRE\[5\]
+ SLICE_16\[0\].RAM16.SLICE\[0\].RAM8.WORD\[6\].W.BYTE\[0\].B.SEL0_B VGND VGND VPWR
+ VPWR SLICE_16\[0\].RAM16.BYTE\[0\].FLOATBUF0\[5\].Z sky130_fd_sc_hd__ebufn_2
Xfill_46_91 VGND VGND VPWR VPWR sky130_fd_sc_hd__decap_12
Xfill_46_80 VGND VGND VPWR VPWR sky130_fd_sc_hd__decap_12
Xtap_38_29 VGND VPWR sky130_fd_sc_hd__tapvpwrvgnd_1
Xtap_38_18 VGND VPWR sky130_fd_sc_hd__tapvpwrvgnd_1
XSLICE_16\[1\].RAM16.SLICE\[0\].RAM8.WORD\[6\].W.BYTE\[0\].B.BIT\[7\].genblk1.STORAGE
+ DIBUF\[7\].X SLICE_16\[1\].RAM16.SLICE\[0\].RAM8.WORD\[6\].W.BYTE\[0\].B.GCLK VGND
+ VGND VPWR VPWR SLICE_16\[1\].RAM16.SLICE\[0\].RAM8.WORD\[6\].W.BYTE\[0\].B.Q_WIRE\[7\]
+ sky130_fd_sc_hd__dlxtp_1
XSLICE_16\[0\].RAM16.Do0_REG.OUTREG_BYTE\[1\].DIODE\[2\] SLICE_16\[0\].RAM16.BYTE\[1\].FLOATBUF0\[10\].Z
+ VGND VGND VPWR VPWR sky130_fd_sc_hd__diode_2
Xtap_17_9 VGND VPWR sky130_fd_sc_hd__tapvpwrvgnd_1
XSLICE_16\[0\].RAM16.SLICE\[1\].RAM8.WORD\[5\].W.BYTE\[1\].B.genblk1.CLKINV SLICE_16\[0\].RAM16.SLICE\[1\].RAM8.WORD\[5\].W.BYTE\[0\].B.CLK
+ VGND VGND VPWR VPWR SLICE_16\[0\].RAM16.SLICE\[1\].RAM8.WORD\[5\].W.BYTE\[1\].B.CLK_B
+ sky130_fd_sc_hd__inv_1
Xtap_0_24 VGND VPWR sky130_fd_sc_hd__tapvpwrvgnd_1
Xtap_0_13 VGND VPWR sky130_fd_sc_hd__tapvpwrvgnd_1
XSLICE_16\[0\].RAM16.SLICE\[1\].RAM8.WORD\[0\].W.BYTE\[1\].B.BIT\[0\].OBUF0 SLICE_16\[0\].RAM16.SLICE\[1\].RAM8.WORD\[0\].W.BYTE\[1\].B.Q_WIRE\[0\]
+ SLICE_16\[0\].RAM16.SLICE\[1\].RAM8.WORD\[0\].W.BYTE\[1\].B.SEL0_B VGND VGND VPWR
+ VPWR SLICE_16\[0\].RAM16.BYTE\[1\].FLOATBUF0\[8\].Z sky130_fd_sc_hd__ebufn_2
Xtap_9_11 VGND VPWR sky130_fd_sc_hd__tapvpwrvgnd_1
Xfill_42_49 VGND VGND VPWR VPWR sky130_fd_sc_hd__decap_12
Xfill_42_38 VGND VGND VPWR VPWR sky130_fd_sc_hd__decap_12
Xfill_42_27 VGND VPWR sky130_fd_sc_hd__tapvpwrvgnd_1
Xfill_42_16 VGND VGND VPWR VPWR sky130_fd_sc_hd__decap_12
XSLICE_16\[1\].RAM16.SLICE\[0\].RAM8.WORD\[7\].W.BYTE\[2\].B.BIT\[4\].OBUF0 SLICE_16\[1\].RAM16.SLICE\[0\].RAM8.WORD\[7\].W.BYTE\[2\].B.Q_WIRE\[4\]
+ SLICE_16\[1\].RAM16.SLICE\[0\].RAM8.WORD\[7\].W.BYTE\[2\].B.SEL0_B VGND VGND VPWR
+ VPWR SLICE_16\[1\].RAM16.BYTE\[2\].FLOATBUF0\[20\].Z sky130_fd_sc_hd__ebufn_2
XSLICE_16\[0\].RAM16.SLICE\[0\].RAM8.WORD\[3\].W.BYTE\[3\].B.BIT\[5\].genblk1.STORAGE
+ DIBUF\[29\].X SLICE_16\[0\].RAM16.SLICE\[0\].RAM8.WORD\[3\].W.BYTE\[3\].B.GCLK VGND
+ VGND VPWR VPWR SLICE_16\[0\].RAM16.SLICE\[0\].RAM8.WORD\[3\].W.BYTE\[3\].B.Q_WIRE\[5\]
+ sky130_fd_sc_hd__dlxtp_1
Xtap_9_22 VGND VPWR sky130_fd_sc_hd__tapvpwrvgnd_1
Xtap_9_33 VGND VPWR sky130_fd_sc_hd__tapvpwrvgnd_1
Xtap_36_1 VGND VPWR sky130_fd_sc_hd__tapvpwrvgnd_1
XSLICE_16\[1\].RAM16.SLICE\[1\].RAM8.WORD\[3\].W.BYTE\[2\].B.DIODE_CLK SLICE_16\[1\].RAM16.SLICE\[1\].RAM8.WORD\[3\].W.BYTE\[0\].B.CLK
+ VGND VGND VPWR VPWR sky130_fd_sc_hd__diode_2
XSLICE_16\[0\].RAM16.SLICE\[0\].RAM8.WORD\[1\].W.SEL0BUF SLICE_16\[0\].RAM16.SLICE\[0\].RAM8.DEC0.SEL\[1\]
+ VGND VGND VPWR VPWR SLICE_16\[0\].RAM16.SLICE\[0\].RAM8.WORD\[1\].W.BYTE\[0\].B.SEL0
+ sky130_fd_sc_hd__clkbuf_2
XSLICE_16\[0\].RAM16.SLICE\[0\].RAM8.WORD\[1\].W.BYTE\[1\].B.BIT\[4\].genblk1.STORAGE
+ DIBUF\[12\].X SLICE_16\[0\].RAM16.SLICE\[0\].RAM8.WORD\[1\].W.BYTE\[1\].B.GCLK VGND
+ VGND VPWR VPWR SLICE_16\[0\].RAM16.SLICE\[0\].RAM8.WORD\[1\].W.BYTE\[1\].B.Q_WIRE\[4\]
+ sky130_fd_sc_hd__dlxtp_1
XSLICE_16\[0\].RAM16.SLICE\[0\].RAM8.WORD\[7\].W.BYTE\[0\].B.BIT\[3\].genblk1.STORAGE
+ DIBUF\[3\].X SLICE_16\[0\].RAM16.SLICE\[0\].RAM8.WORD\[7\].W.BYTE\[0\].B.GCLK VGND
+ VGND VPWR VPWR SLICE_16\[0\].RAM16.SLICE\[0\].RAM8.WORD\[7\].W.BYTE\[0\].B.Q_WIRE\[3\]
+ sky130_fd_sc_hd__dlxtp_1
XDo0MUX.M\[0\].DIODE_A1MUX\[5\] Do0MUX.A1\[5\] VGND VGND VPWR VPWR sky130_fd_sc_hd__diode_2
Xtap_29_0 VGND VPWR sky130_fd_sc_hd__tapvpwrvgnd_1
XSLICE_16\[1\].RAM16.SLICE\[0\].RAM8.WORD\[0\].W.BYTE\[0\].B.CGAND SLICE_16\[1\].RAM16.SLICE\[0\].RAM8.WORD\[0\].W.BYTE\[0\].B.SEL0
+ SLICE_16\[1\].RAM16.SLICE\[0\].RAM8.WE0_buf\[0\] VGND VGND VPWR VPWR SLICE_16\[1\].RAM16.SLICE\[0\].RAM8.WORD\[0\].W.BYTE\[0\].B.WE0_WIRE
+ sky130_fd_sc_hd__and2_1
XSLICE_16\[0\].RAM16.SLICE\[1\].RAM8.WORD\[6\].W.BYTE\[1\].B.DIODE_CLK SLICE_16\[0\].RAM16.SLICE\[1\].RAM8.WORD\[6\].W.BYTE\[0\].B.CLK
+ VGND VGND VPWR VPWR sky130_fd_sc_hd__diode_2
XSLICE_16\[1\].RAM16.SLICE\[0\].RAM8.WORD\[6\].W.BYTE\[0\].B.BIT\[1\].OBUF0 SLICE_16\[1\].RAM16.SLICE\[0\].RAM8.WORD\[6\].W.BYTE\[0\].B.Q_WIRE\[1\]
+ SLICE_16\[1\].RAM16.SLICE\[0\].RAM8.WORD\[6\].W.BYTE\[0\].B.SEL0_B VGND VGND VPWR
+ VPWR SLICE_16\[1\].RAM16.BYTE\[0\].FLOATBUF0\[1\].Z sky130_fd_sc_hd__ebufn_2
XSLICE_16\[0\].RAM16.SLICE\[1\].RAM8.WORD\[3\].W.BYTE\[2\].B.BIT\[0\].OBUF0 SLICE_16\[0\].RAM16.SLICE\[1\].RAM8.WORD\[3\].W.BYTE\[2\].B.Q_WIRE\[0\]
+ SLICE_16\[0\].RAM16.SLICE\[1\].RAM8.WORD\[3\].W.BYTE\[2\].B.SEL0_B VGND VGND VPWR
+ VPWR SLICE_16\[0\].RAM16.BYTE\[2\].FLOATBUF0\[16\].Z sky130_fd_sc_hd__ebufn_2
XSLICE_16\[0\].RAM16.SLICE\[0\].RAM8.WORD\[2\].W.BYTE\[0\].B.genblk1.CG SLICE_16\[0\].RAM16.SLICE\[0\].RAM8.WORD\[2\].W.BYTE\[0\].B.CLK_B
+ SLICE_16\[0\].RAM16.SLICE\[0\].RAM8.WORD\[2\].W.BYTE\[0\].B.WE0_WIRE VGND VGND VPWR
+ VPWR SLICE_16\[0\].RAM16.SLICE\[0\].RAM8.WORD\[2\].W.BYTE\[0\].B.GCLK sky130_fd_sc_hd__dlclkp_1
Xtap_40_19 VGND VPWR sky130_fd_sc_hd__tapvpwrvgnd_1
XSLICE_16\[1\].RAM16.SLICE\[1\].RAM8.WORD\[6\].W.BYTE\[2\].B.BIT\[2\].genblk1.STORAGE
+ DIBUF\[18\].X SLICE_16\[1\].RAM16.SLICE\[1\].RAM8.WORD\[6\].W.BYTE\[2\].B.GCLK VGND
+ VGND VPWR VPWR SLICE_16\[1\].RAM16.SLICE\[1\].RAM8.WORD\[6\].W.BYTE\[2\].B.Q_WIRE\[2\]
+ sky130_fd_sc_hd__dlxtp_1
XSLICE_16\[1\].RAM16.SLICE\[1\].RAM8.WORD\[2\].W.BYTE\[3\].B.BIT\[7\].OBUF0 SLICE_16\[1\].RAM16.SLICE\[1\].RAM8.WORD\[2\].W.BYTE\[3\].B.Q_WIRE\[7\]
+ SLICE_16\[1\].RAM16.SLICE\[1\].RAM8.WORD\[2\].W.BYTE\[3\].B.SEL0_B VGND VGND VPWR
+ VPWR SLICE_16\[1\].RAM16.BYTE\[3\].FLOATBUF0\[31\].Z sky130_fd_sc_hd__ebufn_2
XSLICE_16\[1\].RAM16.SLICE\[1\].RAM8.WORD\[0\].W.BYTE\[3\].B.BIT\[3\].genblk1.STORAGE
+ DIBUF\[27\].X SLICE_16\[1\].RAM16.SLICE\[1\].RAM8.WORD\[0\].W.BYTE\[3\].B.GCLK VGND
+ VGND VPWR VPWR SLICE_16\[1\].RAM16.SLICE\[1\].RAM8.WORD\[0\].W.BYTE\[3\].B.Q_WIRE\[3\]
+ sky130_fd_sc_hd__dlxtp_1
XSLICE_16\[0\].RAM16.Do0_REG.OUTREG_BYTE\[0\].Do_FF\[3\] SLICE_16\[0\].RAM16.Do0_REG.CLKBUF\[0\]
+ SLICE_16\[0\].RAM16.BYTE\[0\].FLOATBUF0\[3\].Z VGND VGND VPWR VPWR Do0MUX.A0\[3\]
+ sky130_fd_sc_hd__dfxtp_1
Xfill_5_3 VGND VPWR sky130_fd_sc_hd__tapvpwrvgnd_1
XSLICE_16\[1\].RAM16.SLICE\[1\].RAM8.WORD\[4\].W.BYTE\[0\].B.BIT\[1\].genblk1.STORAGE
+ DIBUF\[1\].X SLICE_16\[1\].RAM16.SLICE\[1\].RAM8.WORD\[4\].W.BYTE\[0\].B.GCLK VGND
+ VGND VPWR VPWR SLICE_16\[1\].RAM16.SLICE\[1\].RAM8.WORD\[4\].W.BYTE\[0\].B.Q_WIRE\[1\]
+ sky130_fd_sc_hd__dlxtp_1
XSLICE_16\[1\].RAM16.SLICE\[0\].RAM8.WORD\[4\].W.BYTE\[3\].B.genblk1.CG SLICE_16\[1\].RAM16.SLICE\[0\].RAM8.WORD\[4\].W.BYTE\[3\].B.CLK_B
+ SLICE_16\[1\].RAM16.SLICE\[0\].RAM8.WORD\[4\].W.BYTE\[3\].B.WE0_WIRE VGND VGND VPWR
+ VPWR SLICE_16\[1\].RAM16.SLICE\[0\].RAM8.WORD\[4\].W.BYTE\[3\].B.GCLK sky130_fd_sc_hd__dlclkp_1
Xtap_15_6 VGND VPWR sky130_fd_sc_hd__tapvpwrvgnd_1
Xtap_14_31 VGND VPWR sky130_fd_sc_hd__tapvpwrvgnd_1
Xtap_14_20 VGND VPWR sky130_fd_sc_hd__tapvpwrvgnd_1
XSLICE_16\[0\].RAM16.SLICE\[0\].RAM8.WORD\[2\].W.BYTE\[2\].B.CGAND SLICE_16\[0\].RAM16.SLICE\[0\].RAM8.WORD\[2\].W.BYTE\[0\].B.SEL0
+ SLICE_16\[0\].RAM16.SLICE\[0\].RAM8.WE0_buf\[2\] VGND VGND VPWR VPWR SLICE_16\[0\].RAM16.SLICE\[0\].RAM8.WORD\[2\].W.BYTE\[2\].B.WE0_WIRE
+ sky130_fd_sc_hd__and2_1
Xtap_8_5 VGND VPWR sky130_fd_sc_hd__tapvpwrvgnd_1
Xtap_30_30 VGND VPWR sky130_fd_sc_hd__tapvpwrvgnd_1
XSLICE_16\[1\].RAM16.SLICE\[1\].RAM8.WORD\[1\].W.BYTE\[1\].B.BIT\[4\].OBUF0 SLICE_16\[1\].RAM16.SLICE\[1\].RAM8.WORD\[1\].W.BYTE\[1\].B.Q_WIRE\[4\]
+ SLICE_16\[1\].RAM16.SLICE\[1\].RAM8.WORD\[1\].W.BYTE\[1\].B.SEL0_B VGND VGND VPWR
+ VPWR SLICE_16\[1\].RAM16.BYTE\[1\].FLOATBUF0\[12\].Z sky130_fd_sc_hd__ebufn_2
XSLICE_16\[1\].RAM16.SLICE\[0\].RAM8.WORD\[1\].W.BYTE\[0\].B.BIT\[7\].genblk1.STORAGE
+ DIBUF\[7\].X SLICE_16\[1\].RAM16.SLICE\[0\].RAM8.WORD\[1\].W.BYTE\[0\].B.GCLK VGND
+ VGND VPWR VPWR SLICE_16\[1\].RAM16.SLICE\[0\].RAM8.WORD\[1\].W.BYTE\[0\].B.Q_WIRE\[7\]
+ sky130_fd_sc_hd__dlxtp_1
XSLICE_16\[0\].RAM16.SLICE\[1\].RAM8.WORD\[6\].W.BYTE\[3\].B.BIT\[0\].OBUF0 SLICE_16\[0\].RAM16.SLICE\[1\].RAM8.WORD\[6\].W.BYTE\[3\].B.Q_WIRE\[0\]
+ SLICE_16\[0\].RAM16.SLICE\[1\].RAM8.WORD\[6\].W.BYTE\[3\].B.SEL0_B VGND VGND VPWR
+ VPWR SLICE_16\[0\].RAM16.BYTE\[3\].FLOATBUF0\[24\].Z sky130_fd_sc_hd__ebufn_2
Xfill_46_139 VGND VGND VPWR VPWR sky130_fd_sc_hd__decap_12
Xfill_46_128 VGND VGND VPWR VPWR sky130_fd_sc_hd__decap_12
Xfill_46_117 VGND VPWR sky130_fd_sc_hd__tapvpwrvgnd_1
Xfill_46_106 VGND VGND VPWR VPWR sky130_fd_sc_hd__decap_12
XSLICE_16\[0\].RAM16.SLICE\[0\].RAM8.WORD\[2\].W.BYTE\[0\].B.BIT\[3\].genblk1.STORAGE
+ DIBUF\[3\].X SLICE_16\[0\].RAM16.SLICE\[0\].RAM8.WORD\[2\].W.BYTE\[0\].B.GCLK VGND
+ VGND VPWR VPWR SLICE_16\[0\].RAM16.SLICE\[0\].RAM8.WORD\[2\].W.BYTE\[0\].B.Q_WIRE\[3\]
+ sky130_fd_sc_hd__dlxtp_1
XSLICE_16\[0\].RAM16.SLICE\[0\].RAM8.WORD\[4\].W.BYTE\[2\].B.BIT\[4\].genblk1.STORAGE
+ DIBUF\[20\].X SLICE_16\[0\].RAM16.SLICE\[0\].RAM8.WORD\[4\].W.BYTE\[2\].B.GCLK VGND
+ VGND VPWR VPWR SLICE_16\[0\].RAM16.SLICE\[0\].RAM8.WORD\[4\].W.BYTE\[2\].B.Q_WIRE\[4\]
+ sky130_fd_sc_hd__dlxtp_1
Xfill_43_92 VGND VGND VPWR VPWR sky130_fd_sc_hd__decap_12
Xfill_43_81 VGND VPWR sky130_fd_sc_hd__tapvpwrvgnd_1
Xfill_43_70 VGND VGND VPWR VPWR sky130_fd_sc_hd__decap_12
XSLICE_16\[0\].RAM16.SLICE\[1\].RAM8.WORD\[3\].W.BYTE\[0\].B.BIT\[5\].OBUF0 SLICE_16\[0\].RAM16.SLICE\[1\].RAM8.WORD\[3\].W.BYTE\[0\].B.Q_WIRE\[5\]
+ SLICE_16\[0\].RAM16.SLICE\[1\].RAM8.WORD\[3\].W.BYTE\[0\].B.SEL0_B VGND VGND VPWR
+ VPWR SLICE_16\[0\].RAM16.BYTE\[0\].FLOATBUF0\[5\].Z sky130_fd_sc_hd__ebufn_2
XSLICE_16\[1\].RAM16.SLICE\[0\].RAM8.WORD\[0\].W.BYTE\[3\].B.BIT\[6\].OBUF0 SLICE_16\[1\].RAM16.SLICE\[0\].RAM8.WORD\[0\].W.BYTE\[3\].B.Q_WIRE\[6\]
+ SLICE_16\[1\].RAM16.SLICE\[0\].RAM8.WORD\[0\].W.BYTE\[3\].B.SEL0_B VGND VGND VPWR
+ VPWR SLICE_16\[1\].RAM16.BYTE\[3\].FLOATBUF0\[30\].Z sky130_fd_sc_hd__ebufn_2
Xtap_35_19 VGND VPWR sky130_fd_sc_hd__tapvpwrvgnd_1
Xfill_3_0 VGND VPWR sky130_fd_sc_hd__tapvpwrvgnd_1
XSLICE_16\[0\].RAM16.SLICE\[0\].RAM8.WORD\[2\].W.BYTE\[2\].B.BIT\[7\].OBUF0 SLICE_16\[0\].RAM16.SLICE\[0\].RAM8.WORD\[2\].W.BYTE\[2\].B.Q_WIRE\[7\]
+ SLICE_16\[0\].RAM16.SLICE\[0\].RAM8.WORD\[2\].W.BYTE\[2\].B.SEL0_B VGND VGND VPWR
+ VPWR SLICE_16\[0\].RAM16.BYTE\[2\].FLOATBUF0\[23\].Z sky130_fd_sc_hd__ebufn_2
Xtap_6_12 VGND VPWR sky130_fd_sc_hd__tapvpwrvgnd_1
Xtap_6_23 VGND VPWR sky130_fd_sc_hd__tapvpwrvgnd_1
Xtap_6_34 VGND VPWR sky130_fd_sc_hd__tapvpwrvgnd_1
XSLICE_16\[1\].RAM16.SLICE\[1\].RAM8.WORD\[4\].W.BYTE\[2\].B.BIT\[4\].OBUF0 SLICE_16\[1\].RAM16.SLICE\[1\].RAM8.WORD\[4\].W.BYTE\[2\].B.Q_WIRE\[4\]
+ SLICE_16\[1\].RAM16.SLICE\[1\].RAM8.WORD\[4\].W.BYTE\[2\].B.SEL0_B VGND VGND VPWR
+ VPWR SLICE_16\[1\].RAM16.BYTE\[2\].FLOATBUF0\[20\].Z sky130_fd_sc_hd__ebufn_2
XSLICE_16\[0\].RAM16.SLICE\[1\].RAM8.WORD\[7\].W.BYTE\[0\].B.genblk1.CG SLICE_16\[0\].RAM16.SLICE\[1\].RAM8.WORD\[7\].W.BYTE\[0\].B.CLK_B
+ SLICE_16\[0\].RAM16.SLICE\[1\].RAM8.WORD\[7\].W.BYTE\[0\].B.WE0_WIRE VGND VGND VPWR
+ VPWR SLICE_16\[0\].RAM16.SLICE\[1\].RAM8.WORD\[7\].W.BYTE\[0\].B.GCLK sky130_fd_sc_hd__dlclkp_1
Xtap_25_30 VGND VPWR sky130_fd_sc_hd__tapvpwrvgnd_1
XSLICE_16\[0\].RAM16.DIODE_CLK.__cell__ CLK VGND VGND VPWR VPWR sky130_fd_sc_hd__diode_2
Xtap_13_3 VGND VPWR sky130_fd_sc_hd__tapvpwrvgnd_1
Xtap_6_2 VGND VPWR sky130_fd_sc_hd__tapvpwrvgnd_1
XSLICE_16\[1\].RAM16.SLICE\[1\].RAM8.WORD\[7\].W.BYTE\[1\].B.BIT\[1\].genblk1.STORAGE
+ DIBUF\[9\].X SLICE_16\[1\].RAM16.SLICE\[1\].RAM8.WORD\[7\].W.BYTE\[1\].B.GCLK VGND
+ VGND VPWR VPWR SLICE_16\[1\].RAM16.SLICE\[1\].RAM8.WORD\[7\].W.BYTE\[1\].B.Q_WIRE\[1\]
+ sky130_fd_sc_hd__dlxtp_1
XSLICE_16\[1\].RAM16.SLICE\[1\].RAM8.WORD\[1\].W.BYTE\[2\].B.BIT\[2\].genblk1.STORAGE
+ DIBUF\[18\].X SLICE_16\[1\].RAM16.SLICE\[1\].RAM8.WORD\[1\].W.BYTE\[2\].B.GCLK VGND
+ VGND VPWR VPWR SLICE_16\[1\].RAM16.SLICE\[1\].RAM8.WORD\[1\].W.BYTE\[2\].B.Q_WIRE\[2\]
+ sky130_fd_sc_hd__dlxtp_1
XSLICE_16\[0\].RAM16.SLICE\[1\].RAM8.WORD\[6\].W.BYTE\[1\].B.BIT\[5\].OBUF0 SLICE_16\[0\].RAM16.SLICE\[1\].RAM8.WORD\[6\].W.BYTE\[1\].B.Q_WIRE\[5\]
+ SLICE_16\[0\].RAM16.SLICE\[1\].RAM8.WORD\[6\].W.BYTE\[1\].B.SEL0_B VGND VGND VPWR
+ VPWR SLICE_16\[0\].RAM16.BYTE\[1\].FLOATBUF0\[13\].Z sky130_fd_sc_hd__ebufn_2
XSLICE_16\[0\].RAM16.SLICE\[1\].RAM8.WORD\[3\].W.BYTE\[1\].B.CGAND SLICE_16\[0\].RAM16.SLICE\[1\].RAM8.WORD\[3\].W.BYTE\[0\].B.SEL0
+ SLICE_16\[0\].RAM16.SLICE\[1\].RAM8.WE0_buf\[1\] VGND VGND VPWR VPWR SLICE_16\[0\].RAM16.SLICE\[1\].RAM8.WORD\[3\].W.BYTE\[1\].B.WE0_WIRE
+ sky130_fd_sc_hd__and2_1
Xfill_41_7 VGND VGND VPWR VPWR sky130_fd_sc_hd__decap_12
Xfill_34_6 VGND VGND VPWR VPWR sky130_fd_sc_hd__decap_6
Xfill_27_5 VGND VPWR sky130_fd_sc_hd__tapvpwrvgnd_1
XSLICE_16\[0\].RAM16.SLICE\[0\].RAM8.WORD\[1\].W.BYTE\[0\].B.BIT\[4\].OBUF0 SLICE_16\[0\].RAM16.SLICE\[0\].RAM8.WORD\[1\].W.BYTE\[0\].B.Q_WIRE\[4\]
+ SLICE_16\[0\].RAM16.SLICE\[0\].RAM8.WORD\[1\].W.BYTE\[0\].B.SEL0_B VGND VGND VPWR
+ VPWR SLICE_16\[0\].RAM16.BYTE\[0\].FLOATBUF0\[4\].Z sky130_fd_sc_hd__ebufn_2
XSLICE_16\[1\].RAM16.SLICE\[1\].RAM8.WORD\[3\].W.BYTE\[0\].B.BIT\[1\].OBUF0 SLICE_16\[1\].RAM16.SLICE\[1\].RAM8.WORD\[3\].W.BYTE\[0\].B.Q_WIRE\[1\]
+ SLICE_16\[1\].RAM16.SLICE\[1\].RAM8.WORD\[3\].W.BYTE\[0\].B.SEL0_B VGND VGND VPWR
+ VPWR SLICE_16\[1\].RAM16.BYTE\[0\].FLOATBUF0\[1\].Z sky130_fd_sc_hd__ebufn_2
XSLICE_16\[1\].RAM16.SLICE\[0\].RAM8.WORD\[4\].W.BYTE\[1\].B.BIT\[7\].genblk1.STORAGE
+ DIBUF\[15\].X SLICE_16\[1\].RAM16.SLICE\[0\].RAM8.WORD\[4\].W.BYTE\[1\].B.GCLK VGND
+ VGND VPWR VPWR SLICE_16\[1\].RAM16.SLICE\[0\].RAM8.WORD\[4\].W.BYTE\[1\].B.Q_WIRE\[7\]
+ sky130_fd_sc_hd__dlxtp_1
XSLICE_16\[0\].RAM16.SLICE\[0\].RAM8.WORD\[5\].W.BYTE\[3\].B.BIT\[7\].OBUF0 SLICE_16\[0\].RAM16.SLICE\[0\].RAM8.WORD\[5\].W.BYTE\[3\].B.Q_WIRE\[7\]
+ SLICE_16\[0\].RAM16.SLICE\[0\].RAM8.WORD\[5\].W.BYTE\[3\].B.SEL0_B VGND VGND VPWR
+ VPWR SLICE_16\[0\].RAM16.BYTE\[3\].FLOATBUF0\[31\].Z sky130_fd_sc_hd__ebufn_2
XSLICE_16\[1\].RAM16.WEBUF\[2\].__cell__ SLICE_16\[0\].RAM16.WE0\[2\] VGND VGND VPWR
+ VPWR SLICE_16\[1\].RAM16.SLICE\[0\].RAM8.WE0\[2\] sky130_fd_sc_hd__clkbuf_2
XSLICE_16\[1\].RAM16.SLICE\[1\].RAM8.WORD\[7\].W.BYTE\[3\].B.BIT\[4\].OBUF0 SLICE_16\[1\].RAM16.SLICE\[1\].RAM8.WORD\[7\].W.BYTE\[3\].B.Q_WIRE\[4\]
+ SLICE_16\[1\].RAM16.SLICE\[1\].RAM8.WORD\[7\].W.BYTE\[3\].B.SEL0_B VGND VGND VPWR
+ VPWR SLICE_16\[1\].RAM16.BYTE\[3\].FLOATBUF0\[28\].Z sky130_fd_sc_hd__ebufn_2
XSLICE_16\[0\].RAM16.SLICE\[0\].RAM8.WORD\[7\].W.BYTE\[3\].B.BIT\[4\].genblk1.STORAGE
+ DIBUF\[28\].X SLICE_16\[0\].RAM16.SLICE\[0\].RAM8.WORD\[7\].W.BYTE\[3\].B.GCLK VGND
+ VGND VPWR VPWR SLICE_16\[0\].RAM16.SLICE\[0\].RAM8.WORD\[7\].W.BYTE\[3\].B.Q_WIRE\[4\]
+ sky130_fd_sc_hd__dlxtp_1
Xfill_18_29 VGND VGND VPWR VPWR sky130_fd_sc_hd__decap_6
Xfill_18_18 VGND VPWR sky130_fd_sc_hd__tapvpwrvgnd_1
XSLICE_16\[0\].RAM16.SLICE\[0\].RAM8.WORD\[5\].W.BYTE\[1\].B.BIT\[3\].genblk1.STORAGE
+ DIBUF\[11\].X SLICE_16\[0\].RAM16.SLICE\[0\].RAM8.WORD\[5\].W.BYTE\[1\].B.GCLK VGND
+ VGND VPWR VPWR SLICE_16\[0\].RAM16.SLICE\[0\].RAM8.WORD\[5\].W.BYTE\[1\].B.Q_WIRE\[3\]
+ sky130_fd_sc_hd__dlxtp_1
XSLICE_16\[1\].RAM16.SLICE\[1\].RAM8.WORD\[1\].W.CLKBUF SLICE_16\[1\].RAM16.SLICE\[1\].RAM8.CLKBUF.X
+ VGND VGND VPWR VPWR SLICE_16\[1\].RAM16.SLICE\[1\].RAM8.WORD\[1\].W.BYTE\[0\].B.CLK
+ sky130_fd_sc_hd__clkbuf_4
XSLICE_16\[1\].RAM16.SLICE\[0\].RAM8.WORD\[2\].W.BYTE\[2\].B.BIT\[3\].OBUF0 SLICE_16\[1\].RAM16.SLICE\[0\].RAM8.WORD\[2\].W.BYTE\[2\].B.Q_WIRE\[3\]
+ SLICE_16\[1\].RAM16.SLICE\[0\].RAM8.WORD\[2\].W.BYTE\[2\].B.SEL0_B VGND VGND VPWR
+ VPWR SLICE_16\[1\].RAM16.BYTE\[2\].FLOATBUF0\[19\].Z sky130_fd_sc_hd__ebufn_2
XA0BUF\[4\].__cell__ A0[4] VGND VGND VPWR VPWR A0BUF\[4\].X sky130_fd_sc_hd__clkbuf_2
Xtap_11_10 VGND VPWR sky130_fd_sc_hd__tapvpwrvgnd_1
Xtap_11_21 VGND VPWR sky130_fd_sc_hd__tapvpwrvgnd_1
Xtap_11_32 VGND VPWR sky130_fd_sc_hd__tapvpwrvgnd_1
XSLICE_16\[0\].RAM16.SLICE\[0\].RAM8.WORD\[4\].W.BYTE\[1\].B.BIT\[4\].OBUF0 SLICE_16\[0\].RAM16.SLICE\[0\].RAM8.WORD\[4\].W.BYTE\[1\].B.Q_WIRE\[4\]
+ SLICE_16\[0\].RAM16.SLICE\[0\].RAM8.WORD\[4\].W.BYTE\[1\].B.SEL0_B VGND VGND VPWR
+ VPWR SLICE_16\[0\].RAM16.BYTE\[1\].FLOATBUF0\[12\].Z sky130_fd_sc_hd__ebufn_2
Xtap_11_0 VGND VPWR sky130_fd_sc_hd__tapvpwrvgnd_1
XSLICE_16\[1\].RAM16.SLICE\[1\].RAM8.WORD\[6\].W.BYTE\[1\].B.BIT\[1\].OBUF0 SLICE_16\[1\].RAM16.SLICE\[1\].RAM8.WORD\[6\].W.BYTE\[1\].B.Q_WIRE\[1\]
+ SLICE_16\[1\].RAM16.SLICE\[1\].RAM8.WORD\[6\].W.BYTE\[1\].B.SEL0_B VGND VGND VPWR
+ VPWR SLICE_16\[1\].RAM16.BYTE\[1\].FLOATBUF0\[9\].Z sky130_fd_sc_hd__ebufn_2
XSLICE_16\[1\].RAM16.SLICE\[0\].RAM8.WORD\[2\].W.SEL0BUF SLICE_16\[1\].RAM16.SLICE\[0\].RAM8.DEC0.SEL\[2\]
+ VGND VGND VPWR VPWR SLICE_16\[1\].RAM16.SLICE\[0\].RAM8.WORD\[2\].W.BYTE\[0\].B.SEL0
+ sky130_fd_sc_hd__clkbuf_2
XSLICE_16\[0\].RAM16.Do0_REG.Do_CLKBUF\[3\] SLICE_16\[0\].RAM16.Do0_REG.CLK_buf VGND
+ VGND VPWR VPWR SLICE_16\[0\].RAM16.Do0_REG.CLKBUF\[3\] sky130_fd_sc_hd__clkbuf_4
XSLICE_16\[1\].RAM16.SLICE\[1\].RAM8.WORD\[4\].W.BYTE\[3\].B.BIT\[2\].genblk1.STORAGE
+ DIBUF\[26\].X SLICE_16\[1\].RAM16.SLICE\[1\].RAM8.WORD\[4\].W.BYTE\[3\].B.GCLK VGND
+ VGND VPWR VPWR SLICE_16\[1\].RAM16.SLICE\[1\].RAM8.WORD\[4\].W.BYTE\[3\].B.Q_WIRE\[2\]
+ sky130_fd_sc_hd__dlxtp_1
XSLICE_16\[1\].RAM16.SLICE\[1\].RAM8.WORD\[2\].W.BYTE\[1\].B.BIT\[1\].genblk1.STORAGE
+ DIBUF\[9\].X SLICE_16\[1\].RAM16.SLICE\[1\].RAM8.WORD\[2\].W.BYTE\[1\].B.GCLK VGND
+ VGND VPWR VPWR SLICE_16\[1\].RAM16.SLICE\[1\].RAM8.WORD\[2\].W.BYTE\[1\].B.Q_WIRE\[1\]
+ sky130_fd_sc_hd__dlxtp_1
XSLICE_16\[1\].RAM16.SLICE\[0\].RAM8.WORD\[1\].W.BYTE\[0\].B.BIT\[0\].OBUF0 SLICE_16\[1\].RAM16.SLICE\[0\].RAM8.WORD\[1\].W.BYTE\[0\].B.Q_WIRE\[0\]
+ SLICE_16\[1\].RAM16.SLICE\[0\].RAM8.WORD\[1\].W.BYTE\[0\].B.SEL0_B VGND VGND VPWR
+ VPWR SLICE_16\[1\].RAM16.BYTE\[0\].FLOATBUF0\[0\].Z sky130_fd_sc_hd__ebufn_2
Xfill_32_3 VGND VPWR sky130_fd_sc_hd__tapvpwrvgnd_1
XSLICE_16\[1\].RAM16.SLICE\[0\].RAM8.WORD\[6\].W.BYTE\[0\].B.genblk1.CLKINV SLICE_16\[1\].RAM16.SLICE\[0\].RAM8.WORD\[6\].W.BYTE\[0\].B.CLK
+ VGND VGND VPWR VPWR SLICE_16\[1\].RAM16.SLICE\[0\].RAM8.WORD\[6\].W.BYTE\[0\].B.CLK_B
+ sky130_fd_sc_hd__inv_1
XSLICE_16\[1\].RAM16.SLICE\[0\].RAM8.WORD\[5\].W.BYTE\[3\].B.BIT\[3\].OBUF0 SLICE_16\[1\].RAM16.SLICE\[0\].RAM8.WORD\[5\].W.BYTE\[3\].B.Q_WIRE\[3\]
+ SLICE_16\[1\].RAM16.SLICE\[0\].RAM8.WORD\[5\].W.BYTE\[3\].B.SEL0_B VGND VGND VPWR
+ VPWR SLICE_16\[1\].RAM16.BYTE\[3\].FLOATBUF0\[27\].Z sky130_fd_sc_hd__ebufn_2
Xfill_25_2 VGND VPWR sky130_fd_sc_hd__tapvpwrvgnd_1
Xfill_18_1 VGND VGND VPWR VPWR sky130_fd_sc_hd__decap_12
Xtap_47_9 VGND VPWR sky130_fd_sc_hd__tapvpwrvgnd_1
Xfill_20_19 VGND VGND VPWR VPWR sky130_fd_sc_hd__decap_12
Xtap_3_13 VGND VPWR sky130_fd_sc_hd__tapvpwrvgnd_1
Xtap_3_24 VGND VPWR sky130_fd_sc_hd__tapvpwrvgnd_1
Xtap_3_35 VGND VPWR sky130_fd_sc_hd__tapvpwrvgnd_1
XSLICE_16\[0\].RAM16.SLICE\[0\].RAM8.WORD\[7\].W.BYTE\[2\].B.BIT\[4\].OBUF0 SLICE_16\[0\].RAM16.SLICE\[0\].RAM8.WORD\[7\].W.BYTE\[2\].B.Q_WIRE\[4\]
+ SLICE_16\[0\].RAM16.SLICE\[0\].RAM8.WORD\[7\].W.BYTE\[2\].B.SEL0_B VGND VGND VPWR
+ VPWR SLICE_16\[0\].RAM16.BYTE\[2\].FLOATBUF0\[20\].Z sky130_fd_sc_hd__ebufn_2
Xfill_45_38 VGND VGND VPWR VPWR sky130_fd_sc_hd__decap_12
Xfill_45_27 VGND VPWR sky130_fd_sc_hd__tapvpwrvgnd_1
Xfill_45_16 VGND VGND VPWR VPWR sky130_fd_sc_hd__decap_12
XSLICE_16\[1\].RAM16.BYTE\[0\].FLOATBUF0\[3\].__cell__ SLICE_16\[1\].RAM16.BYTE\[0\].FLOATBUF0\[0\].A
+ SLICE_16\[1\].RAM16.BYTE\[0\].FLOATBUF0\[0\].TE_B VGND VGND VPWR VPWR SLICE_16\[1\].RAM16.BYTE\[0\].FLOATBUF0\[3\].Z
+ sky130_fd_sc_hd__ebufn_2
XSLICE_16\[1\].RAM16.SLICE\[0\].RAM8.WORD\[7\].W.BYTE\[2\].B.BIT\[7\].genblk1.STORAGE
+ DIBUF\[23\].X SLICE_16\[1\].RAM16.SLICE\[0\].RAM8.WORD\[7\].W.BYTE\[2\].B.GCLK VGND
+ VGND VPWR VPWR SLICE_16\[1\].RAM16.SLICE\[0\].RAM8.WORD\[7\].W.BYTE\[2\].B.Q_WIRE\[7\]
+ sky130_fd_sc_hd__dlxtp_1
XSLICE_16\[0\].RAM16.SLICE\[0\].RAM8.WORD\[3\].W.BYTE\[3\].B.genblk1.CG SLICE_16\[0\].RAM16.SLICE\[0\].RAM8.WORD\[3\].W.BYTE\[3\].B.CLK_B
+ SLICE_16\[0\].RAM16.SLICE\[0\].RAM8.WORD\[3\].W.BYTE\[3\].B.WE0_WIRE VGND VGND VPWR
+ VPWR SLICE_16\[0\].RAM16.SLICE\[0\].RAM8.WORD\[3\].W.BYTE\[3\].B.GCLK sky130_fd_sc_hd__dlclkp_1
Xfill_45_49 VGND VGND VPWR VPWR sky130_fd_sc_hd__decap_12
XSLICE_16\[1\].RAM16.Do0_REG.OUTREG_BYTE\[3\].Do_FF\[6\] SLICE_16\[1\].RAM16.Do0_REG.CLKBUF\[3\]
+ SLICE_16\[1\].RAM16.BYTE\[3\].FLOATBUF0\[30\].Z VGND VGND VPWR VPWR Do0MUX.A1\[30\]
+ sky130_fd_sc_hd__dfxtp_1
XSLICE_16\[1\].RAM16.SLICE\[0\].RAM8.WORD\[5\].W.BYTE\[0\].B.BIT\[6\].genblk1.STORAGE
+ DIBUF\[6\].X SLICE_16\[1\].RAM16.SLICE\[0\].RAM8.WORD\[5\].W.BYTE\[0\].B.GCLK VGND
+ VGND VPWR VPWR SLICE_16\[1\].RAM16.SLICE\[0\].RAM8.WORD\[5\].W.BYTE\[0\].B.Q_WIRE\[6\]
+ sky130_fd_sc_hd__dlxtp_1
XSLICE_16\[0\].RAM16.SLICE\[1\].RAM8.WORD\[7\].W.BYTE\[0\].B.BIT\[7\].genblk1.STORAGE
+ DIBUF\[7\].X SLICE_16\[0\].RAM16.SLICE\[1\].RAM8.WORD\[7\].W.BYTE\[0\].B.GCLK VGND
+ VGND VPWR VPWR SLICE_16\[0\].RAM16.SLICE\[1\].RAM8.WORD\[7\].W.BYTE\[0\].B.Q_WIRE\[7\]
+ sky130_fd_sc_hd__dlxtp_1
Xfill_21_101 VGND VGND VPWR VPWR sky130_fd_sc_hd__decap_8
XSLICE_16\[0\].RAM16.SLICE\[0\].RAM8.WORD\[2\].W.BYTE\[3\].B.BIT\[4\].genblk1.STORAGE
+ DIBUF\[28\].X SLICE_16\[0\].RAM16.SLICE\[0\].RAM8.WORD\[2\].W.BYTE\[3\].B.GCLK VGND
+ VGND VPWR VPWR SLICE_16\[0\].RAM16.SLICE\[0\].RAM8.WORD\[2\].W.BYTE\[3\].B.Q_WIRE\[4\]
+ sky130_fd_sc_hd__dlxtp_1
XDo0MUX.M\[2\].MUX\[0\] Do0MUX.A0\[16\] Do0MUX.A1\[16\] Do0MUX.SEL\[2\] VGND VGND
+ VPWR VPWR Do0[16] sky130_fd_sc_hd__mux2_1
XDo0MUX.SEL0BUF\[0\] A0BUF\[4\].X VGND VGND VPWR VPWR Do0MUX.SEL\[0\] sky130_fd_sc_hd__clkbuf_2
XSLICE_16\[1\].RAM16.SLICE\[0\].RAM8.WORD\[4\].W.BYTE\[1\].B.BIT\[0\].OBUF0 SLICE_16\[1\].RAM16.SLICE\[0\].RAM8.WORD\[4\].W.BYTE\[1\].B.Q_WIRE\[0\]
+ SLICE_16\[1\].RAM16.SLICE\[0\].RAM8.WORD\[4\].W.BYTE\[1\].B.SEL0_B VGND VGND VPWR
+ VPWR SLICE_16\[1\].RAM16.BYTE\[1\].FLOATBUF0\[8\].Z sky130_fd_sc_hd__ebufn_2
Xfill_19_50 VGND VGND VPWR VPWR sky130_fd_sc_hd__decap_12
XSLICE_16\[0\].RAM16.SLICE\[0\].RAM8.WORD\[0\].W.BYTE\[1\].B.BIT\[3\].genblk1.STORAGE
+ DIBUF\[11\].X SLICE_16\[0\].RAM16.SLICE\[0\].RAM8.WORD\[0\].W.BYTE\[1\].B.GCLK VGND
+ VGND VPWR VPWR SLICE_16\[0\].RAM16.SLICE\[0\].RAM8.WORD\[0\].W.BYTE\[1\].B.Q_WIRE\[3\]
+ sky130_fd_sc_hd__dlxtp_1
XSLICE_16\[0\].RAM16.SLICE\[0\].RAM8.WORD\[6\].W.BYTE\[0\].B.BIT\[2\].genblk1.STORAGE
+ DIBUF\[2\].X SLICE_16\[0\].RAM16.SLICE\[0\].RAM8.WORD\[6\].W.BYTE\[0\].B.GCLK VGND
+ VGND VPWR VPWR SLICE_16\[0\].RAM16.SLICE\[0\].RAM8.WORD\[6\].W.BYTE\[0\].B.Q_WIRE\[2\]
+ sky130_fd_sc_hd__dlxtp_1
Xfill_19_94 VGND VGND VPWR VPWR sky130_fd_sc_hd__decap_12
Xfill_19_83 VGND VGND VPWR VPWR sky130_fd_sc_hd__decap_12
Xfill_19_72 VGND VPWR sky130_fd_sc_hd__tapvpwrvgnd_1
Xfill_19_61 VGND VGND VPWR VPWR sky130_fd_sc_hd__decap_12
XSLICE_16\[0\].RAM16.SLICE\[0\].RAM8.WORD\[6\].W.BYTE\[0\].B.BIT\[1\].OBUF0 SLICE_16\[0\].RAM16.SLICE\[0\].RAM8.WORD\[6\].W.BYTE\[0\].B.Q_WIRE\[1\]
+ SLICE_16\[0\].RAM16.SLICE\[0\].RAM8.WORD\[6\].W.BYTE\[0\].B.SEL0_B VGND VGND VPWR
+ VPWR SLICE_16\[0\].RAM16.BYTE\[0\].FLOATBUF0\[1\].Z sky130_fd_sc_hd__ebufn_2
XSLICE_16\[1\].RAM16.SLICE\[0\].RAM8.WORD\[0\].W.BYTE\[2\].B.genblk1.CG SLICE_16\[1\].RAM16.SLICE\[0\].RAM8.WORD\[0\].W.BYTE\[2\].B.CLK_B
+ SLICE_16\[1\].RAM16.SLICE\[0\].RAM8.WORD\[0\].W.BYTE\[2\].B.WE0_WIRE VGND VGND VPWR
+ VPWR SLICE_16\[1\].RAM16.SLICE\[0\].RAM8.WORD\[0\].W.BYTE\[2\].B.GCLK sky130_fd_sc_hd__dlclkp_1
XSLICE_16\[0\].RAM16.SLICE\[1\].RAM8.WORD\[2\].W.BYTE\[3\].B.BIT\[7\].OBUF0 SLICE_16\[0\].RAM16.SLICE\[1\].RAM8.WORD\[2\].W.BYTE\[3\].B.Q_WIRE\[7\]
+ SLICE_16\[0\].RAM16.SLICE\[1\].RAM8.WORD\[2\].W.BYTE\[3\].B.SEL0_B VGND VGND VPWR
+ VPWR SLICE_16\[0\].RAM16.BYTE\[3\].FLOATBUF0\[31\].Z sky130_fd_sc_hd__ebufn_2
Xfill_30_0 VGND VPWR sky130_fd_sc_hd__tapvpwrvgnd_1
XDo0MUX.M\[1\].MUX\[2\] Do0MUX.A0\[10\] Do0MUX.A1\[10\] Do0MUX.SEL\[1\] VGND VGND
+ VPWR VPWR Do0[10] sky130_fd_sc_hd__mux2_1
XSLICE_16\[1\].RAM16.SLICE\[1\].RAM8.WORD\[5\].W.BYTE\[2\].B.BIT\[1\].genblk1.STORAGE
+ DIBUF\[17\].X SLICE_16\[1\].RAM16.SLICE\[1\].RAM8.WORD\[5\].W.BYTE\[2\].B.GCLK VGND
+ VGND VPWR VPWR SLICE_16\[1\].RAM16.SLICE\[1\].RAM8.WORD\[5\].W.BYTE\[2\].B.Q_WIRE\[1\]
+ sky130_fd_sc_hd__dlxtp_1
XSLICE_16\[0\].RAM16.SLICE\[0\].RAM8.WORD\[0\].W.SEL0BUF SLICE_16\[0\].RAM16.SLICE\[0\].RAM8.DEC0.SEL\[0\]
+ VGND VGND VPWR VPWR SLICE_16\[0\].RAM16.SLICE\[0\].RAM8.WORD\[0\].W.BYTE\[0\].B.SEL0
+ sky130_fd_sc_hd__clkbuf_2
Xtap_38_5 VGND VPWR sky130_fd_sc_hd__tapvpwrvgnd_1
XSLICE_16\[1\].RAM16.SLICE\[1\].RAM8.WORD\[3\].W.BYTE\[0\].B.BIT\[0\].genblk1.STORAGE
+ DIBUF\[0\].X SLICE_16\[1\].RAM16.SLICE\[1\].RAM8.WORD\[3\].W.BYTE\[0\].B.GCLK VGND
+ VGND VPWR VPWR SLICE_16\[1\].RAM16.SLICE\[1\].RAM8.WORD\[3\].W.BYTE\[0\].B.Q_WIRE\[0\]
+ sky130_fd_sc_hd__dlxtp_1
XSLICE_16\[1\].RAM16.SLICE\[0\].RAM8.WORD\[7\].W.BYTE\[2\].B.BIT\[0\].OBUF0 SLICE_16\[1\].RAM16.SLICE\[0\].RAM8.WORD\[7\].W.BYTE\[2\].B.Q_WIRE\[0\]
+ SLICE_16\[1\].RAM16.SLICE\[0\].RAM8.WORD\[7\].W.BYTE\[2\].B.SEL0_B VGND VGND VPWR
+ VPWR SLICE_16\[1\].RAM16.BYTE\[2\].FLOATBUF0\[16\].Z sky130_fd_sc_hd__ebufn_2
XSLICE_16\[0\].RAM16.FBUFENBUF0\[2\].__cell__ DEC0.SEL\[0\] VGND VGND VPWR VPWR SLICE_16\[0\].RAM16.BYTE\[2\].FLOATBUF0\[16\].TE_B
+ sky130_fd_sc_hd__clkbuf_2
Xtap_33_30 VGND VPWR sky130_fd_sc_hd__tapvpwrvgnd_1
XSLICE_16\[0\].RAM16.SLICE\[1\].RAM8.WORD\[1\].W.BYTE\[1\].B.BIT\[4\].OBUF0 SLICE_16\[0\].RAM16.SLICE\[1\].RAM8.WORD\[1\].W.BYTE\[1\].B.Q_WIRE\[4\]
+ SLICE_16\[0\].RAM16.SLICE\[1\].RAM8.WORD\[1\].W.BYTE\[1\].B.SEL0_B VGND VGND VPWR
+ VPWR SLICE_16\[0\].RAM16.BYTE\[1\].FLOATBUF0\[12\].Z sky130_fd_sc_hd__ebufn_2
XDo0MUX.M\[0\].MUX\[4\] Do0MUX.A0\[4\] Do0MUX.A1\[4\] Do0MUX.SEL\[0\] VGND VGND VPWR
+ VPWR Do0[4] sky130_fd_sc_hd__mux2_1
XSLICE_16\[1\].RAM16.SLICE\[0\].RAM8.WORD\[2\].W.BYTE\[2\].B.BIT\[7\].genblk1.STORAGE
+ DIBUF\[23\].X SLICE_16\[1\].RAM16.SLICE\[0\].RAM8.WORD\[2\].W.BYTE\[2\].B.GCLK VGND
+ VGND VPWR VPWR SLICE_16\[1\].RAM16.SLICE\[0\].RAM8.WORD\[2\].W.BYTE\[2\].B.Q_WIRE\[7\]
+ sky130_fd_sc_hd__dlxtp_1
Xfill_21_95 VGND VGND VPWR VPWR sky130_fd_sc_hd__decap_12
Xfill_21_84 VGND VPWR sky130_fd_sc_hd__tapvpwrvgnd_1
Xfill_21_73 VGND VGND VPWR VPWR sky130_fd_sc_hd__decap_12
Xfill_21_62 VGND VGND VPWR VPWR sky130_fd_sc_hd__decap_12
Xfill_21_51 VGND VPWR sky130_fd_sc_hd__tapvpwrvgnd_1
Xfill_21_40 VGND VGND VPWR VPWR sky130_fd_sc_hd__decap_12
XSLICE_16\[1\].RAM16.SLICE\[0\].RAM8.WORD\[0\].W.BYTE\[0\].B.BIT\[6\].genblk1.STORAGE
+ DIBUF\[6\].X SLICE_16\[1\].RAM16.SLICE\[0\].RAM8.WORD\[0\].W.BYTE\[0\].B.GCLK VGND
+ VGND VPWR VPWR SLICE_16\[1\].RAM16.SLICE\[0\].RAM8.WORD\[0\].W.BYTE\[0\].B.Q_WIRE\[6\]
+ sky130_fd_sc_hd__dlxtp_1
XSLICE_16\[0\].RAM16.Do0_REG.OUTREG_BYTE\[2\].DIODE\[6\] SLICE_16\[0\].RAM16.BYTE\[2\].FLOATBUF0\[22\].Z
+ VGND VGND VPWR VPWR sky130_fd_sc_hd__diode_2
Xfill_46_92 VGND VGND VPWR VPWR sky130_fd_sc_hd__decap_12
Xfill_46_81 VGND VPWR sky130_fd_sc_hd__tapvpwrvgnd_1
Xfill_46_70 VGND VPWR sky130_fd_sc_hd__tapvpwrvgnd_1
XSLICE_16\[0\].RAM16.SLICE\[0\].RAM8.WORD\[0\].W.BYTE\[3\].B.BIT\[6\].OBUF0 SLICE_16\[0\].RAM16.SLICE\[0\].RAM8.WORD\[0\].W.BYTE\[3\].B.Q_WIRE\[6\]
+ SLICE_16\[0\].RAM16.SLICE\[0\].RAM8.WORD\[0\].W.BYTE\[3\].B.SEL0_B VGND VGND VPWR
+ VPWR SLICE_16\[0\].RAM16.BYTE\[3\].FLOATBUF0\[30\].Z sky130_fd_sc_hd__ebufn_2
XSLICE_16\[0\].RAM16.SLICE\[1\].RAM8.WORD\[2\].W.BYTE\[0\].B.BIT\[7\].genblk1.STORAGE
+ DIBUF\[7\].X SLICE_16\[0\].RAM16.SLICE\[1\].RAM8.WORD\[2\].W.BYTE\[0\].B.GCLK VGND
+ VGND VPWR VPWR SLICE_16\[0\].RAM16.SLICE\[1\].RAM8.WORD\[2\].W.BYTE\[0\].B.Q_WIRE\[7\]
+ sky130_fd_sc_hd__dlxtp_1
XDo0MUX.M\[2\].DIODE_A1MUX\[21\] Do0MUX.A1\[21\] VGND VGND VPWR VPWR sky130_fd_sc_hd__diode_2
XSLICE_16\[1\].RAM16.SLICE\[1\].RAM8.WORD\[2\].W.BYTE\[3\].B.BIT\[3\].OBUF0 SLICE_16\[1\].RAM16.SLICE\[1\].RAM8.WORD\[2\].W.BYTE\[3\].B.Q_WIRE\[3\]
+ SLICE_16\[1\].RAM16.SLICE\[1\].RAM8.WORD\[2\].W.BYTE\[3\].B.SEL0_B VGND VGND VPWR
+ VPWR SLICE_16\[1\].RAM16.BYTE\[3\].FLOATBUF0\[27\].Z sky130_fd_sc_hd__ebufn_2
XSLICE_16\[1\].RAM16.SLICE\[1\].RAM8.WORD\[3\].W.BYTE\[0\].B.genblk1.CLKINV SLICE_16\[1\].RAM16.SLICE\[1\].RAM8.WORD\[3\].W.BYTE\[0\].B.CLK
+ VGND VGND VPWR VPWR SLICE_16\[1\].RAM16.SLICE\[1\].RAM8.WORD\[3\].W.BYTE\[0\].B.CLK_B
+ sky130_fd_sc_hd__inv_1
XSLICE_16\[1\].RAM16.SLICE\[0\].RAM8.WORD\[0\].W.BYTE\[0\].B.DIODE_CLK SLICE_16\[1\].RAM16.SLICE\[0\].RAM8.WORD\[0\].W.BYTE\[0\].B.CLK
+ VGND VGND VPWR VPWR sky130_fd_sc_hd__diode_2
XSLICE_16\[0\].RAM16.SLICE\[0\].RAM8.WORD\[3\].W.BYTE\[2\].B.BIT\[3\].genblk1.STORAGE
+ DIBUF\[19\].X SLICE_16\[0\].RAM16.SLICE\[0\].RAM8.WORD\[3\].W.BYTE\[2\].B.GCLK VGND
+ VGND VPWR VPWR SLICE_16\[0\].RAM16.SLICE\[0\].RAM8.WORD\[3\].W.BYTE\[2\].B.Q_WIRE\[3\]
+ sky130_fd_sc_hd__dlxtp_1
Xtap_38_19 VGND VPWR sky130_fd_sc_hd__tapvpwrvgnd_1
XSLICE_16\[0\].RAM16.SLICE\[0\].RAM8.WORD\[1\].W.BYTE\[0\].B.BIT\[2\].genblk1.STORAGE
+ DIBUF\[2\].X SLICE_16\[0\].RAM16.SLICE\[0\].RAM8.WORD\[1\].W.BYTE\[0\].B.GCLK VGND
+ VGND VPWR VPWR SLICE_16\[0\].RAM16.SLICE\[0\].RAM8.WORD\[1\].W.BYTE\[0\].B.Q_WIRE\[2\]
+ sky130_fd_sc_hd__dlxtp_1
Xtap_0_25 VGND VPWR sky130_fd_sc_hd__tapvpwrvgnd_1
Xtap_0_14 VGND VPWR sky130_fd_sc_hd__tapvpwrvgnd_1
XSLICE_16\[0\].RAM16.SLICE\[0\].RAM8.WORD\[6\].W.BYTE\[3\].B.SEL0INV SLICE_16\[0\].RAM16.SLICE\[0\].RAM8.WORD\[6\].W.BYTE\[0\].B.SEL0
+ VGND VGND VPWR VPWR SLICE_16\[0\].RAM16.SLICE\[0\].RAM8.WORD\[6\].W.BYTE\[3\].B.SEL0_B
+ sky130_fd_sc_hd__inv_1
Xtap_9_12 VGND VPWR sky130_fd_sc_hd__tapvpwrvgnd_1
Xtap_9_23 VGND VPWR sky130_fd_sc_hd__tapvpwrvgnd_1
Xtap_9_34 VGND VPWR sky130_fd_sc_hd__tapvpwrvgnd_1
Xfill_42_39 VGND VPWR sky130_fd_sc_hd__tapvpwrvgnd_1
Xfill_42_28 VGND VGND VPWR VPWR sky130_fd_sc_hd__decap_12
Xfill_42_17 VGND VGND VPWR VPWR sky130_fd_sc_hd__decap_12
XSLICE_16\[1\].RAM16.SLICE\[1\].RAM8.WORD\[5\].W.BYTE\[2\].B.genblk1.CG SLICE_16\[1\].RAM16.SLICE\[1\].RAM8.WORD\[5\].W.BYTE\[2\].B.CLK_B
+ SLICE_16\[1\].RAM16.SLICE\[1\].RAM8.WORD\[5\].W.BYTE\[2\].B.WE0_WIRE VGND VGND VPWR
+ VPWR SLICE_16\[1\].RAM16.SLICE\[1\].RAM8.WORD\[5\].W.BYTE\[2\].B.GCLK sky130_fd_sc_hd__dlclkp_1
XSLICE_16\[1\].RAM16.SLICE\[0\].RAM8.WORD\[7\].W.BYTE\[0\].B.BIT\[5\].OBUF0 SLICE_16\[1\].RAM16.SLICE\[0\].RAM8.WORD\[7\].W.BYTE\[0\].B.Q_WIRE\[5\]
+ SLICE_16\[1\].RAM16.SLICE\[0\].RAM8.WORD\[7\].W.BYTE\[0\].B.SEL0_B VGND VGND VPWR
+ VPWR SLICE_16\[1\].RAM16.BYTE\[0\].FLOATBUF0\[5\].Z sky130_fd_sc_hd__ebufn_2
XSLICE_16\[0\].RAM16.SLICE\[1\].RAM8.WORD\[4\].W.BYTE\[2\].B.BIT\[4\].OBUF0 SLICE_16\[0\].RAM16.SLICE\[1\].RAM8.WORD\[4\].W.BYTE\[2\].B.Q_WIRE\[4\]
+ SLICE_16\[0\].RAM16.SLICE\[1\].RAM8.WORD\[4\].W.BYTE\[2\].B.SEL0_B VGND VGND VPWR
+ VPWR SLICE_16\[0\].RAM16.BYTE\[2\].FLOATBUF0\[20\].Z sky130_fd_sc_hd__ebufn_2
Xtap_36_2 VGND VPWR sky130_fd_sc_hd__tapvpwrvgnd_1
Xtap_29_1 VGND VPWR sky130_fd_sc_hd__tapvpwrvgnd_1
XDo0MUX.M\[3\].DIODE_A1MUX\[25\] Do0MUX.A1\[25\] VGND VGND VPWR VPWR sky130_fd_sc_hd__diode_2
Xtap_28_30 VGND VPWR sky130_fd_sc_hd__tapvpwrvgnd_1
XSLICE_16\[0\].RAM16.BYTE\[1\].FLOATBUF0\[11\].__cell__ SLICE_16\[0\].RAM16.BYTE\[1\].FLOATBUF0\[10\].A
+ SLICE_16\[0\].RAM16.BYTE\[1\].FLOATBUF0\[10\].TE_B VGND VGND VPWR VPWR SLICE_16\[0\].RAM16.BYTE\[1\].FLOATBUF0\[11\].Z
+ sky130_fd_sc_hd__ebufn_2
XSLICE_16\[1\].RAM16.SLICE\[1\].RAM8.WORD\[1\].W.BYTE\[1\].B.BIT\[0\].OBUF0 SLICE_16\[1\].RAM16.SLICE\[1\].RAM8.WORD\[1\].W.BYTE\[1\].B.Q_WIRE\[0\]
+ SLICE_16\[1\].RAM16.SLICE\[1\].RAM8.WORD\[1\].W.BYTE\[1\].B.SEL0_B VGND VGND VPWR
+ VPWR SLICE_16\[1\].RAM16.BYTE\[1\].FLOATBUF0\[8\].Z sky130_fd_sc_hd__ebufn_2
XSLICE_16\[1\].RAM16.SLICE\[1\].RAM8.WORD\[6\].W.BYTE\[1\].B.genblk1.CLKINV SLICE_16\[1\].RAM16.SLICE\[1\].RAM8.WORD\[6\].W.BYTE\[0\].B.CLK
+ VGND VGND VPWR VPWR SLICE_16\[1\].RAM16.SLICE\[1\].RAM8.WORD\[6\].W.BYTE\[1\].B.CLK_B
+ sky130_fd_sc_hd__inv_1
XSLICE_16\[1\].RAM16.SLICE\[1\].RAM8.WORD\[6\].W.BYTE\[1\].B.BIT\[0\].genblk1.STORAGE
+ DIBUF\[8\].X SLICE_16\[1\].RAM16.SLICE\[1\].RAM8.WORD\[6\].W.BYTE\[1\].B.GCLK VGND
+ VGND VPWR VPWR SLICE_16\[1\].RAM16.SLICE\[1\].RAM8.WORD\[6\].W.BYTE\[1\].B.Q_WIRE\[0\]
+ sky130_fd_sc_hd__dlxtp_1
XSLICE_16\[1\].RAM16.SLICE\[1\].RAM8.WORD\[0\].W.BYTE\[2\].B.BIT\[1\].genblk1.STORAGE
+ DIBUF\[17\].X SLICE_16\[1\].RAM16.SLICE\[1\].RAM8.WORD\[0\].W.BYTE\[2\].B.GCLK VGND
+ VGND VPWR VPWR SLICE_16\[1\].RAM16.SLICE\[1\].RAM8.WORD\[0\].W.BYTE\[2\].B.Q_WIRE\[1\]
+ sky130_fd_sc_hd__dlxtp_1
XSLICE_16\[0\].RAM16.Do0_REG.OUTREG_BYTE\[1\].Do_FF\[7\] SLICE_16\[0\].RAM16.Do0_REG.CLKBUF\[1\]
+ SLICE_16\[0\].RAM16.BYTE\[1\].FLOATBUF0\[15\].Z VGND VGND VPWR VPWR Do0MUX.A0\[15\]
+ sky130_fd_sc_hd__dfxtp_1
XSLICE_16\[0\].RAM16.SLICE\[1\].RAM8.WORD\[3\].W.BYTE\[0\].B.BIT\[1\].OBUF0 SLICE_16\[0\].RAM16.SLICE\[1\].RAM8.WORD\[3\].W.BYTE\[0\].B.Q_WIRE\[1\]
+ SLICE_16\[0\].RAM16.SLICE\[1\].RAM8.WORD\[3\].W.BYTE\[0\].B.SEL0_B VGND VGND VPWR
+ VPWR SLICE_16\[0\].RAM16.BYTE\[0\].FLOATBUF0\[1\].Z sky130_fd_sc_hd__ebufn_2
XSLICE_16\[0\].RAM16.SLICE\[1\].RAM8.WORD\[7\].W.BYTE\[3\].B.BIT\[4\].OBUF0 SLICE_16\[0\].RAM16.SLICE\[1\].RAM8.WORD\[7\].W.BYTE\[3\].B.Q_WIRE\[4\]
+ SLICE_16\[0\].RAM16.SLICE\[1\].RAM8.WORD\[7\].W.BYTE\[3\].B.SEL0_B VGND VGND VPWR
+ VPWR SLICE_16\[0\].RAM16.BYTE\[3\].FLOATBUF0\[28\].Z sky130_fd_sc_hd__ebufn_2
Xfill_5_4 VGND VGND VPWR VPWR sky130_fd_sc_hd__decap_4
XSLICE_16\[1\].RAM16.SLICE\[0\].RAM8.WORD\[5\].W.BYTE\[3\].B.BIT\[7\].genblk1.STORAGE
+ DIBUF\[31\].X SLICE_16\[1\].RAM16.SLICE\[0\].RAM8.WORD\[5\].W.BYTE\[3\].B.GCLK VGND
+ VGND VPWR VPWR SLICE_16\[1\].RAM16.SLICE\[0\].RAM8.WORD\[5\].W.BYTE\[3\].B.Q_WIRE\[7\]
+ sky130_fd_sc_hd__dlxtp_1
XSLICE_16\[1\].RAM16.SLICE\[0\].RAM8.WORD\[0\].W.BYTE\[3\].B.BIT\[2\].OBUF0 SLICE_16\[1\].RAM16.SLICE\[0\].RAM8.WORD\[0\].W.BYTE\[3\].B.Q_WIRE\[2\]
+ SLICE_16\[1\].RAM16.SLICE\[0\].RAM8.WORD\[0\].W.BYTE\[3\].B.SEL0_B VGND VGND VPWR
+ VPWR SLICE_16\[1\].RAM16.BYTE\[3\].FLOATBUF0\[26\].Z sky130_fd_sc_hd__ebufn_2
XSLICE_16\[1\].RAM16.SLICE\[0\].RAM8.WORD\[3\].W.BYTE\[1\].B.BIT\[6\].genblk1.STORAGE
+ DIBUF\[14\].X SLICE_16\[1\].RAM16.SLICE\[0\].RAM8.WORD\[3\].W.BYTE\[1\].B.GCLK VGND
+ VGND VPWR VPWR SLICE_16\[1\].RAM16.SLICE\[0\].RAM8.WORD\[3\].W.BYTE\[1\].B.Q_WIRE\[6\]
+ sky130_fd_sc_hd__dlxtp_1
XSLICE_16\[1\].RAM16.SLICE\[0\].RAM8.WORD\[3\].W.BYTE\[3\].B.DIODE_CLK SLICE_16\[1\].RAM16.SLICE\[0\].RAM8.WORD\[3\].W.BYTE\[0\].B.CLK
+ VGND VGND VPWR VPWR sky130_fd_sc_hd__diode_2
Xtap_15_7 VGND VPWR sky130_fd_sc_hd__tapvpwrvgnd_1
XSLICE_16\[0\].RAM16.SLICE\[1\].RAM8.WORD\[5\].W.BYTE\[1\].B.BIT\[7\].genblk1.STORAGE
+ DIBUF\[15\].X SLICE_16\[0\].RAM16.SLICE\[1\].RAM8.WORD\[5\].W.BYTE\[1\].B.GCLK VGND
+ VGND VPWR VPWR SLICE_16\[0\].RAM16.SLICE\[1\].RAM8.WORD\[5\].W.BYTE\[1\].B.Q_WIRE\[7\]
+ sky130_fd_sc_hd__dlxtp_1
XSLICE_16\[0\].RAM16.SLICE\[0\].RAM8.WORD\[2\].W.BYTE\[2\].B.BIT\[3\].OBUF0 SLICE_16\[0\].RAM16.SLICE\[0\].RAM8.WORD\[2\].W.BYTE\[2\].B.Q_WIRE\[3\]
+ SLICE_16\[0\].RAM16.SLICE\[0\].RAM8.WORD\[2\].W.BYTE\[2\].B.SEL0_B VGND VGND VPWR
+ VPWR SLICE_16\[0\].RAM16.BYTE\[2\].FLOATBUF0\[19\].Z sky130_fd_sc_hd__ebufn_2
XSLICE_16\[1\].RAM16.SLICE\[1\].RAM8.WORD\[4\].W.BYTE\[2\].B.BIT\[0\].OBUF0 SLICE_16\[1\].RAM16.SLICE\[1\].RAM8.WORD\[4\].W.BYTE\[2\].B.Q_WIRE\[0\]
+ SLICE_16\[1\].RAM16.SLICE\[1\].RAM8.WORD\[4\].W.BYTE\[2\].B.SEL0_B VGND VGND VPWR
+ VPWR SLICE_16\[1\].RAM16.BYTE\[2\].FLOATBUF0\[16\].Z sky130_fd_sc_hd__ebufn_2
Xtap_14_32 VGND VPWR sky130_fd_sc_hd__tapvpwrvgnd_1
Xtap_14_21 VGND VPWR sky130_fd_sc_hd__tapvpwrvgnd_1
Xtap_14_10 VGND VPWR sky130_fd_sc_hd__tapvpwrvgnd_1
XSLICE_16\[0\].RAM16.SLICE\[0\].RAM8.WORD\[4\].W.BYTE\[1\].B.BIT\[2\].genblk1.STORAGE
+ DIBUF\[10\].X SLICE_16\[0\].RAM16.SLICE\[0\].RAM8.WORD\[4\].W.BYTE\[1\].B.GCLK VGND
+ VGND VPWR VPWR SLICE_16\[0\].RAM16.SLICE\[0\].RAM8.WORD\[4\].W.BYTE\[1\].B.Q_WIRE\[2\]
+ sky130_fd_sc_hd__dlxtp_1
XSLICE_16\[0\].RAM16.SLICE\[0\].RAM8.WORD\[6\].W.BYTE\[3\].B.BIT\[3\].genblk1.STORAGE
+ DIBUF\[27\].X SLICE_16\[0\].RAM16.SLICE\[0\].RAM8.WORD\[6\].W.BYTE\[3\].B.GCLK VGND
+ VGND VPWR VPWR SLICE_16\[0\].RAM16.SLICE\[0\].RAM8.WORD\[6\].W.BYTE\[3\].B.Q_WIRE\[3\]
+ sky130_fd_sc_hd__dlxtp_1
Xtap_8_6 VGND VPWR sky130_fd_sc_hd__tapvpwrvgnd_1
Xtap_30_31 VGND VPWR sky130_fd_sc_hd__tapvpwrvgnd_1
Xtap_30_20 VGND VPWR sky130_fd_sc_hd__tapvpwrvgnd_1
Xtap_41_0 VGND VPWR sky130_fd_sc_hd__tapvpwrvgnd_1
XSLICE_16\[0\].RAM16.SLICE\[1\].RAM8.WORD\[6\].W.BYTE\[1\].B.BIT\[1\].OBUF0 SLICE_16\[0\].RAM16.SLICE\[1\].RAM8.WORD\[6\].W.BYTE\[1\].B.Q_WIRE\[1\]
+ SLICE_16\[0\].RAM16.SLICE\[1\].RAM8.WORD\[6\].W.BYTE\[1\].B.SEL0_B VGND VGND VPWR
+ VPWR SLICE_16\[0\].RAM16.BYTE\[1\].FLOATBUF0\[9\].Z sky130_fd_sc_hd__ebufn_2
XSLICE_16\[0\].RAM16.SLICE\[1\].RAM8.WORD\[0\].W.BYTE\[3\].B.DIODE_CLK SLICE_16\[0\].RAM16.SLICE\[1\].RAM8.WORD\[0\].W.BYTE\[0\].B.CLK
+ VGND VGND VPWR VPWR sky130_fd_sc_hd__diode_2
XSLICE_16\[0\].RAM16.SLICE\[0\].RAM8.WORD\[6\].W.BYTE\[2\].B.DIODE_CLK SLICE_16\[0\].RAM16.SLICE\[0\].RAM8.WORD\[6\].W.BYTE\[0\].B.CLK
+ VGND VGND VPWR VPWR sky130_fd_sc_hd__diode_2
Xfill_46_129 VGND VPWR sky130_fd_sc_hd__tapvpwrvgnd_1
Xfill_46_118 VGND VGND VPWR VPWR sky130_fd_sc_hd__decap_12
Xfill_46_107 VGND VGND VPWR VPWR sky130_fd_sc_hd__decap_12
Xfill_43_93 VGND VPWR sky130_fd_sc_hd__tapvpwrvgnd_1
Xfill_43_82 VGND VGND VPWR VPWR sky130_fd_sc_hd__decap_12
Xfill_43_71 VGND VGND VPWR VPWR sky130_fd_sc_hd__decap_12
Xfill_43_60 VGND VPWR sky130_fd_sc_hd__tapvpwrvgnd_1
XSLICE_16\[1\].RAM16.SLICE\[1\].RAM8.WORD\[2\].W.BYTE\[0\].B.DIODE_CLK SLICE_16\[1\].RAM16.SLICE\[1\].RAM8.WORD\[2\].W.BYTE\[0\].B.CLK
+ VGND VGND VPWR VPWR sky130_fd_sc_hd__diode_2
XSLICE_16\[1\].RAM16.SLICE\[1\].RAM8.WORD\[1\].W.BYTE\[3\].B.CGAND SLICE_16\[1\].RAM16.SLICE\[1\].RAM8.WORD\[1\].W.BYTE\[0\].B.SEL0
+ SLICE_16\[1\].RAM16.SLICE\[1\].RAM8.WE0_buf\[3\] VGND VGND VPWR VPWR SLICE_16\[1\].RAM16.SLICE\[1\].RAM8.WORD\[1\].W.BYTE\[3\].B.WE0_WIRE
+ sky130_fd_sc_hd__and2_1
XSLICE_16\[0\].RAM16.SLICE\[0\].RAM8.WORD\[1\].W.BYTE\[0\].B.BIT\[0\].OBUF0 SLICE_16\[0\].RAM16.SLICE\[0\].RAM8.WORD\[1\].W.BYTE\[0\].B.Q_WIRE\[0\]
+ SLICE_16\[0\].RAM16.SLICE\[0\].RAM8.WORD\[1\].W.BYTE\[0\].B.SEL0_B VGND VGND VPWR
+ VPWR SLICE_16\[0\].RAM16.BYTE\[0\].FLOATBUF0\[0\].Z sky130_fd_sc_hd__ebufn_2
XSLICE_16\[0\].RAM16.SLICE\[0\].RAM8.WORD\[6\].W.BYTE\[0\].B.genblk1.CLKINV SLICE_16\[0\].RAM16.SLICE\[0\].RAM8.WORD\[6\].W.BYTE\[0\].B.CLK
+ VGND VGND VPWR VPWR SLICE_16\[0\].RAM16.SLICE\[0\].RAM8.WORD\[6\].W.BYTE\[0\].B.CLK_B
+ sky130_fd_sc_hd__inv_1
XSLICE_16\[1\].RAM16.SLICE\[0\].RAM8.WORD\[0\].W.BYTE\[1\].B.BIT\[7\].OBUF0 SLICE_16\[1\].RAM16.SLICE\[0\].RAM8.WORD\[0\].W.BYTE\[1\].B.Q_WIRE\[7\]
+ SLICE_16\[1\].RAM16.SLICE\[0\].RAM8.WORD\[0\].W.BYTE\[1\].B.SEL0_B VGND VGND VPWR
+ VPWR SLICE_16\[1\].RAM16.BYTE\[1\].FLOATBUF0\[15\].Z sky130_fd_sc_hd__ebufn_2
XSLICE_16\[0\].RAM16.SLICE\[0\].RAM8.WORD\[5\].W.BYTE\[3\].B.BIT\[3\].OBUF0 SLICE_16\[0\].RAM16.SLICE\[0\].RAM8.WORD\[5\].W.BYTE\[3\].B.Q_WIRE\[3\]
+ SLICE_16\[0\].RAM16.SLICE\[0\].RAM8.WORD\[5\].W.BYTE\[3\].B.SEL0_B VGND VGND VPWR
+ VPWR SLICE_16\[0\].RAM16.BYTE\[3\].FLOATBUF0\[27\].Z sky130_fd_sc_hd__ebufn_2
XSLICE_16\[1\].RAM16.SLICE\[1\].RAM8.WORD\[7\].W.BYTE\[3\].B.BIT\[0\].OBUF0 SLICE_16\[1\].RAM16.SLICE\[1\].RAM8.WORD\[7\].W.BYTE\[3\].B.Q_WIRE\[0\]
+ SLICE_16\[1\].RAM16.SLICE\[1\].RAM8.WORD\[7\].W.BYTE\[3\].B.SEL0_B VGND VGND VPWR
+ VPWR SLICE_16\[1\].RAM16.BYTE\[3\].FLOATBUF0\[24\].Z sky130_fd_sc_hd__ebufn_2
XSLICE_16\[1\].RAM16.SLICE\[1\].RAM8.WORD\[3\].W.BYTE\[3\].B.BIT\[1\].genblk1.STORAGE
+ DIBUF\[25\].X SLICE_16\[1\].RAM16.SLICE\[1\].RAM8.WORD\[3\].W.BYTE\[3\].B.GCLK VGND
+ VGND VPWR VPWR SLICE_16\[1\].RAM16.SLICE\[1\].RAM8.WORD\[3\].W.BYTE\[3\].B.Q_WIRE\[1\]
+ sky130_fd_sc_hd__dlxtp_1
XSLICE_16\[1\].RAM16.SLICE\[0\].RAM8.WORD\[4\].W.CLKBUF SLICE_16\[1\].RAM16.SLICE\[0\].RAM8.CLKBUF.X
+ VGND VGND VPWR VPWR SLICE_16\[1\].RAM16.SLICE\[0\].RAM8.WORD\[4\].W.BYTE\[0\].B.CLK
+ sky130_fd_sc_hd__clkbuf_4
Xfill_3_1 VGND VPWR sky130_fd_sc_hd__tapvpwrvgnd_1
XSLICE_16\[1\].RAM16.Do0_REG.OUTREG_BYTE\[1\].DIODE\[2\] SLICE_16\[1\].RAM16.BYTE\[1\].FLOATBUF0\[10\].Z
+ VGND VGND VPWR VPWR sky130_fd_sc_hd__diode_2
XSLICE_16\[1\].RAM16.SLICE\[1\].RAM8.WORD\[1\].W.BYTE\[1\].B.BIT\[0\].genblk1.STORAGE
+ DIBUF\[8\].X SLICE_16\[1\].RAM16.SLICE\[1\].RAM8.WORD\[1\].W.BYTE\[1\].B.GCLK VGND
+ VGND VPWR VPWR SLICE_16\[1\].RAM16.SLICE\[1\].RAM8.WORD\[1\].W.BYTE\[1\].B.Q_WIRE\[0\]
+ sky130_fd_sc_hd__dlxtp_1
XDIBUF\[22\].__cell__ Di0[22] VGND VGND VPWR VPWR DIBUF\[22\].X sky130_fd_sc_hd__clkbuf_16
Xtap_6_13 VGND VPWR sky130_fd_sc_hd__tapvpwrvgnd_1
Xtap_6_24 VGND VPWR sky130_fd_sc_hd__tapvpwrvgnd_1
Xtap_6_35 VGND VPWR sky130_fd_sc_hd__tapvpwrvgnd_1
XSLICE_16\[1\].RAM16.SLICE\[1\].RAM8.WORD\[4\].W.BYTE\[0\].B.BIT\[5\].OBUF0 SLICE_16\[1\].RAM16.SLICE\[1\].RAM8.WORD\[4\].W.BYTE\[0\].B.Q_WIRE\[5\]
+ SLICE_16\[1\].RAM16.SLICE\[1\].RAM8.WORD\[4\].W.BYTE\[0\].B.SEL0_B VGND VGND VPWR
+ VPWR SLICE_16\[1\].RAM16.BYTE\[0\].FLOATBUF0\[5\].Z sky130_fd_sc_hd__ebufn_2
XSLICE_16\[1\].RAM16.SLICE\[0\].RAM8.WORD\[4\].W.BYTE\[3\].B.SEL0INV SLICE_16\[1\].RAM16.SLICE\[0\].RAM8.WORD\[4\].W.BYTE\[0\].B.SEL0
+ VGND VGND VPWR VPWR SLICE_16\[1\].RAM16.SLICE\[0\].RAM8.WORD\[4\].W.BYTE\[3\].B.SEL0_B
+ sky130_fd_sc_hd__inv_1
Xtap_25_31 VGND VPWR sky130_fd_sc_hd__tapvpwrvgnd_1
Xtap_25_20 VGND VPWR sky130_fd_sc_hd__tapvpwrvgnd_1
Xtap_13_4 VGND VPWR sky130_fd_sc_hd__tapvpwrvgnd_1
Xtap_6_3 VGND VPWR sky130_fd_sc_hd__tapvpwrvgnd_1
XSLICE_16\[1\].RAM16.SLICE\[0\].RAM8.WORD\[6\].W.BYTE\[2\].B.BIT\[6\].genblk1.STORAGE
+ DIBUF\[22\].X SLICE_16\[1\].RAM16.SLICE\[0\].RAM8.WORD\[6\].W.BYTE\[2\].B.GCLK VGND
+ VGND VPWR VPWR SLICE_16\[1\].RAM16.SLICE\[0\].RAM8.WORD\[6\].W.BYTE\[2\].B.Q_WIRE\[6\]
+ sky130_fd_sc_hd__dlxtp_1
XSLICE_16\[1\].RAM16.SLICE\[0\].RAM8.WORD\[1\].W.SEL0BUF SLICE_16\[1\].RAM16.SLICE\[0\].RAM8.DEC0.SEL\[1\]
+ VGND VGND VPWR VPWR SLICE_16\[1\].RAM16.SLICE\[0\].RAM8.WORD\[1\].W.BYTE\[0\].B.SEL0
+ sky130_fd_sc_hd__clkbuf_2
XSLICE_16\[1\].RAM16.SLICE\[0\].RAM8.WORD\[0\].W.BYTE\[3\].B.BIT\[7\].genblk1.STORAGE
+ DIBUF\[31\].X SLICE_16\[1\].RAM16.SLICE\[0\].RAM8.WORD\[0\].W.BYTE\[3\].B.GCLK VGND
+ VGND VPWR VPWR SLICE_16\[1\].RAM16.SLICE\[0\].RAM8.WORD\[0\].W.BYTE\[3\].B.Q_WIRE\[7\]
+ sky130_fd_sc_hd__dlxtp_1
XSLICE_16\[0\].RAM16.SLICE\[0\].RAM8.WORD\[4\].W.BYTE\[1\].B.BIT\[0\].OBUF0 SLICE_16\[0\].RAM16.SLICE\[0\].RAM8.WORD\[4\].W.BYTE\[1\].B.Q_WIRE\[0\]
+ SLICE_16\[0\].RAM16.SLICE\[0\].RAM8.WORD\[4\].W.BYTE\[1\].B.SEL0_B VGND VGND VPWR
+ VPWR SLICE_16\[0\].RAM16.BYTE\[1\].FLOATBUF0\[8\].Z sky130_fd_sc_hd__ebufn_2
XSLICE_16\[1\].RAM16.SLICE\[0\].RAM8.WORD\[3\].W.BYTE\[2\].B.BIT\[7\].OBUF0 SLICE_16\[1\].RAM16.SLICE\[0\].RAM8.WORD\[3\].W.BYTE\[2\].B.Q_WIRE\[7\]
+ SLICE_16\[1\].RAM16.SLICE\[0\].RAM8.WORD\[3\].W.BYTE\[2\].B.SEL0_B VGND VGND VPWR
+ VPWR SLICE_16\[1\].RAM16.BYTE\[2\].FLOATBUF0\[23\].Z sky130_fd_sc_hd__ebufn_2
XSLICE_16\[1\].RAM16.SLICE\[0\].RAM8.WORD\[4\].W.BYTE\[0\].B.BIT\[5\].genblk1.STORAGE
+ DIBUF\[5\].X SLICE_16\[1\].RAM16.SLICE\[0\].RAM8.WORD\[4\].W.BYTE\[0\].B.GCLK VGND
+ VGND VPWR VPWR SLICE_16\[1\].RAM16.SLICE\[0\].RAM8.WORD\[4\].W.BYTE\[0\].B.Q_WIRE\[5\]
+ sky130_fd_sc_hd__dlxtp_1
Xfill_41_8 VGND VGND VPWR VPWR sky130_fd_sc_hd__decap_12
XSLICE_16\[1\].RAM16.SLICE\[0\].RAM8.WORD\[5\].W.BYTE\[0\].B.CGAND SLICE_16\[1\].RAM16.SLICE\[0\].RAM8.WORD\[5\].W.BYTE\[0\].B.SEL0
+ SLICE_16\[1\].RAM16.SLICE\[0\].RAM8.WE0_buf\[0\] VGND VGND VPWR VPWR SLICE_16\[1\].RAM16.SLICE\[0\].RAM8.WORD\[5\].W.BYTE\[0\].B.WE0_WIRE
+ sky130_fd_sc_hd__and2_1
XSLICE_16\[0\].RAM16.SLICE\[1\].RAM8.WORD\[6\].W.BYTE\[0\].B.BIT\[6\].genblk1.STORAGE
+ DIBUF\[6\].X SLICE_16\[0\].RAM16.SLICE\[1\].RAM8.WORD\[6\].W.BYTE\[0\].B.GCLK VGND
+ VGND VPWR VPWR SLICE_16\[0\].RAM16.SLICE\[1\].RAM8.WORD\[6\].W.BYTE\[0\].B.Q_WIRE\[6\]
+ sky130_fd_sc_hd__dlxtp_1
XSLICE_16\[0\].RAM16.SLICE\[0\].RAM8.WORD\[1\].W.BYTE\[3\].B.BIT\[3\].genblk1.STORAGE
+ DIBUF\[27\].X SLICE_16\[0\].RAM16.SLICE\[0\].RAM8.WORD\[1\].W.BYTE\[3\].B.GCLK VGND
+ VGND VPWR VPWR SLICE_16\[0\].RAM16.SLICE\[0\].RAM8.WORD\[1\].W.BYTE\[3\].B.Q_WIRE\[3\]
+ sky130_fd_sc_hd__dlxtp_1
XSLICE_16\[0\].RAM16.SLICE\[0\].RAM8.WORD\[7\].W.BYTE\[2\].B.BIT\[2\].genblk1.STORAGE
+ DIBUF\[18\].X SLICE_16\[0\].RAM16.SLICE\[0\].RAM8.WORD\[7\].W.BYTE\[2\].B.GCLK VGND
+ VGND VPWR VPWR SLICE_16\[0\].RAM16.SLICE\[0\].RAM8.WORD\[7\].W.BYTE\[2\].B.Q_WIRE\[2\]
+ sky130_fd_sc_hd__dlxtp_1
XSLICE_16\[0\].RAM16.SLICE\[1\].RAM8.WORD\[0\].W.BYTE\[1\].B.BIT\[7\].genblk1.STORAGE
+ DIBUF\[15\].X SLICE_16\[0\].RAM16.SLICE\[1\].RAM8.WORD\[0\].W.BYTE\[1\].B.GCLK VGND
+ VGND VPWR VPWR SLICE_16\[0\].RAM16.SLICE\[1\].RAM8.WORD\[0\].W.BYTE\[1\].B.Q_WIRE\[7\]
+ sky130_fd_sc_hd__dlxtp_1
Xfill_27_6 VGND VGND VPWR VPWR sky130_fd_sc_hd__decap_6
XSLICE_16\[0\].RAM16.SLICE\[0\].RAM8.WORD\[5\].W.BYTE\[0\].B.BIT\[1\].genblk1.STORAGE
+ DIBUF\[1\].X SLICE_16\[0\].RAM16.SLICE\[0\].RAM8.WORD\[5\].W.BYTE\[0\].B.GCLK VGND
+ VGND VPWR VPWR SLICE_16\[0\].RAM16.SLICE\[0\].RAM8.WORD\[5\].W.BYTE\[0\].B.Q_WIRE\[1\]
+ sky130_fd_sc_hd__dlxtp_1
XSLICE_16\[1\].RAM16.SLICE\[1\].RAM8.WORD\[7\].W.BYTE\[1\].B.BIT\[5\].OBUF0 SLICE_16\[1\].RAM16.SLICE\[1\].RAM8.WORD\[7\].W.BYTE\[1\].B.Q_WIRE\[5\]
+ SLICE_16\[1\].RAM16.SLICE\[1\].RAM8.WORD\[7\].W.BYTE\[1\].B.SEL0_B VGND VGND VPWR
+ VPWR SLICE_16\[1\].RAM16.BYTE\[1\].FLOATBUF0\[13\].Z sky130_fd_sc_hd__ebufn_2
XSLICE_16\[1\].RAM16.SLICE\[1\].RAM8.WORD\[5\].W.BYTE\[3\].B.DIODE_CLK SLICE_16\[1\].RAM16.SLICE\[1\].RAM8.WORD\[5\].W.BYTE\[0\].B.CLK
+ VGND VGND VPWR VPWR sky130_fd_sc_hd__diode_2
XSLICE_16\[1\].RAM16.Do0_REG.OUTREG_BYTE\[0\].Do_FF\[3\] SLICE_16\[1\].RAM16.Do0_REG.CLKBUF\[0\]
+ SLICE_16\[1\].RAM16.BYTE\[0\].FLOATBUF0\[3\].Z VGND VGND VPWR VPWR Do0MUX.A1\[3\]
+ sky130_fd_sc_hd__dfxtp_1
Xfill_18_19 VGND VGND VPWR VPWR sky130_fd_sc_hd__decap_12
XSLICE_16\[1\].RAM16.SLICE\[0\].RAM8.WORD\[2\].W.BYTE\[0\].B.BIT\[4\].OBUF0 SLICE_16\[1\].RAM16.SLICE\[0\].RAM8.WORD\[2\].W.BYTE\[0\].B.Q_WIRE\[4\]
+ SLICE_16\[1\].RAM16.SLICE\[0\].RAM8.WORD\[2\].W.BYTE\[0\].B.SEL0_B VGND VGND VPWR
+ VPWR SLICE_16\[1\].RAM16.BYTE\[0\].FLOATBUF0\[4\].Z sky130_fd_sc_hd__ebufn_2
XSLICE_16\[0\].RAM16.SLICE\[0\].RAM8.WORD\[7\].W.BYTE\[2\].B.BIT\[0\].OBUF0 SLICE_16\[0\].RAM16.SLICE\[0\].RAM8.WORD\[7\].W.BYTE\[2\].B.Q_WIRE\[0\]
+ SLICE_16\[0\].RAM16.SLICE\[0\].RAM8.WORD\[7\].W.BYTE\[2\].B.SEL0_B VGND VGND VPWR
+ VPWR SLICE_16\[0\].RAM16.BYTE\[2\].FLOATBUF0\[16\].Z sky130_fd_sc_hd__ebufn_2
XSLICE_16\[1\].RAM16.SLICE\[0\].RAM8.WORD\[6\].W.BYTE\[3\].B.BIT\[7\].OBUF0 SLICE_16\[1\].RAM16.SLICE\[0\].RAM8.WORD\[6\].W.BYTE\[3\].B.Q_WIRE\[7\]
+ SLICE_16\[1\].RAM16.SLICE\[0\].RAM8.WORD\[6\].W.BYTE\[3\].B.SEL0_B VGND VGND VPWR
+ VPWR SLICE_16\[1\].RAM16.BYTE\[3\].FLOATBUF0\[31\].Z sky130_fd_sc_hd__ebufn_2
Xtap_11_11 VGND VPWR sky130_fd_sc_hd__tapvpwrvgnd_1
Xtap_11_22 VGND VPWR sky130_fd_sc_hd__tapvpwrvgnd_1
Xtap_11_33 VGND VPWR sky130_fd_sc_hd__tapvpwrvgnd_1
Xtap_36_30 VGND VPWR sky130_fd_sc_hd__tapvpwrvgnd_1
XSLICE_16\[1\].RAM16.SLICE\[1\].RAM8.WORD\[4\].W.BYTE\[2\].B.BIT\[0\].genblk1.STORAGE
+ DIBUF\[16\].X SLICE_16\[1\].RAM16.SLICE\[1\].RAM8.WORD\[4\].W.BYTE\[2\].B.GCLK VGND
+ VGND VPWR VPWR SLICE_16\[1\].RAM16.SLICE\[1\].RAM8.WORD\[4\].W.BYTE\[2\].B.Q_WIRE\[0\]
+ sky130_fd_sc_hd__dlxtp_1
XSLICE_16\[0\].RAM16.SLICE\[1\].RAM8.WORD\[4\].W.BYTE\[2\].B.genblk1.CG SLICE_16\[0\].RAM16.SLICE\[1\].RAM8.WORD\[4\].W.BYTE\[2\].B.CLK_B
+ SLICE_16\[0\].RAM16.SLICE\[1\].RAM8.WORD\[4\].W.BYTE\[2\].B.WE0_WIRE VGND VGND VPWR
+ VPWR SLICE_16\[0\].RAM16.SLICE\[1\].RAM8.WORD\[4\].W.BYTE\[2\].B.GCLK sky130_fd_sc_hd__dlclkp_1
XSLICE_16\[0\].RAM16.SLICE\[0\].RAM8.WORD\[7\].W.BYTE\[2\].B.CGAND SLICE_16\[0\].RAM16.SLICE\[0\].RAM8.WORD\[7\].W.BYTE\[0\].B.SEL0
+ SLICE_16\[0\].RAM16.SLICE\[0\].RAM8.WE0_buf\[2\] VGND VGND VPWR VPWR SLICE_16\[0\].RAM16.SLICE\[0\].RAM8.WORD\[7\].W.BYTE\[2\].B.WE0_WIRE
+ sky130_fd_sc_hd__and2_1
Xtap_11_1 VGND VPWR sky130_fd_sc_hd__tapvpwrvgnd_1
XSLICE_16\[0\].RAM16.Do0_REG.OUTREG_BYTE\[2\].Do_FF\[0\] SLICE_16\[0\].RAM16.Do0_REG.CLKBUF\[2\]
+ SLICE_16\[0\].RAM16.BYTE\[2\].FLOATBUF0\[16\].Z VGND VGND VPWR VPWR Do0MUX.A0\[16\]
+ sky130_fd_sc_hd__dfxtp_1
Xtap_4_0 VGND VPWR sky130_fd_sc_hd__tapvpwrvgnd_1
XDIBUF\[6\].__cell__ Di0[6] VGND VGND VPWR VPWR DIBUF\[6\].X sky130_fd_sc_hd__clkbuf_16
Xfill_32_4 VGND VGND VPWR VPWR sky130_fd_sc_hd__fill_2
XSLICE_16\[1\].RAM16.SLICE\[0\].RAM8.WORD\[7\].W.BYTE\[1\].B.BIT\[5\].genblk1.STORAGE
+ DIBUF\[13\].X SLICE_16\[1\].RAM16.SLICE\[0\].RAM8.WORD\[7\].W.BYTE\[1\].B.GCLK VGND
+ VGND VPWR VPWR SLICE_16\[1\].RAM16.SLICE\[0\].RAM8.WORD\[7\].W.BYTE\[1\].B.Q_WIRE\[5\]
+ sky130_fd_sc_hd__dlxtp_1
XSLICE_16\[1\].RAM16.SLICE\[0\].RAM8.WORD\[5\].W.BYTE\[1\].B.BIT\[4\].OBUF0 SLICE_16\[1\].RAM16.SLICE\[0\].RAM8.WORD\[5\].W.BYTE\[1\].B.Q_WIRE\[4\]
+ SLICE_16\[1\].RAM16.SLICE\[0\].RAM8.WORD\[5\].W.BYTE\[1\].B.SEL0_B VGND VGND VPWR
+ VPWR SLICE_16\[1\].RAM16.BYTE\[1\].FLOATBUF0\[12\].Z sky130_fd_sc_hd__ebufn_2
Xfill_25_3 VGND VGND VPWR VPWR sky130_fd_sc_hd__decap_4
XSLICE_16\[1\].RAM16.SLICE\[0\].RAM8.WORD\[1\].W.BYTE\[2\].B.BIT\[6\].genblk1.STORAGE
+ DIBUF\[22\].X SLICE_16\[1\].RAM16.SLICE\[0\].RAM8.WORD\[1\].W.BYTE\[2\].B.GCLK VGND
+ VGND VPWR VPWR SLICE_16\[1\].RAM16.SLICE\[0\].RAM8.WORD\[1\].W.BYTE\[2\].B.Q_WIRE\[6\]
+ sky130_fd_sc_hd__dlxtp_1
Xfill_18_2 VGND VGND VPWR VPWR sky130_fd_sc_hd__decap_12
XSLICE_16\[0\].RAM16.SLICE\[1\].RAM8.WORD\[3\].W.BYTE\[0\].B.genblk1.CLKINV SLICE_16\[0\].RAM16.SLICE\[1\].RAM8.WORD\[3\].W.BYTE\[0\].B.CLK
+ VGND VGND VPWR VPWR SLICE_16\[0\].RAM16.SLICE\[1\].RAM8.WORD\[3\].W.BYTE\[0\].B.CLK_B
+ sky130_fd_sc_hd__inv_1
XSLICE_16\[0\].RAM16.SLICE\[1\].RAM8.WORD\[2\].W.BYTE\[3\].B.BIT\[3\].OBUF0 SLICE_16\[0\].RAM16.SLICE\[1\].RAM8.WORD\[2\].W.BYTE\[3\].B.Q_WIRE\[3\]
+ SLICE_16\[0\].RAM16.SLICE\[1\].RAM8.WORD\[2\].W.BYTE\[3\].B.SEL0_B VGND VGND VPWR
+ VPWR SLICE_16\[0\].RAM16.BYTE\[3\].FLOATBUF0\[27\].Z sky130_fd_sc_hd__ebufn_2
XSLICE_16\[1\].RAM16.SLICE\[1\].RAM8.WORD\[1\].W.BYTE\[1\].B.genblk1.CG SLICE_16\[1\].RAM16.SLICE\[1\].RAM8.WORD\[1\].W.BYTE\[1\].B.CLK_B
+ SLICE_16\[1\].RAM16.SLICE\[1\].RAM8.WORD\[1\].W.BYTE\[1\].B.WE0_WIRE VGND VGND VPWR
+ VPWR SLICE_16\[1\].RAM16.SLICE\[1\].RAM8.WORD\[1\].W.BYTE\[1\].B.GCLK sky130_fd_sc_hd__dlclkp_1
XSLICE_16\[0\].RAM16.SLICE\[1\].RAM8.WORD\[3\].W.BYTE\[2\].B.BIT\[7\].genblk1.STORAGE
+ DIBUF\[23\].X SLICE_16\[0\].RAM16.SLICE\[1\].RAM8.WORD\[3\].W.BYTE\[2\].B.GCLK VGND
+ VGND VPWR VPWR SLICE_16\[0\].RAM16.SLICE\[1\].RAM8.WORD\[3\].W.BYTE\[2\].B.Q_WIRE\[7\]
+ sky130_fd_sc_hd__dlxtp_1
XSLICE_16\[0\].RAM16.SLICE\[1\].RAM8.WORD\[1\].W.BYTE\[0\].B.BIT\[6\].genblk1.STORAGE
+ DIBUF\[6\].X SLICE_16\[0\].RAM16.SLICE\[1\].RAM8.WORD\[1\].W.BYTE\[0\].B.GCLK VGND
+ VGND VPWR VPWR SLICE_16\[0\].RAM16.SLICE\[1\].RAM8.WORD\[1\].W.BYTE\[0\].B.Q_WIRE\[6\]
+ sky130_fd_sc_hd__dlxtp_1
Xtap_3_14 VGND VPWR sky130_fd_sc_hd__tapvpwrvgnd_1
XSLICE_16\[0\].RAM16.SLICE\[0\].RAM8.WORD\[2\].W.BYTE\[2\].B.BIT\[2\].genblk1.STORAGE
+ DIBUF\[18\].X SLICE_16\[0\].RAM16.SLICE\[0\].RAM8.WORD\[2\].W.BYTE\[2\].B.GCLK VGND
+ VGND VPWR VPWR SLICE_16\[0\].RAM16.SLICE\[0\].RAM8.WORD\[2\].W.BYTE\[2\].B.Q_WIRE\[2\]
+ sky130_fd_sc_hd__dlxtp_1
Xtap_3_25 VGND VPWR sky130_fd_sc_hd__tapvpwrvgnd_1
Xtap_3_36 VGND VPWR sky130_fd_sc_hd__tapvpwrvgnd_1
XSLICE_16\[0\].RAM16.SLICE\[0\].RAM8.WORD\[7\].W.BYTE\[0\].B.BIT\[5\].OBUF0 SLICE_16\[0\].RAM16.SLICE\[0\].RAM8.WORD\[7\].W.BYTE\[0\].B.Q_WIRE\[5\]
+ SLICE_16\[0\].RAM16.SLICE\[0\].RAM8.WORD\[7\].W.BYTE\[0\].B.SEL0_B VGND VGND VPWR
+ VPWR SLICE_16\[0\].RAM16.BYTE\[0\].FLOATBUF0\[5\].Z sky130_fd_sc_hd__ebufn_2
Xfill_45_39 VGND VPWR sky130_fd_sc_hd__tapvpwrvgnd_1
Xfill_45_28 VGND VGND VPWR VPWR sky130_fd_sc_hd__decap_12
Xfill_45_17 VGND VGND VPWR VPWR sky130_fd_sc_hd__decap_12
XSLICE_16\[0\].RAM16.SLICE\[0\].RAM8.WORD\[0\].W.BYTE\[0\].B.BIT\[1\].genblk1.STORAGE
+ DIBUF\[1\].X SLICE_16\[0\].RAM16.SLICE\[0\].RAM8.WORD\[0\].W.BYTE\[0\].B.GCLK VGND
+ VGND VPWR VPWR SLICE_16\[0\].RAM16.SLICE\[0\].RAM8.WORD\[0\].W.BYTE\[0\].B.Q_WIRE\[1\]
+ sky130_fd_sc_hd__dlxtp_1
Xfill_21_102 VGND VGND VPWR VPWR sky130_fd_sc_hd__decap_3
Xfill_19_84 VGND VPWR sky130_fd_sc_hd__tapvpwrvgnd_1
Xfill_19_73 VGND VGND VPWR VPWR sky130_fd_sc_hd__decap_12
Xfill_19_62 VGND VGND VPWR VPWR sky130_fd_sc_hd__decap_12
Xfill_19_51 VGND VPWR sky130_fd_sc_hd__tapvpwrvgnd_1
Xfill_19_40 VGND VGND VPWR VPWR sky130_fd_sc_hd__decap_12
XSLICE_16\[0\].RAM16.SLICE\[1\].RAM8.WORD\[6\].W.BYTE\[1\].B.genblk1.CLKINV SLICE_16\[0\].RAM16.SLICE\[1\].RAM8.WORD\[6\].W.BYTE\[0\].B.CLK
+ VGND VGND VPWR VPWR SLICE_16\[0\].RAM16.SLICE\[1\].RAM8.WORD\[6\].W.BYTE\[1\].B.CLK_B
+ sky130_fd_sc_hd__inv_1
XSLICE_16\[0\].RAM16.SLICE\[1\].RAM8.WORD\[1\].W.BYTE\[1\].B.BIT\[0\].OBUF0 SLICE_16\[0\].RAM16.SLICE\[1\].RAM8.WORD\[1\].W.BYTE\[1\].B.Q_WIRE\[0\]
+ SLICE_16\[0\].RAM16.SLICE\[1\].RAM8.WORD\[1\].W.BYTE\[1\].B.SEL0_B VGND VGND VPWR
+ VPWR SLICE_16\[0\].RAM16.BYTE\[1\].FLOATBUF0\[8\].Z sky130_fd_sc_hd__ebufn_2
XSLICE_16\[1\].RAM16.SLICE\[1\].RAM8.WORD\[0\].W.BYTE\[2\].B.BIT\[7\].OBUF0 SLICE_16\[1\].RAM16.SLICE\[1\].RAM8.WORD\[0\].W.BYTE\[2\].B.Q_WIRE\[7\]
+ SLICE_16\[1\].RAM16.SLICE\[1\].RAM8.WORD\[0\].W.BYTE\[2\].B.SEL0_B VGND VGND VPWR
+ VPWR SLICE_16\[1\].RAM16.BYTE\[2\].FLOATBUF0\[23\].Z sky130_fd_sc_hd__ebufn_2
Xfill_19_95 VGND VGND VPWR VPWR sky130_fd_sc_hd__decap_12
XSLICE_16\[1\].RAM16.SLICE\[1\].RAM8.WORD\[7\].W.BYTE\[3\].B.BIT\[0\].genblk1.STORAGE
+ DIBUF\[24\].X SLICE_16\[1\].RAM16.SLICE\[1\].RAM8.WORD\[7\].W.BYTE\[3\].B.GCLK VGND
+ VGND VPWR VPWR SLICE_16\[1\].RAM16.SLICE\[1\].RAM8.WORD\[7\].W.BYTE\[3\].B.Q_WIRE\[0\]
+ sky130_fd_sc_hd__dlxtp_1
XWEBUF\[2\].__cell__ WE0[2] VGND VGND VPWR VPWR SLICE_16\[0\].RAM16.WE0\[2\] sky130_fd_sc_hd__clkbuf_2
XSLICE_16\[0\].RAM16.SLICE\[0\].RAM8.WORD\[0\].W.BYTE\[3\].B.BIT\[2\].OBUF0 SLICE_16\[0\].RAM16.SLICE\[0\].RAM8.WORD\[0\].W.BYTE\[3\].B.Q_WIRE\[2\]
+ SLICE_16\[0\].RAM16.SLICE\[0\].RAM8.WORD\[0\].W.BYTE\[3\].B.SEL0_B VGND VGND VPWR
+ VPWR SLICE_16\[0\].RAM16.BYTE\[3\].FLOATBUF0\[26\].Z sky130_fd_sc_hd__ebufn_2
Xfill_30_1 VGND VPWR sky130_fd_sc_hd__tapvpwrvgnd_1
Xfill_23_0 VGND VPWR sky130_fd_sc_hd__tapvpwrvgnd_1
XSLICE_16\[0\].RAM16.SLICE\[0\].RAM8.WORD\[6\].W.BYTE\[2\].B.SEL0INV SLICE_16\[0\].RAM16.SLICE\[0\].RAM8.WORD\[6\].W.BYTE\[0\].B.SEL0
+ VGND VGND VPWR VPWR SLICE_16\[0\].RAM16.SLICE\[0\].RAM8.WORD\[6\].W.BYTE\[2\].B.SEL0_B
+ sky130_fd_sc_hd__inv_1
Xtap_38_6 VGND VPWR sky130_fd_sc_hd__tapvpwrvgnd_1
XSLICE_16\[1\].RAM16.SLICE\[0\].RAM8.WORD\[7\].W.BYTE\[0\].B.BIT\[1\].OBUF0 SLICE_16\[1\].RAM16.SLICE\[0\].RAM8.WORD\[7\].W.BYTE\[0\].B.Q_WIRE\[1\]
+ SLICE_16\[1\].RAM16.SLICE\[0\].RAM8.WORD\[7\].W.BYTE\[0\].B.SEL0_B VGND VGND VPWR
+ VPWR SLICE_16\[1\].RAM16.BYTE\[0\].FLOATBUF0\[1\].Z sky130_fd_sc_hd__ebufn_2
XSLICE_16\[1\].RAM16.SLICE\[0\].RAM8.WORD\[4\].W.BYTE\[3\].B.BIT\[6\].genblk1.STORAGE
+ DIBUF\[30\].X SLICE_16\[1\].RAM16.SLICE\[0\].RAM8.WORD\[4\].W.BYTE\[3\].B.GCLK VGND
+ VGND VPWR VPWR SLICE_16\[1\].RAM16.SLICE\[0\].RAM8.WORD\[4\].W.BYTE\[3\].B.Q_WIRE\[6\]
+ sky130_fd_sc_hd__dlxtp_1
XSLICE_16\[1\].RAM16.SLICE\[0\].RAM8.WORD\[2\].W.BYTE\[1\].B.BIT\[5\].genblk1.STORAGE
+ DIBUF\[13\].X SLICE_16\[1\].RAM16.SLICE\[0\].RAM8.WORD\[2\].W.BYTE\[1\].B.GCLK VGND
+ VGND VPWR VPWR SLICE_16\[1\].RAM16.SLICE\[0\].RAM8.WORD\[2\].W.BYTE\[1\].B.Q_WIRE\[5\]
+ sky130_fd_sc_hd__dlxtp_1
Xtap_17_10 VGND VPWR sky130_fd_sc_hd__tapvpwrvgnd_1
XSLICE_16\[0\].RAM16.SLICE\[1\].RAM8.WORD\[6\].W.BYTE\[3\].B.BIT\[7\].genblk1.STORAGE
+ DIBUF\[31\].X SLICE_16\[0\].RAM16.SLICE\[1\].RAM8.WORD\[6\].W.BYTE\[3\].B.GCLK VGND
+ VGND VPWR VPWR SLICE_16\[0\].RAM16.SLICE\[1\].RAM8.WORD\[6\].W.BYTE\[3\].B.Q_WIRE\[7\]
+ sky130_fd_sc_hd__dlxtp_1
XSLICE_16\[0\].RAM16.SLICE\[1\].RAM8.WORD\[4\].W.BYTE\[2\].B.BIT\[0\].OBUF0 SLICE_16\[0\].RAM16.SLICE\[1\].RAM8.WORD\[4\].W.BYTE\[2\].B.Q_WIRE\[0\]
+ SLICE_16\[0\].RAM16.SLICE\[1\].RAM8.WORD\[4\].W.BYTE\[2\].B.SEL0_B VGND VGND VPWR
+ VPWR SLICE_16\[0\].RAM16.BYTE\[2\].FLOATBUF0\[16\].Z sky130_fd_sc_hd__ebufn_2
XDo0MUX.M\[1\].DIODE_A1MUX\[10\] Do0MUX.A1\[10\] VGND VGND VPWR VPWR sky130_fd_sc_hd__diode_2
XSLICE_16\[1\].RAM16.BYTE\[2\].FLOATBUF0\[21\].__cell__ SLICE_16\[1\].RAM16.BYTE\[2\].FLOATBUF0\[16\].A
+ SLICE_16\[1\].RAM16.BYTE\[2\].FLOATBUF0\[16\].TE_B VGND VGND VPWR VPWR SLICE_16\[1\].RAM16.BYTE\[2\].FLOATBUF0\[21\].Z
+ sky130_fd_sc_hd__ebufn_2
XSLICE_16\[1\].RAM16.SLICE\[1\].RAM8.WORD\[3\].W.BYTE\[3\].B.BIT\[7\].OBUF0 SLICE_16\[1\].RAM16.SLICE\[1\].RAM8.WORD\[3\].W.BYTE\[3\].B.Q_WIRE\[7\]
+ SLICE_16\[1\].RAM16.SLICE\[1\].RAM8.WORD\[3\].W.BYTE\[3\].B.SEL0_B VGND VGND VPWR
+ VPWR SLICE_16\[1\].RAM16.BYTE\[3\].FLOATBUF0\[31\].Z sky130_fd_sc_hd__ebufn_2
Xtap_33_31 VGND VPWR sky130_fd_sc_hd__tapvpwrvgnd_1
Xtap_33_20 VGND VPWR sky130_fd_sc_hd__tapvpwrvgnd_1
XSLICE_16\[0\].RAM16.SLICE\[1\].RAM8.WORD\[4\].W.BYTE\[1\].B.BIT\[6\].genblk1.STORAGE
+ DIBUF\[14\].X SLICE_16\[0\].RAM16.SLICE\[1\].RAM8.WORD\[4\].W.BYTE\[1\].B.GCLK VGND
+ VGND VPWR VPWR SLICE_16\[0\].RAM16.SLICE\[1\].RAM8.WORD\[4\].W.BYTE\[1\].B.Q_WIRE\[6\]
+ sky130_fd_sc_hd__dlxtp_1
Xfill_21_41 VGND VGND VPWR VPWR sky130_fd_sc_hd__decap_12
Xfill_21_30 VGND VPWR sky130_fd_sc_hd__tapvpwrvgnd_1
XSLICE_16\[0\].RAM16.SLICE\[0\].RAM8.WORD\[5\].W.BYTE\[3\].B.BIT\[2\].genblk1.STORAGE
+ DIBUF\[26\].X SLICE_16\[0\].RAM16.SLICE\[0\].RAM8.WORD\[5\].W.BYTE\[3\].B.GCLK VGND
+ VGND VPWR VPWR SLICE_16\[0\].RAM16.SLICE\[0\].RAM8.WORD\[5\].W.BYTE\[3\].B.Q_WIRE\[2\]
+ sky130_fd_sc_hd__dlxtp_1
Xfill_21_96 VGND VPWR sky130_fd_sc_hd__tapvpwrvgnd_1
Xfill_21_85 VGND VGND VPWR VPWR sky130_fd_sc_hd__decap_12
Xfill_21_74 VGND VGND VPWR VPWR sky130_fd_sc_hd__decap_12
Xfill_21_63 VGND VPWR sky130_fd_sc_hd__tapvpwrvgnd_1
Xfill_21_52 VGND VGND VPWR VPWR sky130_fd_sc_hd__decap_12
XSLICE_16\[0\].RAM16.SLICE\[0\].RAM8.WORD\[3\].W.BYTE\[1\].B.BIT\[1\].genblk1.STORAGE
+ DIBUF\[9\].X SLICE_16\[0\].RAM16.SLICE\[0\].RAM8.WORD\[3\].W.BYTE\[1\].B.GCLK VGND
+ VGND VPWR VPWR SLICE_16\[0\].RAM16.SLICE\[0\].RAM8.WORD\[3\].W.BYTE\[1\].B.Q_WIRE\[1\]
+ sky130_fd_sc_hd__dlxtp_1
Xfill_46_71 VGND VPWR sky130_fd_sc_hd__tapvpwrvgnd_1
Xfill_46_60 VGND VGND VPWR VPWR sky130_fd_sc_hd__decap_4
Xfill_46_93 VGND VPWR sky130_fd_sc_hd__tapvpwrvgnd_1
Xfill_46_82 VGND VGND VPWR VPWR sky130_fd_sc_hd__decap_12
XSLICE_16\[0\].RAM16.SLICE\[0\].RAM8.WORD\[0\].W.BYTE\[1\].B.BIT\[7\].OBUF0 SLICE_16\[0\].RAM16.SLICE\[0\].RAM8.WORD\[0\].W.BYTE\[1\].B.Q_WIRE\[7\]
+ SLICE_16\[0\].RAM16.SLICE\[0\].RAM8.WORD\[0\].W.BYTE\[1\].B.SEL0_B VGND VGND VPWR
+ VPWR SLICE_16\[0\].RAM16.BYTE\[1\].FLOATBUF0\[15\].Z sky130_fd_sc_hd__ebufn_2
XSLICE_16\[1\].RAM16.SLICE\[1\].RAM8.WORD\[2\].W.BYTE\[1\].B.BIT\[4\].OBUF0 SLICE_16\[1\].RAM16.SLICE\[1\].RAM8.WORD\[2\].W.BYTE\[1\].B.Q_WIRE\[4\]
+ SLICE_16\[1\].RAM16.SLICE\[1\].RAM8.WORD\[2\].W.BYTE\[1\].B.SEL0_B VGND VGND VPWR
+ VPWR SLICE_16\[1\].RAM16.BYTE\[1\].FLOATBUF0\[12\].Z sky130_fd_sc_hd__ebufn_2
XSLICE_16\[0\].RAM16.SLICE\[1\].RAM8.WORD\[7\].W.BYTE\[3\].B.BIT\[0\].OBUF0 SLICE_16\[0\].RAM16.SLICE\[1\].RAM8.WORD\[7\].W.BYTE\[3\].B.Q_WIRE\[0\]
+ SLICE_16\[0\].RAM16.SLICE\[1\].RAM8.WORD\[7\].W.BYTE\[3\].B.SEL0_B VGND VGND VPWR
+ VPWR SLICE_16\[0\].RAM16.BYTE\[3\].FLOATBUF0\[24\].Z sky130_fd_sc_hd__ebufn_2
Xtap_0_26 VGND VPWR sky130_fd_sc_hd__tapvpwrvgnd_1
Xtap_0_15 VGND VPWR sky130_fd_sc_hd__tapvpwrvgnd_1
XSLICE_16\[0\].RAM16.SLICE\[0\].RAM8.WORD\[3\].W.BYTE\[1\].B.CGAND SLICE_16\[0\].RAM16.SLICE\[0\].RAM8.WORD\[3\].W.BYTE\[0\].B.SEL0
+ SLICE_16\[0\].RAM16.SLICE\[0\].RAM8.WE0_buf\[1\] VGND VGND VPWR VPWR SLICE_16\[0\].RAM16.SLICE\[0\].RAM8.WORD\[3\].W.BYTE\[1\].B.WE0_WIRE
+ sky130_fd_sc_hd__and2_1
Xtap_9_13 VGND VPWR sky130_fd_sc_hd__tapvpwrvgnd_1
Xtap_9_24 VGND VPWR sky130_fd_sc_hd__tapvpwrvgnd_1
Xtap_9_35 VGND VPWR sky130_fd_sc_hd__tapvpwrvgnd_1
Xfill_42_29 VGND VGND VPWR VPWR sky130_fd_sc_hd__decap_12
Xfill_42_18 VGND VPWR sky130_fd_sc_hd__tapvpwrvgnd_1
XSLICE_16\[1\].RAM16.SLICE\[1\].RAM8.WORD\[2\].W.BYTE\[3\].B.BIT\[0\].genblk1.STORAGE
+ DIBUF\[24\].X SLICE_16\[1\].RAM16.SLICE\[1\].RAM8.WORD\[2\].W.BYTE\[3\].B.GCLK VGND
+ VGND VPWR VPWR SLICE_16\[1\].RAM16.SLICE\[1\].RAM8.WORD\[2\].W.BYTE\[3\].B.Q_WIRE\[0\]
+ sky130_fd_sc_hd__dlxtp_1
XSLICE_16\[0\].RAM16.SLICE\[1\].RAM8.WORD\[4\].W.BYTE\[0\].B.BIT\[5\].OBUF0 SLICE_16\[0\].RAM16.SLICE\[1\].RAM8.WORD\[4\].W.BYTE\[0\].B.Q_WIRE\[5\]
+ SLICE_16\[0\].RAM16.SLICE\[1\].RAM8.WORD\[4\].W.BYTE\[0\].B.SEL0_B VGND VGND VPWR
+ VPWR SLICE_16\[0\].RAM16.BYTE\[0\].FLOATBUF0\[5\].Z sky130_fd_sc_hd__ebufn_2
Xtap_36_3 VGND VPWR sky130_fd_sc_hd__tapvpwrvgnd_1
Xtap_29_2 VGND VPWR sky130_fd_sc_hd__tapvpwrvgnd_1
Xtap_28_31 VGND VPWR sky130_fd_sc_hd__tapvpwrvgnd_1
Xtap_28_20 VGND VPWR sky130_fd_sc_hd__tapvpwrvgnd_1
XSLICE_16\[1\].RAM16.SLICE\[0\].RAM8.WORD\[1\].W.BYTE\[3\].B.BIT\[6\].OBUF0 SLICE_16\[1\].RAM16.SLICE\[0\].RAM8.WORD\[1\].W.BYTE\[3\].B.Q_WIRE\[6\]
+ SLICE_16\[1\].RAM16.SLICE\[0\].RAM8.WORD\[1\].W.BYTE\[3\].B.SEL0_B VGND VGND VPWR
+ VPWR SLICE_16\[1\].RAM16.BYTE\[3\].FLOATBUF0\[30\].Z sky130_fd_sc_hd__ebufn_2
XSLICE_16\[0\].RAM16.SLICE\[0\].RAM8.WORD\[3\].W.BYTE\[2\].B.BIT\[7\].OBUF0 SLICE_16\[0\].RAM16.SLICE\[0\].RAM8.WORD\[3\].W.BYTE\[2\].B.Q_WIRE\[7\]
+ SLICE_16\[0\].RAM16.SLICE\[0\].RAM8.WORD\[3\].W.BYTE\[2\].B.SEL0_B VGND VGND VPWR
+ VPWR SLICE_16\[0\].RAM16.BYTE\[2\].FLOATBUF0\[23\].Z sky130_fd_sc_hd__ebufn_2
XSLICE_16\[1\].RAM16.SLICE\[1\].RAM8.WORD\[5\].W.BYTE\[2\].B.BIT\[4\].OBUF0 SLICE_16\[1\].RAM16.SLICE\[1\].RAM8.WORD\[5\].W.BYTE\[2\].B.Q_WIRE\[4\]
+ SLICE_16\[1\].RAM16.SLICE\[1\].RAM8.WORD\[5\].W.BYTE\[2\].B.SEL0_B VGND VGND VPWR
+ VPWR SLICE_16\[1\].RAM16.BYTE\[2\].FLOATBUF0\[20\].Z sky130_fd_sc_hd__ebufn_2
XSLICE_16\[1\].RAM16.SLICE\[0\].RAM8.WORD\[5\].W.BYTE\[2\].B.BIT\[5\].genblk1.STORAGE
+ DIBUF\[21\].X SLICE_16\[1\].RAM16.SLICE\[0\].RAM8.WORD\[5\].W.BYTE\[2\].B.GCLK VGND
+ VGND VPWR VPWR SLICE_16\[1\].RAM16.SLICE\[0\].RAM8.WORD\[5\].W.BYTE\[2\].B.Q_WIRE\[5\]
+ sky130_fd_sc_hd__dlxtp_1
XSLICE_16\[1\].RAM16.SLICE\[0\].RAM8.WORD\[3\].W.BYTE\[0\].B.BIT\[4\].genblk1.STORAGE
+ DIBUF\[4\].X SLICE_16\[1\].RAM16.SLICE\[0\].RAM8.WORD\[3\].W.BYTE\[0\].B.GCLK VGND
+ VGND VPWR VPWR SLICE_16\[1\].RAM16.SLICE\[0\].RAM8.WORD\[3\].W.BYTE\[0\].B.Q_WIRE\[4\]
+ sky130_fd_sc_hd__dlxtp_1
XSLICE_16\[0\].RAM16.SLICE\[1\].RAM8.WORD\[7\].W.BYTE\[2\].B.BIT\[6\].genblk1.STORAGE
+ DIBUF\[22\].X SLICE_16\[0\].RAM16.SLICE\[1\].RAM8.WORD\[7\].W.BYTE\[2\].B.GCLK VGND
+ VGND VPWR VPWR SLICE_16\[0\].RAM16.SLICE\[1\].RAM8.WORD\[7\].W.BYTE\[2\].B.Q_WIRE\[6\]
+ sky130_fd_sc_hd__dlxtp_1
XSLICE_16\[0\].RAM16.SLICE\[1\].RAM8.WORD\[1\].W.BYTE\[3\].B.BIT\[7\].genblk1.STORAGE
+ DIBUF\[31\].X SLICE_16\[0\].RAM16.SLICE\[1\].RAM8.WORD\[1\].W.BYTE\[3\].B.GCLK VGND
+ VGND VPWR VPWR SLICE_16\[0\].RAM16.SLICE\[1\].RAM8.WORD\[1\].W.BYTE\[3\].B.Q_WIRE\[7\]
+ sky130_fd_sc_hd__dlxtp_1
XSLICE_16\[1\].RAM16.SLICE\[0\].RAM8.WORD\[0\].W.BYTE\[1\].B.BIT\[3\].OBUF0 SLICE_16\[1\].RAM16.SLICE\[0\].RAM8.WORD\[0\].W.BYTE\[1\].B.Q_WIRE\[3\]
+ SLICE_16\[1\].RAM16.SLICE\[0\].RAM8.WORD\[0\].W.BYTE\[1\].B.SEL0_B VGND VGND VPWR
+ VPWR SLICE_16\[1\].RAM16.BYTE\[1\].FLOATBUF0\[11\].Z sky130_fd_sc_hd__ebufn_2
XSLICE_16\[0\].RAM16.SLICE\[1\].RAM8.WORD\[7\].W.BYTE\[1\].B.BIT\[5\].OBUF0 SLICE_16\[0\].RAM16.SLICE\[1\].RAM8.WORD\[7\].W.BYTE\[1\].B.Q_WIRE\[5\]
+ SLICE_16\[0\].RAM16.SLICE\[1\].RAM8.WORD\[7\].W.BYTE\[1\].B.SEL0_B VGND VGND VPWR
+ VPWR SLICE_16\[0\].RAM16.BYTE\[1\].FLOATBUF0\[13\].Z sky130_fd_sc_hd__ebufn_2
XSLICE_16\[0\].RAM16.SLICE\[1\].RAM8.WORD\[5\].W.BYTE\[0\].B.BIT\[5\].genblk1.STORAGE
+ DIBUF\[5\].X SLICE_16\[0\].RAM16.SLICE\[1\].RAM8.WORD\[5\].W.BYTE\[0\].B.GCLK VGND
+ VGND VPWR VPWR SLICE_16\[0\].RAM16.SLICE\[1\].RAM8.WORD\[5\].W.BYTE\[0\].B.Q_WIRE\[5\]
+ sky130_fd_sc_hd__dlxtp_1
Xfill_5_5 VGND VPWR sky130_fd_sc_hd__tapvpwrvgnd_1
XSLICE_16\[0\].RAM16.SLICE\[0\].RAM8.WORD\[0\].W.BYTE\[3\].B.BIT\[2\].genblk1.STORAGE
+ DIBUF\[26\].X SLICE_16\[0\].RAM16.SLICE\[0\].RAM8.WORD\[0\].W.BYTE\[3\].B.GCLK VGND
+ VGND VPWR VPWR SLICE_16\[0\].RAM16.SLICE\[0\].RAM8.WORD\[0\].W.BYTE\[3\].B.Q_WIRE\[2\]
+ sky130_fd_sc_hd__dlxtp_1
XDIBUF\[12\].__cell__ Di0[12] VGND VGND VPWR VPWR DIBUF\[12\].X sky130_fd_sc_hd__clkbuf_16
XSLICE_16\[0\].RAM16.SLICE\[0\].RAM8.WORD\[4\].W.BYTE\[0\].B.BIT\[0\].genblk1.STORAGE
+ DIBUF\[0\].X SLICE_16\[0\].RAM16.SLICE\[0\].RAM8.WORD\[4\].W.BYTE\[0\].B.GCLK VGND
+ VGND VPWR VPWR SLICE_16\[0\].RAM16.SLICE\[0\].RAM8.WORD\[4\].W.BYTE\[0\].B.Q_WIRE\[0\]
+ sky130_fd_sc_hd__dlxtp_1
XSLICE_16\[0\].RAM16.SLICE\[0\].RAM8.WORD\[6\].W.BYTE\[2\].B.BIT\[1\].genblk1.STORAGE
+ DIBUF\[17\].X SLICE_16\[0\].RAM16.SLICE\[0\].RAM8.WORD\[6\].W.BYTE\[2\].B.GCLK VGND
+ VGND VPWR VPWR SLICE_16\[0\].RAM16.SLICE\[0\].RAM8.WORD\[6\].W.BYTE\[2\].B.Q_WIRE\[1\]
+ sky130_fd_sc_hd__dlxtp_1
XSLICE_16\[1\].RAM16.SLICE\[0\].RAM8.WORD\[4\].W.BYTE\[2\].B.SEL0INV SLICE_16\[1\].RAM16.SLICE\[0\].RAM8.WORD\[4\].W.BYTE\[0\].B.SEL0
+ VGND VGND VPWR VPWR SLICE_16\[1\].RAM16.SLICE\[0\].RAM8.WORD\[4\].W.BYTE\[2\].B.SEL0_B
+ sky130_fd_sc_hd__inv_1
Xtap_15_8 VGND VPWR sky130_fd_sc_hd__tapvpwrvgnd_1
XSLICE_16\[0\].RAM16.SLICE\[0\].RAM8.WORD\[2\].W.BYTE\[0\].B.BIT\[4\].OBUF0 SLICE_16\[0\].RAM16.SLICE\[0\].RAM8.WORD\[2\].W.BYTE\[0\].B.Q_WIRE\[4\]
+ SLICE_16\[0\].RAM16.SLICE\[0\].RAM8.WORD\[2\].W.BYTE\[0\].B.SEL0_B VGND VGND VPWR
+ VPWR SLICE_16\[0\].RAM16.BYTE\[0\].FLOATBUF0\[4\].Z sky130_fd_sc_hd__ebufn_2
Xtap_8_7 VGND VPWR sky130_fd_sc_hd__tapvpwrvgnd_1
XSLICE_16\[0\].RAM16.SLICE\[1\].RAM8.WORD\[0\].W.BYTE\[1\].B.genblk1.CG SLICE_16\[0\].RAM16.SLICE\[1\].RAM8.WORD\[0\].W.BYTE\[1\].B.CLK_B
+ SLICE_16\[0\].RAM16.SLICE\[1\].RAM8.WORD\[0\].W.BYTE\[1\].B.WE0_WIRE VGND VGND VPWR
+ VPWR SLICE_16\[0\].RAM16.SLICE\[1\].RAM8.WORD\[0\].W.BYTE\[1\].B.GCLK sky130_fd_sc_hd__dlclkp_1
XSLICE_16\[1\].RAM16.SLICE\[1\].RAM8.WORD\[4\].W.BYTE\[0\].B.BIT\[1\].OBUF0 SLICE_16\[1\].RAM16.SLICE\[1\].RAM8.WORD\[4\].W.BYTE\[0\].B.Q_WIRE\[1\]
+ SLICE_16\[1\].RAM16.SLICE\[1\].RAM8.WORD\[4\].W.BYTE\[0\].B.SEL0_B VGND VGND VPWR
+ VPWR SLICE_16\[1\].RAM16.BYTE\[0\].FLOATBUF0\[1\].Z sky130_fd_sc_hd__ebufn_2
XSLICE_16\[1\].RAM16.SLICE\[0\].RAM8.WORD\[0\].W.SEL0BUF SLICE_16\[1\].RAM16.SLICE\[0\].RAM8.DEC0.SEL\[0\]
+ VGND VGND VPWR VPWR SLICE_16\[1\].RAM16.SLICE\[0\].RAM8.WORD\[0\].W.BYTE\[0\].B.SEL0
+ sky130_fd_sc_hd__clkbuf_2
Xtap_14_33 VGND VPWR sky130_fd_sc_hd__tapvpwrvgnd_1
Xtap_14_22 VGND VPWR sky130_fd_sc_hd__tapvpwrvgnd_1
Xtap_14_11 VGND VPWR sky130_fd_sc_hd__tapvpwrvgnd_1
XSLICE_16\[0\].RAM16.SLICE\[0\].RAM8.WORD\[6\].W.BYTE\[3\].B.BIT\[7\].OBUF0 SLICE_16\[0\].RAM16.SLICE\[0\].RAM8.WORD\[6\].W.BYTE\[3\].B.Q_WIRE\[7\]
+ SLICE_16\[0\].RAM16.SLICE\[0\].RAM8.WORD\[6\].W.BYTE\[3\].B.SEL0_B VGND VGND VPWR
+ VPWR SLICE_16\[0\].RAM16.BYTE\[3\].FLOATBUF0\[31\].Z sky130_fd_sc_hd__ebufn_2
Xtap_30_32 VGND VPWR sky130_fd_sc_hd__tapvpwrvgnd_1
Xtap_30_21 VGND VPWR sky130_fd_sc_hd__tapvpwrvgnd_1
Xtap_30_10 VGND VPWR sky130_fd_sc_hd__tapvpwrvgnd_1
XSLICE_16\[0\].RAM16.SLICE\[1\].RAM8.WORD\[4\].W.BYTE\[0\].B.CGAND SLICE_16\[0\].RAM16.SLICE\[1\].RAM8.WORD\[4\].W.BYTE\[0\].B.SEL0
+ SLICE_16\[0\].RAM16.SLICE\[1\].RAM8.WE0_buf\[0\] VGND VGND VPWR VPWR SLICE_16\[0\].RAM16.SLICE\[1\].RAM8.WORD\[4\].W.BYTE\[0\].B.WE0_WIRE
+ sky130_fd_sc_hd__and2_1
Xtap_34_0 VGND VPWR sky130_fd_sc_hd__tapvpwrvgnd_1
Xfill_46_119 VGND VGND VPWR VPWR sky130_fd_sc_hd__decap_12
Xfill_46_108 VGND VPWR sky130_fd_sc_hd__tapvpwrvgnd_1
XSLICE_16\[1\].RAM16.SLICE\[0\].RAM8.WORD\[3\].W.BYTE\[2\].B.BIT\[3\].OBUF0 SLICE_16\[1\].RAM16.SLICE\[0\].RAM8.WORD\[3\].W.BYTE\[2\].B.Q_WIRE\[3\]
+ SLICE_16\[1\].RAM16.SLICE\[0\].RAM8.WORD\[3\].W.BYTE\[2\].B.SEL0_B VGND VGND VPWR
+ VPWR SLICE_16\[1\].RAM16.BYTE\[2\].FLOATBUF0\[19\].Z sky130_fd_sc_hd__ebufn_2
Xfill_43_94 VGND VGND VPWR VPWR sky130_fd_sc_hd__decap_12
Xfill_43_83 VGND VGND VPWR VPWR sky130_fd_sc_hd__decap_12
Xfill_43_72 VGND VPWR sky130_fd_sc_hd__tapvpwrvgnd_1
Xfill_43_61 VGND VGND VPWR VPWR sky130_fd_sc_hd__decap_12
Xfill_43_50 VGND VGND VPWR VPWR sky130_fd_sc_hd__decap_12
XSLICE_16\[0\].RAM16.SLICE\[0\].RAM8.WORD\[2\].W.BYTE\[3\].B.SEL0INV SLICE_16\[0\].RAM16.SLICE\[0\].RAM8.WORD\[2\].W.BYTE\[0\].B.SEL0
+ VGND VGND VPWR VPWR SLICE_16\[0\].RAM16.SLICE\[0\].RAM8.WORD\[2\].W.BYTE\[3\].B.SEL0_B
+ sky130_fd_sc_hd__inv_1
XSLICE_16\[0\].RAM16.SLICE\[0\].RAM8.WORD\[7\].W.BYTE\[0\].B.genblk1.CG SLICE_16\[0\].RAM16.SLICE\[0\].RAM8.WORD\[7\].W.BYTE\[0\].B.CLK_B
+ SLICE_16\[0\].RAM16.SLICE\[0\].RAM8.WORD\[7\].W.BYTE\[0\].B.WE0_WIRE VGND VGND VPWR
+ VPWR SLICE_16\[0\].RAM16.SLICE\[0\].RAM8.WORD\[7\].W.BYTE\[0\].B.GCLK sky130_fd_sc_hd__dlclkp_1
XSLICE_16\[1\].RAM16.Do0_REG.OUTREG_BYTE\[2\].DIODE\[6\] SLICE_16\[1\].RAM16.BYTE\[2\].FLOATBUF0\[22\].Z
+ VGND VGND VPWR VPWR sky130_fd_sc_hd__diode_2
XSLICE_16\[0\].RAM16.SLICE\[0\].RAM8.WORD\[5\].W.BYTE\[1\].B.BIT\[4\].OBUF0 SLICE_16\[0\].RAM16.SLICE\[0\].RAM8.WORD\[5\].W.BYTE\[1\].B.Q_WIRE\[4\]
+ SLICE_16\[0\].RAM16.SLICE\[0\].RAM8.WORD\[5\].W.BYTE\[1\].B.SEL0_B VGND VGND VPWR
+ VPWR SLICE_16\[0\].RAM16.BYTE\[1\].FLOATBUF0\[12\].Z sky130_fd_sc_hd__ebufn_2
XSLICE_16\[1\].RAM16.SLICE\[1\].RAM8.WORD\[7\].W.BYTE\[1\].B.BIT\[1\].OBUF0 SLICE_16\[1\].RAM16.SLICE\[1\].RAM8.WORD\[7\].W.BYTE\[1\].B.Q_WIRE\[1\]
+ SLICE_16\[1\].RAM16.SLICE\[1\].RAM8.WORD\[7\].W.BYTE\[1\].B.SEL0_B VGND VGND VPWR
+ VPWR SLICE_16\[1\].RAM16.BYTE\[1\].FLOATBUF0\[9\].Z sky130_fd_sc_hd__ebufn_2
Xfill_3_2 VGND VPWR sky130_fd_sc_hd__tapvpwrvgnd_1
XSLICE_16\[1\].RAM16.SLICE\[0\].RAM8.WORD\[6\].W.BYTE\[1\].B.BIT\[4\].genblk1.STORAGE
+ DIBUF\[12\].X SLICE_16\[1\].RAM16.SLICE\[0\].RAM8.WORD\[6\].W.BYTE\[1\].B.GCLK VGND
+ VGND VPWR VPWR SLICE_16\[1\].RAM16.SLICE\[0\].RAM8.WORD\[6\].W.BYTE\[1\].B.Q_WIRE\[4\]
+ sky130_fd_sc_hd__dlxtp_1
XSLICE_16\[1\].RAM16.SLICE\[0\].RAM8.WORD\[0\].W.BYTE\[2\].B.BIT\[5\].genblk1.STORAGE
+ DIBUF\[21\].X SLICE_16\[1\].RAM16.SLICE\[0\].RAM8.WORD\[0\].W.BYTE\[2\].B.GCLK VGND
+ VGND VPWR VPWR SLICE_16\[1\].RAM16.SLICE\[0\].RAM8.WORD\[0\].W.BYTE\[2\].B.Q_WIRE\[5\]
+ sky130_fd_sc_hd__dlxtp_1
Xtap_6_14 VGND VPWR sky130_fd_sc_hd__tapvpwrvgnd_1
Xtap_6_25 VGND VPWR sky130_fd_sc_hd__tapvpwrvgnd_1
XSLICE_16\[1\].RAM16.Do0_REG.Do_CLKBUF\[3\] SLICE_16\[1\].RAM16.Do0_REG.CLK_buf VGND
+ VGND VPWR VPWR SLICE_16\[1\].RAM16.Do0_REG.CLKBUF\[3\] sky130_fd_sc_hd__clkbuf_4
XSLICE_16\[1\].RAM16.SLICE\[0\].RAM8.WORD\[2\].W.BYTE\[0\].B.BIT\[0\].OBUF0 SLICE_16\[1\].RAM16.SLICE\[0\].RAM8.WORD\[2\].W.BYTE\[0\].B.Q_WIRE\[0\]
+ SLICE_16\[1\].RAM16.SLICE\[0\].RAM8.WORD\[2\].W.BYTE\[0\].B.SEL0_B VGND VGND VPWR
+ VPWR SLICE_16\[1\].RAM16.BYTE\[0\].FLOATBUF0\[0\].Z sky130_fd_sc_hd__ebufn_2
Xtap_13_5 VGND VPWR sky130_fd_sc_hd__tapvpwrvgnd_1
XSLICE_16\[0\].RAM16.SLICE\[1\].RAM8.WORD\[2\].W.BYTE\[2\].B.BIT\[6\].genblk1.STORAGE
+ DIBUF\[22\].X SLICE_16\[0\].RAM16.SLICE\[1\].RAM8.WORD\[2\].W.BYTE\[2\].B.GCLK VGND
+ VGND VPWR VPWR SLICE_16\[0\].RAM16.SLICE\[1\].RAM8.WORD\[2\].W.BYTE\[2\].B.Q_WIRE\[6\]
+ sky130_fd_sc_hd__dlxtp_1
XSLICE_16\[1\].RAM16.SLICE\[0\].RAM8.WORD\[7\].W.BYTE\[0\].B.genblk1.CLKINV SLICE_16\[1\].RAM16.SLICE\[0\].RAM8.WORD\[7\].W.BYTE\[0\].B.CLK
+ VGND VGND VPWR VPWR SLICE_16\[1\].RAM16.SLICE\[0\].RAM8.WORD\[7\].W.BYTE\[0\].B.CLK_B
+ sky130_fd_sc_hd__inv_1
XSLICE_16\[1\].RAM16.SLICE\[0\].RAM8.WORD\[6\].W.BYTE\[3\].B.BIT\[3\].OBUF0 SLICE_16\[1\].RAM16.SLICE\[0\].RAM8.WORD\[6\].W.BYTE\[3\].B.Q_WIRE\[3\]
+ SLICE_16\[1\].RAM16.SLICE\[0\].RAM8.WORD\[6\].W.BYTE\[3\].B.SEL0_B VGND VGND VPWR
+ VPWR SLICE_16\[1\].RAM16.BYTE\[3\].FLOATBUF0\[27\].Z sky130_fd_sc_hd__ebufn_2
Xtap_25_32 VGND VPWR sky130_fd_sc_hd__tapvpwrvgnd_1
Xtap_25_21 VGND VPWR sky130_fd_sc_hd__tapvpwrvgnd_1
Xtap_25_10 VGND VPWR sky130_fd_sc_hd__tapvpwrvgnd_1
XSLICE_16\[0\].RAM16.SLICE\[0\].RAM8.WORD\[1\].W.BYTE\[2\].B.BIT\[1\].genblk1.STORAGE
+ DIBUF\[17\].X SLICE_16\[0\].RAM16.SLICE\[0\].RAM8.WORD\[1\].W.BYTE\[2\].B.GCLK VGND
+ VGND VPWR VPWR SLICE_16\[0\].RAM16.SLICE\[0\].RAM8.WORD\[1\].W.BYTE\[2\].B.Q_WIRE\[1\]
+ sky130_fd_sc_hd__dlxtp_1
Xtap_6_4 VGND VPWR sky130_fd_sc_hd__tapvpwrvgnd_1
XSLICE_16\[0\].RAM16.SLICE\[0\].RAM8.WORD\[7\].W.BYTE\[1\].B.BIT\[0\].genblk1.STORAGE
+ DIBUF\[8\].X SLICE_16\[0\].RAM16.SLICE\[0\].RAM8.WORD\[7\].W.BYTE\[1\].B.GCLK VGND
+ VGND VPWR VPWR SLICE_16\[0\].RAM16.SLICE\[0\].RAM8.WORD\[7\].W.BYTE\[1\].B.Q_WIRE\[0\]
+ sky130_fd_sc_hd__dlxtp_1
XSLICE_16\[0\].RAM16.SLICE\[1\].RAM8.WORD\[0\].W.BYTE\[0\].B.BIT\[5\].genblk1.STORAGE
+ DIBUF\[5\].X SLICE_16\[0\].RAM16.SLICE\[1\].RAM8.WORD\[0\].W.BYTE\[0\].B.GCLK VGND
+ VGND VPWR VPWR SLICE_16\[0\].RAM16.SLICE\[1\].RAM8.WORD\[0\].W.BYTE\[0\].B.Q_WIRE\[5\]
+ sky130_fd_sc_hd__dlxtp_1
XSLICE_16\[1\].RAM16.SLICE\[0\].RAM8.WORD\[2\].W.BYTE\[1\].B.DIODE_CLK SLICE_16\[1\].RAM16.SLICE\[0\].RAM8.WORD\[2\].W.BYTE\[0\].B.CLK
+ VGND VGND VPWR VPWR sky130_fd_sc_hd__diode_2
XSLICE_16\[0\].RAM16.SLICE\[1\].RAM8.WORD\[0\].W.BYTE\[2\].B.BIT\[7\].OBUF0 SLICE_16\[0\].RAM16.SLICE\[1\].RAM8.WORD\[0\].W.BYTE\[2\].B.Q_WIRE\[7\]
+ SLICE_16\[0\].RAM16.SLICE\[1\].RAM8.WORD\[0\].W.BYTE\[2\].B.SEL0_B VGND VGND VPWR
+ VPWR SLICE_16\[0\].RAM16.BYTE\[2\].FLOATBUF0\[23\].Z sky130_fd_sc_hd__ebufn_2
Xfill_41_9 VGND VPWR sky130_fd_sc_hd__tapvpwrvgnd_1
Xfill_42_100 VGND VGND VPWR VPWR sky130_fd_sc_hd__decap_12
XSLICE_16\[1\].RAM16.Do0_REG.OUTREG_BYTE\[1\].Do_FF\[7\] SLICE_16\[1\].RAM16.Do0_REG.CLKBUF\[1\]
+ SLICE_16\[1\].RAM16.BYTE\[1\].FLOATBUF0\[15\].Z VGND VGND VPWR VPWR Do0MUX.A1\[15\]
+ sky130_fd_sc_hd__dfxtp_1
XSLICE_16\[1\].RAM16.A0BUF\[3\].__cell__ A0BUF\[3\].X VGND VGND VPWR VPWR SLICE_16\[1\].RAM16.A0BUF\[3\].X
+ sky130_fd_sc_hd__clkbuf_2
XSLICE_16\[1\].RAM16.SLICE\[0\].RAM8.WORD\[5\].W.BYTE\[1\].B.BIT\[0\].OBUF0 SLICE_16\[1\].RAM16.SLICE\[0\].RAM8.WORD\[5\].W.BYTE\[1\].B.Q_WIRE\[0\]
+ SLICE_16\[1\].RAM16.SLICE\[0\].RAM8.WORD\[5\].W.BYTE\[1\].B.SEL0_B VGND VGND VPWR
+ VPWR SLICE_16\[1\].RAM16.BYTE\[1\].FLOATBUF0\[8\].Z sky130_fd_sc_hd__ebufn_2
XSLICE_16\[0\].RAM16.SLICE\[0\].RAM8.WORD\[5\].W.BYTE\[0\].B.DIODE_CLK SLICE_16\[0\].RAM16.SLICE\[0\].RAM8.WORD\[5\].W.BYTE\[0\].B.CLK
+ VGND VGND VPWR VPWR sky130_fd_sc_hd__diode_2
XSLICE_16\[0\].RAM16.SLICE\[0\].RAM8.WORD\[7\].W.BYTE\[0\].B.BIT\[1\].OBUF0 SLICE_16\[0\].RAM16.SLICE\[0\].RAM8.WORD\[7\].W.BYTE\[0\].B.Q_WIRE\[1\]
+ SLICE_16\[0\].RAM16.SLICE\[0\].RAM8.WORD\[7\].W.BYTE\[0\].B.SEL0_B VGND VGND VPWR
+ VPWR SLICE_16\[0\].RAM16.BYTE\[0\].FLOATBUF0\[1\].Z sky130_fd_sc_hd__ebufn_2
Xtap_11_12 VGND VPWR sky130_fd_sc_hd__tapvpwrvgnd_1
Xtap_11_23 VGND VPWR sky130_fd_sc_hd__tapvpwrvgnd_1
Xtap_11_34 VGND VPWR sky130_fd_sc_hd__tapvpwrvgnd_1
XSLICE_16\[0\].RAM16.Do0_REG.OUTREG_BYTE\[3\].Do_FF\[4\] SLICE_16\[0\].RAM16.Do0_REG.CLKBUF\[3\]
+ SLICE_16\[0\].RAM16.BYTE\[3\].FLOATBUF0\[28\].Z VGND VGND VPWR VPWR Do0MUX.A0\[28\]
+ sky130_fd_sc_hd__dfxtp_1
XSLICE_16\[0\].RAM16.SLICE\[1\].RAM8.WORD\[3\].W.BYTE\[3\].B.BIT\[7\].OBUF0 SLICE_16\[0\].RAM16.SLICE\[1\].RAM8.WORD\[3\].W.BYTE\[3\].B.Q_WIRE\[7\]
+ SLICE_16\[0\].RAM16.SLICE\[1\].RAM8.WORD\[3\].W.BYTE\[3\].B.SEL0_B VGND VGND VPWR
+ VPWR SLICE_16\[0\].RAM16.BYTE\[3\].FLOATBUF0\[31\].Z sky130_fd_sc_hd__ebufn_2
Xtap_36_31 VGND VPWR sky130_fd_sc_hd__tapvpwrvgnd_1
Xtap_36_20 VGND VPWR sky130_fd_sc_hd__tapvpwrvgnd_1
Xtap_11_2 VGND VPWR sky130_fd_sc_hd__tapvpwrvgnd_1
XSLICE_16\[1\].RAM16.SLICE\[0\].RAM8.WORD\[7\].W.BYTE\[0\].B.BIT\[3\].genblk1.STORAGE
+ DIBUF\[3\].X SLICE_16\[1\].RAM16.SLICE\[0\].RAM8.WORD\[7\].W.BYTE\[0\].B.GCLK VGND
+ VGND VPWR VPWR SLICE_16\[1\].RAM16.SLICE\[0\].RAM8.WORD\[7\].W.BYTE\[0\].B.Q_WIRE\[3\]
+ sky130_fd_sc_hd__dlxtp_1
XSLICE_16\[1\].RAM16.SLICE\[0\].RAM8.WORD\[3\].W.BYTE\[3\].B.BIT\[5\].genblk1.STORAGE
+ DIBUF\[29\].X SLICE_16\[1\].RAM16.SLICE\[0\].RAM8.WORD\[3\].W.BYTE\[3\].B.GCLK VGND
+ VGND VPWR VPWR SLICE_16\[1\].RAM16.SLICE\[0\].RAM8.WORD\[3\].W.BYTE\[3\].B.Q_WIRE\[5\]
+ sky130_fd_sc_hd__dlxtp_1
Xtap_4_1 VGND VPWR sky130_fd_sc_hd__tapvpwrvgnd_1
XSLICE_16\[1\].RAM16.SLICE\[0\].RAM8.WORD\[1\].W.BYTE\[1\].B.BIT\[4\].genblk1.STORAGE
+ DIBUF\[12\].X SLICE_16\[1\].RAM16.SLICE\[0\].RAM8.WORD\[1\].W.BYTE\[1\].B.GCLK VGND
+ VGND VPWR VPWR SLICE_16\[1\].RAM16.SLICE\[0\].RAM8.WORD\[1\].W.BYTE\[1\].B.Q_WIRE\[4\]
+ sky130_fd_sc_hd__dlxtp_1
XSLICE_16\[0\].RAM16.SLICE\[1\].RAM8.WORD\[5\].W.BYTE\[3\].B.BIT\[6\].genblk1.STORAGE
+ DIBUF\[30\].X SLICE_16\[0\].RAM16.SLICE\[1\].RAM8.WORD\[5\].W.BYTE\[3\].B.GCLK VGND
+ VGND VPWR VPWR SLICE_16\[0\].RAM16.SLICE\[1\].RAM8.WORD\[5\].W.BYTE\[3\].B.Q_WIRE\[6\]
+ sky130_fd_sc_hd__dlxtp_1
XSLICE_16\[1\].RAM16.SLICE\[1\].RAM8.WORD\[0\].W.BYTE\[2\].B.BIT\[3\].OBUF0 SLICE_16\[1\].RAM16.SLICE\[1\].RAM8.WORD\[0\].W.BYTE\[2\].B.Q_WIRE\[3\]
+ SLICE_16\[1\].RAM16.SLICE\[1\].RAM8.WORD\[0\].W.BYTE\[2\].B.SEL0_B VGND VGND VPWR
+ VPWR SLICE_16\[1\].RAM16.BYTE\[2\].FLOATBUF0\[19\].Z sky130_fd_sc_hd__ebufn_2
XSLICE_16\[0\].RAM16.BYTE\[0\].FLOATBUF0\[3\].__cell__ SLICE_16\[0\].RAM16.BYTE\[0\].FLOATBUF0\[0\].A
+ SLICE_16\[0\].RAM16.BYTE\[0\].FLOATBUF0\[0\].TE_B VGND VGND VPWR VPWR SLICE_16\[0\].RAM16.BYTE\[0\].FLOATBUF0\[3\].Z
+ sky130_fd_sc_hd__ebufn_2
XSLICE_16\[0\].RAM16.SLICE\[1\].RAM8.WORD\[3\].W.BYTE\[1\].B.BIT\[5\].genblk1.STORAGE
+ DIBUF\[13\].X SLICE_16\[0\].RAM16.SLICE\[1\].RAM8.WORD\[3\].W.BYTE\[1\].B.GCLK VGND
+ VGND VPWR VPWR SLICE_16\[0\].RAM16.SLICE\[1\].RAM8.WORD\[3\].W.BYTE\[1\].B.Q_WIRE\[5\]
+ sky130_fd_sc_hd__dlxtp_1
XSLICE_16\[0\].RAM16.SLICE\[0\].RAM8.WORD\[4\].W.BYTE\[3\].B.BIT\[1\].genblk1.STORAGE
+ DIBUF\[25\].X SLICE_16\[0\].RAM16.SLICE\[0\].RAM8.WORD\[4\].W.BYTE\[3\].B.GCLK VGND
+ VGND VPWR VPWR SLICE_16\[0\].RAM16.SLICE\[0\].RAM8.WORD\[4\].W.BYTE\[3\].B.Q_WIRE\[1\]
+ sky130_fd_sc_hd__dlxtp_1
Xfill_32_5 VGND VPWR sky130_fd_sc_hd__tapvpwrvgnd_1
Xfill_25_4 VGND VPWR sky130_fd_sc_hd__tapvpwrvgnd_1
XSLICE_16\[1\].RAM16.SLICE\[0\].RAM8.WORD\[0\].W.BYTE\[3\].B.SEL0INV SLICE_16\[1\].RAM16.SLICE\[0\].RAM8.WORD\[0\].W.BYTE\[0\].B.SEL0
+ VGND VGND VPWR VPWR SLICE_16\[1\].RAM16.SLICE\[0\].RAM8.WORD\[0\].W.BYTE\[3\].B.SEL0_B
+ sky130_fd_sc_hd__inv_1
XSLICE_16\[0\].RAM16.SLICE\[0\].RAM8.WORD\[2\].W.BYTE\[1\].B.BIT\[0\].genblk1.STORAGE
+ DIBUF\[8\].X SLICE_16\[0\].RAM16.SLICE\[0\].RAM8.WORD\[2\].W.BYTE\[1\].B.GCLK VGND
+ VGND VPWR VPWR SLICE_16\[0\].RAM16.SLICE\[0\].RAM8.WORD\[2\].W.BYTE\[1\].B.Q_WIRE\[0\]
+ sky130_fd_sc_hd__dlxtp_1
XSLICE_16\[0\].RAM16.SLICE\[0\].RAM8.WORD\[6\].W.BYTE\[1\].B.SEL0INV SLICE_16\[0\].RAM16.SLICE\[0\].RAM8.WORD\[6\].W.BYTE\[0\].B.SEL0
+ VGND VGND VPWR VPWR SLICE_16\[0\].RAM16.SLICE\[0\].RAM8.WORD\[6\].W.BYTE\[1\].B.SEL0_B
+ sky130_fd_sc_hd__inv_1
XSLICE_16\[1\].RAM16.SLICE\[1\].RAM8.WORD\[6\].W.BYTE\[3\].B.CGAND SLICE_16\[1\].RAM16.SLICE\[1\].RAM8.WORD\[6\].W.BYTE\[0\].B.SEL0
+ SLICE_16\[1\].RAM16.SLICE\[1\].RAM8.WE0_buf\[3\] VGND VGND VPWR VPWR SLICE_16\[1\].RAM16.SLICE\[1\].RAM8.WORD\[6\].W.BYTE\[3\].B.WE0_WIRE
+ sky130_fd_sc_hd__and2_1
Xfill_18_3 VGND VPWR sky130_fd_sc_hd__tapvpwrvgnd_1
XSLICE_16\[0\].RAM16.SLICE\[1\].RAM8.WORD\[2\].W.BYTE\[1\].B.BIT\[4\].OBUF0 SLICE_16\[0\].RAM16.SLICE\[1\].RAM8.WORD\[2\].W.BYTE\[1\].B.Q_WIRE\[4\]
+ SLICE_16\[0\].RAM16.SLICE\[1\].RAM8.WORD\[2\].W.BYTE\[1\].B.SEL0_B VGND VGND VPWR
+ VPWR SLICE_16\[0\].RAM16.BYTE\[1\].FLOATBUF0\[12\].Z sky130_fd_sc_hd__ebufn_2
Xtap_3_15 VGND VPWR sky130_fd_sc_hd__tapvpwrvgnd_1
Xtap_3_26 VGND VPWR sky130_fd_sc_hd__tapvpwrvgnd_1
Xfill_45_29 VGND VGND VPWR VPWR sky130_fd_sc_hd__decap_12
Xfill_45_18 VGND VPWR sky130_fd_sc_hd__tapvpwrvgnd_1
XSLICE_16\[0\].RAM16.Do0_REG.OUTREG_BYTE\[0\].DIODE\[7\] SLICE_16\[0\].RAM16.BYTE\[0\].FLOATBUF0\[7\].Z
+ VGND VGND VPWR VPWR sky130_fd_sc_hd__diode_2
XSLICE_16\[0\].RAM16.SLICE\[0\].RAM8.WORD\[1\].W.BYTE\[3\].B.BIT\[6\].OBUF0 SLICE_16\[0\].RAM16.SLICE\[0\].RAM8.WORD\[1\].W.BYTE\[3\].B.Q_WIRE\[6\]
+ SLICE_16\[0\].RAM16.SLICE\[0\].RAM8.WORD\[1\].W.BYTE\[3\].B.SEL0_B VGND VGND VPWR
+ VPWR SLICE_16\[0\].RAM16.BYTE\[3\].FLOATBUF0\[30\].Z sky130_fd_sc_hd__ebufn_2
XSLICE_16\[1\].RAM16.SLICE\[1\].RAM8.WORD\[4\].W.BYTE\[1\].B.DIODE_CLK SLICE_16\[1\].RAM16.SLICE\[1\].RAM8.WORD\[4\].W.BYTE\[0\].B.CLK
+ VGND VGND VPWR VPWR sky130_fd_sc_hd__diode_2
XSLICE_16\[1\].RAM16.SLICE\[1\].RAM8.WORD\[4\].W.BYTE\[0\].B.genblk1.CLKINV SLICE_16\[1\].RAM16.SLICE\[1\].RAM8.WORD\[4\].W.BYTE\[0\].B.CLK
+ VGND VGND VPWR VPWR SLICE_16\[1\].RAM16.SLICE\[1\].RAM8.WORD\[4\].W.BYTE\[0\].B.CLK_B
+ sky130_fd_sc_hd__inv_1
XSLICE_16\[1\].RAM16.SLICE\[1\].RAM8.WORD\[3\].W.BYTE\[3\].B.BIT\[3\].OBUF0 SLICE_16\[1\].RAM16.SLICE\[1\].RAM8.WORD\[3\].W.BYTE\[3\].B.Q_WIRE\[3\]
+ SLICE_16\[1\].RAM16.SLICE\[1\].RAM8.WORD\[3\].W.BYTE\[3\].B.SEL0_B VGND VGND VPWR
+ VPWR SLICE_16\[1\].RAM16.BYTE\[3\].FLOATBUF0\[27\].Z sky130_fd_sc_hd__ebufn_2
Xfill_21_103 VGND VPWR sky130_fd_sc_hd__tapvpwrvgnd_1
Xfill_19_96 VGND VPWR sky130_fd_sc_hd__tapvpwrvgnd_1
Xfill_19_85 VGND VGND VPWR VPWR sky130_fd_sc_hd__decap_12
Xfill_19_74 VGND VGND VPWR VPWR sky130_fd_sc_hd__decap_12
Xfill_19_63 VGND VPWR sky130_fd_sc_hd__tapvpwrvgnd_1
Xfill_19_52 VGND VGND VPWR VPWR sky130_fd_sc_hd__decap_12
Xfill_19_41 VGND VGND VPWR VPWR sky130_fd_sc_hd__decap_12
Xfill_19_30 VGND VPWR sky130_fd_sc_hd__tapvpwrvgnd_1
XSLICE_16\[0\].RAM16.SLICE\[0\].RAM8.WORD\[1\].W.CLKBUF SLICE_16\[0\].RAM16.SLICE\[0\].RAM8.CLKBUF.X
+ VGND VGND VPWR VPWR SLICE_16\[0\].RAM16.SLICE\[0\].RAM8.WORD\[1\].W.BYTE\[0\].B.CLK
+ sky130_fd_sc_hd__clkbuf_4
XSLICE_16\[0\].RAM16.SLICE\[1\].RAM8.WORD\[5\].W.BYTE\[2\].B.BIT\[4\].OBUF0 SLICE_16\[0\].RAM16.SLICE\[1\].RAM8.WORD\[5\].W.BYTE\[2\].B.Q_WIRE\[4\]
+ SLICE_16\[0\].RAM16.SLICE\[1\].RAM8.WORD\[5\].W.BYTE\[2\].B.SEL0_B VGND VGND VPWR
+ VPWR SLICE_16\[0\].RAM16.BYTE\[2\].FLOATBUF0\[20\].Z sky130_fd_sc_hd__ebufn_2
XSLICE_16\[0\].RAM16.SLICE\[1\].RAM8.WORD\[7\].W.BYTE\[0\].B.DIODE_CLK SLICE_16\[0\].RAM16.SLICE\[1\].RAM8.WORD\[7\].W.BYTE\[0\].B.CLK
+ VGND VGND VPWR VPWR sky130_fd_sc_hd__diode_2
XSLICE_16\[1\].RAM16.SLICE\[0\].RAM8.WORD\[4\].W.BYTE\[2\].B.BIT\[4\].genblk1.STORAGE
+ DIBUF\[20\].X SLICE_16\[1\].RAM16.SLICE\[0\].RAM8.WORD\[4\].W.BYTE\[2\].B.GCLK VGND
+ VGND VPWR VPWR SLICE_16\[1\].RAM16.SLICE\[0\].RAM8.WORD\[4\].W.BYTE\[2\].B.Q_WIRE\[4\]
+ sky130_fd_sc_hd__dlxtp_1
XSLICE_16\[0\].RAM16.SLICE\[0\].RAM8.WORD\[0\].W.BYTE\[1\].B.BIT\[3\].OBUF0 SLICE_16\[0\].RAM16.SLICE\[0\].RAM8.WORD\[0\].W.BYTE\[1\].B.Q_WIRE\[3\]
+ SLICE_16\[0\].RAM16.SLICE\[0\].RAM8.WORD\[0\].W.BYTE\[1\].B.SEL0_B VGND VGND VPWR
+ VPWR SLICE_16\[0\].RAM16.BYTE\[1\].FLOATBUF0\[11\].Z sky130_fd_sc_hd__ebufn_2
XSLICE_16\[1\].RAM16.SLICE\[1\].RAM8.WORD\[2\].W.BYTE\[1\].B.BIT\[0\].OBUF0 SLICE_16\[1\].RAM16.SLICE\[1\].RAM8.WORD\[2\].W.BYTE\[1\].B.Q_WIRE\[0\]
+ SLICE_16\[1\].RAM16.SLICE\[1\].RAM8.WORD\[2\].W.BYTE\[1\].B.SEL0_B VGND VGND VPWR
+ VPWR SLICE_16\[1\].RAM16.BYTE\[1\].FLOATBUF0\[8\].Z sky130_fd_sc_hd__ebufn_2
Xfill_30_2 VGND VGND VPWR VPWR sky130_fd_sc_hd__decap_3
XSLICE_16\[1\].RAM16.SLICE\[0\].RAM8.WORD\[2\].W.BYTE\[0\].B.BIT\[3\].genblk1.STORAGE
+ DIBUF\[3\].X SLICE_16\[1\].RAM16.SLICE\[0\].RAM8.WORD\[2\].W.BYTE\[0\].B.GCLK VGND
+ VGND VPWR VPWR SLICE_16\[1\].RAM16.SLICE\[0\].RAM8.WORD\[2\].W.BYTE\[0\].B.Q_WIRE\[3\]
+ sky130_fd_sc_hd__dlxtp_1
Xfill_23_1 VGND VPWR sky130_fd_sc_hd__tapvpwrvgnd_1
Xfill_16_0 VGND VPWR sky130_fd_sc_hd__tapvpwrvgnd_1
XSLICE_16\[0\].RAM16.SLICE\[1\].RAM8.WORD\[6\].W.BYTE\[2\].B.BIT\[5\].genblk1.STORAGE
+ DIBUF\[21\].X SLICE_16\[0\].RAM16.SLICE\[1\].RAM8.WORD\[6\].W.BYTE\[2\].B.GCLK VGND
+ VGND VPWR VPWR SLICE_16\[0\].RAM16.SLICE\[1\].RAM8.WORD\[6\].W.BYTE\[2\].B.Q_WIRE\[5\]
+ sky130_fd_sc_hd__dlxtp_1
XSLICE_16\[0\].RAM16.SLICE\[1\].RAM8.WORD\[0\].W.BYTE\[3\].B.BIT\[6\].genblk1.STORAGE
+ DIBUF\[30\].X SLICE_16\[0\].RAM16.SLICE\[1\].RAM8.WORD\[0\].W.BYTE\[3\].B.GCLK VGND
+ VGND VPWR VPWR SLICE_16\[0\].RAM16.SLICE\[1\].RAM8.WORD\[0\].W.BYTE\[3\].B.Q_WIRE\[6\]
+ sky130_fd_sc_hd__dlxtp_1
XSLICE_16\[1\].RAM16.SLICE\[1\].RAM8.WORD\[7\].W.BYTE\[1\].B.genblk1.CLKINV SLICE_16\[1\].RAM16.SLICE\[1\].RAM8.WORD\[7\].W.BYTE\[0\].B.CLK
+ VGND VGND VPWR VPWR SLICE_16\[1\].RAM16.SLICE\[1\].RAM8.WORD\[7\].W.BYTE\[1\].B.CLK_B
+ sky130_fd_sc_hd__inv_1
XSLICE_16\[0\].RAM16.SLICE\[1\].RAM8.WORD\[4\].W.BYTE\[0\].B.BIT\[4\].genblk1.STORAGE
+ DIBUF\[4\].X SLICE_16\[0\].RAM16.SLICE\[1\].RAM8.WORD\[4\].W.BYTE\[0\].B.GCLK VGND
+ VGND VPWR VPWR SLICE_16\[0\].RAM16.SLICE\[1\].RAM8.WORD\[4\].W.BYTE\[0\].B.Q_WIRE\[4\]
+ sky130_fd_sc_hd__dlxtp_1
Xtap_38_7 VGND VPWR sky130_fd_sc_hd__tapvpwrvgnd_1
XSLICE_16\[0\].RAM16.SLICE\[0\].RAM8.WORD\[5\].W.BYTE\[2\].B.BIT\[0\].genblk1.STORAGE
+ DIBUF\[16\].X SLICE_16\[0\].RAM16.SLICE\[0\].RAM8.WORD\[5\].W.BYTE\[2\].B.GCLK VGND
+ VGND VPWR VPWR SLICE_16\[0\].RAM16.SLICE\[0\].RAM8.WORD\[5\].W.BYTE\[2\].B.Q_WIRE\[0\]
+ sky130_fd_sc_hd__dlxtp_1
XSLICE_16\[0\].RAM16.SLICE\[1\].RAM8.WORD\[4\].W.BYTE\[0\].B.BIT\[1\].OBUF0 SLICE_16\[0\].RAM16.SLICE\[1\].RAM8.WORD\[4\].W.BYTE\[0\].B.Q_WIRE\[1\]
+ SLICE_16\[0\].RAM16.SLICE\[1\].RAM8.WORD\[4\].W.BYTE\[0\].B.SEL0_B VGND VGND VPWR
+ VPWR SLICE_16\[0\].RAM16.BYTE\[0\].FLOATBUF0\[1\].Z sky130_fd_sc_hd__ebufn_2
Xtap_33_32 VGND VPWR sky130_fd_sc_hd__tapvpwrvgnd_1
Xtap_33_21 VGND VPWR sky130_fd_sc_hd__tapvpwrvgnd_1
Xtap_33_10 VGND VPWR sky130_fd_sc_hd__tapvpwrvgnd_1
XSLICE_16\[1\].RAM16.SLICE\[0\].RAM8.WORD\[1\].W.BYTE\[3\].B.BIT\[2\].OBUF0 SLICE_16\[1\].RAM16.SLICE\[0\].RAM8.WORD\[1\].W.BYTE\[3\].B.Q_WIRE\[2\]
+ SLICE_16\[1\].RAM16.SLICE\[0\].RAM8.WORD\[1\].W.BYTE\[3\].B.SEL0_B VGND VGND VPWR
+ VPWR SLICE_16\[1\].RAM16.BYTE\[3\].FLOATBUF0\[26\].Z sky130_fd_sc_hd__ebufn_2
XSLICE_16\[1\].RAM16.BYTE\[1\].FLOATBUF0\[13\].__cell__ SLICE_16\[1\].RAM16.BYTE\[1\].FLOATBUF0\[10\].A
+ SLICE_16\[1\].RAM16.BYTE\[1\].FLOATBUF0\[10\].TE_B VGND VGND VPWR VPWR SLICE_16\[1\].RAM16.BYTE\[1\].FLOATBUF0\[13\].Z
+ sky130_fd_sc_hd__ebufn_2
XSLICE_16\[1\].RAM16.SLICE\[0\].RAM8.WORD\[1\].W.BYTE\[3\].B.CGAND SLICE_16\[1\].RAM16.SLICE\[0\].RAM8.WORD\[1\].W.BYTE\[0\].B.SEL0
+ SLICE_16\[1\].RAM16.SLICE\[0\].RAM8.WE0_buf\[3\] VGND VGND VPWR VPWR SLICE_16\[1\].RAM16.SLICE\[0\].RAM8.WORD\[1\].W.BYTE\[3\].B.WE0_WIRE
+ sky130_fd_sc_hd__and2_1
Xfill_21_64 VGND VGND VPWR VPWR sky130_fd_sc_hd__decap_12
Xfill_21_53 VGND VGND VPWR VPWR sky130_fd_sc_hd__decap_12
Xfill_21_42 VGND VPWR sky130_fd_sc_hd__tapvpwrvgnd_1
Xfill_21_31 VGND VGND VPWR VPWR sky130_fd_sc_hd__decap_12
Xfill_21_20 VGND VGND VPWR VPWR sky130_fd_sc_hd__decap_12
XSLICE_16\[1\].RAM16.Do0_REG.OUTREG_BYTE\[2\].Do_FF\[0\] SLICE_16\[1\].RAM16.Do0_REG.CLKBUF\[2\]
+ SLICE_16\[1\].RAM16.BYTE\[2\].FLOATBUF0\[16\].Z VGND VGND VPWR VPWR Do0MUX.A1\[16\]
+ sky130_fd_sc_hd__dfxtp_1
Xfill_21_97 VGND VGND VPWR VPWR sky130_fd_sc_hd__decap_12
Xfill_21_86 VGND VGND VPWR VPWR sky130_fd_sc_hd__decap_12
Xfill_21_75 VGND VPWR sky130_fd_sc_hd__tapvpwrvgnd_1
XSLICE_16\[0\].RAM16.SLICE\[0\].RAM8.WORD\[3\].W.BYTE\[2\].B.BIT\[3\].OBUF0 SLICE_16\[0\].RAM16.SLICE\[0\].RAM8.WORD\[3\].W.BYTE\[2\].B.Q_WIRE\[3\]
+ SLICE_16\[0\].RAM16.SLICE\[0\].RAM8.WORD\[3\].W.BYTE\[2\].B.SEL0_B VGND VGND VPWR
+ VPWR SLICE_16\[0\].RAM16.BYTE\[2\].FLOATBUF0\[19\].Z sky130_fd_sc_hd__ebufn_2
Xfill_46_94 VGND VGND VPWR VPWR sky130_fd_sc_hd__decap_12
Xfill_46_83 VGND VGND VPWR VPWR sky130_fd_sc_hd__decap_12
Xfill_46_72 VGND VGND VPWR VPWR sky130_fd_sc_hd__decap_4
Xfill_46_61 VGND VPWR sky130_fd_sc_hd__tapvpwrvgnd_1
Xfill_46_50 VGND VPWR sky130_fd_sc_hd__tapvpwrvgnd_1
XSLICE_16\[1\].RAM16.SLICE\[1\].RAM8.WORD\[5\].W.BYTE\[2\].B.BIT\[0\].OBUF0 SLICE_16\[1\].RAM16.SLICE\[1\].RAM8.WORD\[5\].W.BYTE\[2\].B.Q_WIRE\[0\]
+ SLICE_16\[1\].RAM16.SLICE\[1\].RAM8.WORD\[5\].W.BYTE\[2\].B.SEL0_B VGND VGND VPWR
+ VPWR SLICE_16\[1\].RAM16.BYTE\[2\].FLOATBUF0\[16\].Z sky130_fd_sc_hd__ebufn_2
XSLICE_16\[1\].RAM16.SLICE\[0\].RAM8.WORD\[5\].W.BYTE\[2\].B.genblk1.CG SLICE_16\[1\].RAM16.SLICE\[0\].RAM8.WORD\[5\].W.BYTE\[2\].B.CLK_B
+ SLICE_16\[1\].RAM16.SLICE\[0\].RAM8.WORD\[5\].W.BYTE\[2\].B.WE0_WIRE VGND VGND VPWR
+ VPWR SLICE_16\[1\].RAM16.SLICE\[0\].RAM8.WORD\[5\].W.BYTE\[2\].B.GCLK sky130_fd_sc_hd__dlclkp_1
XSLICE_16\[1\].RAM16.SLICE\[0\].RAM8.WORD\[4\].W.BYTE\[1\].B.SEL0INV SLICE_16\[1\].RAM16.SLICE\[0\].RAM8.WORD\[4\].W.BYTE\[0\].B.SEL0
+ VGND VGND VPWR VPWR SLICE_16\[1\].RAM16.SLICE\[0\].RAM8.WORD\[4\].W.BYTE\[1\].B.SEL0_B
+ sky130_fd_sc_hd__inv_1
XSLICE_16\[0\].RAM16.SLICE\[1\].RAM8.WORD\[7\].W.BYTE\[1\].B.BIT\[1\].OBUF0 SLICE_16\[0\].RAM16.SLICE\[1\].RAM8.WORD\[7\].W.BYTE\[1\].B.Q_WIRE\[1\]
+ SLICE_16\[0\].RAM16.SLICE\[1\].RAM8.WORD\[7\].W.BYTE\[1\].B.SEL0_B VGND VGND VPWR
+ VPWR SLICE_16\[0\].RAM16.BYTE\[1\].FLOATBUF0\[9\].Z sky130_fd_sc_hd__ebufn_2
Xtap_0_27 VGND VPWR sky130_fd_sc_hd__tapvpwrvgnd_1
Xtap_0_16 VGND VPWR sky130_fd_sc_hd__tapvpwrvgnd_1
XSLICE_16\[0\].RAM16.SLICE\[1\].RAM8.DEC0.ABUF\[1\] SLICE_16\[0\].RAM16.A0BUF\[1\].X
+ VGND VGND VPWR VPWR SLICE_16\[0\].RAM16.SLICE\[1\].RAM8.DEC0.A_buf\[1\] sky130_fd_sc_hd__clkbuf_2
Xtap_9_14 VGND VPWR sky130_fd_sc_hd__tapvpwrvgnd_1
Xtap_9_25 VGND VPWR sky130_fd_sc_hd__tapvpwrvgnd_1
Xtap_9_36 VGND VPWR sky130_fd_sc_hd__tapvpwrvgnd_1
Xfill_42_19 VGND VGND VPWR VPWR sky130_fd_sc_hd__decap_12
XSLICE_16\[1\].RAM16.SLICE\[0\].RAM8.WORD\[7\].W.BYTE\[3\].B.BIT\[4\].genblk1.STORAGE
+ DIBUF\[28\].X SLICE_16\[1\].RAM16.SLICE\[0\].RAM8.WORD\[7\].W.BYTE\[3\].B.GCLK VGND
+ VGND VPWR VPWR SLICE_16\[1\].RAM16.SLICE\[0\].RAM8.WORD\[7\].W.BYTE\[3\].B.Q_WIRE\[4\]
+ sky130_fd_sc_hd__dlxtp_1
XSLICE_16\[0\].RAM16.SLICE\[1\].RAM8.WORD\[6\].W.BYTE\[3\].B.SEL0INV SLICE_16\[0\].RAM16.SLICE\[1\].RAM8.WORD\[6\].W.BYTE\[0\].B.SEL0
+ VGND VGND VPWR VPWR SLICE_16\[0\].RAM16.SLICE\[1\].RAM8.WORD\[6\].W.BYTE\[3\].B.SEL0_B
+ sky130_fd_sc_hd__inv_1
XSLICE_16\[0\].RAM16.SLICE\[0\].RAM8.WORD\[2\].W.BYTE\[0\].B.BIT\[0\].OBUF0 SLICE_16\[0\].RAM16.SLICE\[0\].RAM8.WORD\[2\].W.BYTE\[0\].B.Q_WIRE\[0\]
+ SLICE_16\[0\].RAM16.SLICE\[0\].RAM8.WORD\[2\].W.BYTE\[0\].B.SEL0_B VGND VGND VPWR
+ VPWR SLICE_16\[0\].RAM16.BYTE\[0\].FLOATBUF0\[0\].Z sky130_fd_sc_hd__ebufn_2
XSLICE_16\[0\].RAM16.SLICE\[0\].RAM8.WORD\[7\].W.BYTE\[0\].B.genblk1.CLKINV SLICE_16\[0\].RAM16.SLICE\[0\].RAM8.WORD\[7\].W.BYTE\[0\].B.CLK
+ VGND VGND VPWR VPWR SLICE_16\[0\].RAM16.SLICE\[0\].RAM8.WORD\[7\].W.BYTE\[0\].B.CLK_B
+ sky130_fd_sc_hd__inv_1
Xtap_36_4 VGND VPWR sky130_fd_sc_hd__tapvpwrvgnd_1
Xtap_29_3 VGND VPWR sky130_fd_sc_hd__tapvpwrvgnd_1
Xtap_28_32 VGND VPWR sky130_fd_sc_hd__tapvpwrvgnd_1
Xtap_28_21 VGND VPWR sky130_fd_sc_hd__tapvpwrvgnd_1
XSLICE_16\[1\].RAM16.SLICE\[0\].RAM8.WORD\[5\].W.BYTE\[1\].B.BIT\[3\].genblk1.STORAGE
+ DIBUF\[11\].X SLICE_16\[1\].RAM16.SLICE\[0\].RAM8.WORD\[5\].W.BYTE\[1\].B.GCLK VGND
+ VGND VPWR VPWR SLICE_16\[1\].RAM16.SLICE\[0\].RAM8.WORD\[5\].W.BYTE\[1\].B.Q_WIRE\[3\]
+ sky130_fd_sc_hd__dlxtp_1
Xtap_28_10 VGND VPWR sky130_fd_sc_hd__tapvpwrvgnd_1
XSLICE_16\[1\].RAM16.SLICE\[0\].RAM8.WORD\[1\].W.BYTE\[1\].B.BIT\[7\].OBUF0 SLICE_16\[1\].RAM16.SLICE\[0\].RAM8.WORD\[1\].W.BYTE\[1\].B.Q_WIRE\[7\]
+ SLICE_16\[1\].RAM16.SLICE\[0\].RAM8.WORD\[1\].W.BYTE\[1\].B.SEL0_B VGND VGND VPWR
+ VPWR SLICE_16\[1\].RAM16.BYTE\[1\].FLOATBUF0\[15\].Z sky130_fd_sc_hd__ebufn_2
XSLICE_16\[0\].RAM16.SLICE\[0\].RAM8.WORD\[6\].W.BYTE\[3\].B.BIT\[3\].OBUF0 SLICE_16\[0\].RAM16.SLICE\[0\].RAM8.WORD\[6\].W.BYTE\[3\].B.Q_WIRE\[3\]
+ SLICE_16\[0\].RAM16.SLICE\[0\].RAM8.WORD\[6\].W.BYTE\[3\].B.SEL0_B VGND VGND VPWR
+ VPWR SLICE_16\[0\].RAM16.BYTE\[3\].FLOATBUF0\[27\].Z sky130_fd_sc_hd__ebufn_2
XSLICE_16\[0\].RAM16.BYTE\[3\].FLOATBUF0\[27\].__cell__ SLICE_16\[0\].RAM16.BYTE\[3\].FLOATBUF0\[24\].A
+ SLICE_16\[0\].RAM16.BYTE\[3\].FLOATBUF0\[24\].TE_B VGND VGND VPWR VPWR SLICE_16\[0\].RAM16.BYTE\[3\].FLOATBUF0\[27\].Z
+ sky130_fd_sc_hd__ebufn_2
XSLICE_16\[0\].RAM16.SLICE\[1\].RAM8.WORD\[7\].W.BYTE\[1\].B.BIT\[4\].genblk1.STORAGE
+ DIBUF\[12\].X SLICE_16\[0\].RAM16.SLICE\[1\].RAM8.WORD\[7\].W.BYTE\[1\].B.GCLK VGND
+ VGND VPWR VPWR SLICE_16\[0\].RAM16.SLICE\[1\].RAM8.WORD\[7\].W.BYTE\[1\].B.Q_WIRE\[4\]
+ sky130_fd_sc_hd__dlxtp_1
XSLICE_16\[0\].RAM16.SLICE\[1\].RAM8.WORD\[1\].W.BYTE\[2\].B.BIT\[5\].genblk1.STORAGE
+ DIBUF\[21\].X SLICE_16\[0\].RAM16.SLICE\[1\].RAM8.WORD\[1\].W.BYTE\[2\].B.GCLK VGND
+ VGND VPWR VPWR SLICE_16\[0\].RAM16.SLICE\[1\].RAM8.WORD\[1\].W.BYTE\[2\].B.Q_WIRE\[5\]
+ sky130_fd_sc_hd__dlxtp_1
XSLICE_16\[0\].RAM16.SLICE\[0\].RAM8.WORD\[2\].W.BYTE\[2\].B.SEL0INV SLICE_16\[0\].RAM16.SLICE\[0\].RAM8.WORD\[2\].W.BYTE\[0\].B.SEL0
+ VGND VGND VPWR VPWR SLICE_16\[0\].RAM16.SLICE\[0\].RAM8.WORD\[2\].W.BYTE\[2\].B.SEL0_B
+ sky130_fd_sc_hd__inv_1
XSLICE_16\[1\].RAM16.SLICE\[1\].RAM8.WORD\[5\].W.BYTE\[0\].B.BIT\[5\].OBUF0 SLICE_16\[1\].RAM16.SLICE\[1\].RAM8.WORD\[5\].W.BYTE\[0\].B.Q_WIRE\[5\]
+ SLICE_16\[1\].RAM16.SLICE\[1\].RAM8.WORD\[5\].W.BYTE\[0\].B.SEL0_B VGND VGND VPWR
+ VPWR SLICE_16\[1\].RAM16.BYTE\[0\].FLOATBUF0\[5\].Z sky130_fd_sc_hd__ebufn_2
XSLICE_16\[1\].RAM16.SLICE\[1\].RAM8.WORD\[2\].W.BYTE\[2\].B.CGAND SLICE_16\[1\].RAM16.SLICE\[1\].RAM8.WORD\[2\].W.BYTE\[0\].B.SEL0
+ SLICE_16\[1\].RAM16.SLICE\[1\].RAM8.WE0_buf\[2\] VGND VGND VPWR VPWR SLICE_16\[1\].RAM16.SLICE\[1\].RAM8.WORD\[2\].W.BYTE\[2\].B.WE0_WIRE
+ sky130_fd_sc_hd__and2_1
XSLICE_16\[0\].RAM16.SLICE\[0\].RAM8.WORD\[0\].W.BYTE\[2\].B.BIT\[0\].genblk1.STORAGE
+ DIBUF\[16\].X SLICE_16\[0\].RAM16.SLICE\[0\].RAM8.WORD\[0\].W.BYTE\[2\].B.GCLK VGND
+ VGND VPWR VPWR SLICE_16\[0\].RAM16.SLICE\[0\].RAM8.WORD\[0\].W.BYTE\[2\].B.Q_WIRE\[0\]
+ sky130_fd_sc_hd__dlxtp_1
Xfill_5_6 VGND VGND VPWR VPWR sky130_fd_sc_hd__decap_6
XSLICE_16\[0\].RAM16.SLICE\[0\].RAM8.WORD\[5\].W.BYTE\[1\].B.BIT\[0\].OBUF0 SLICE_16\[0\].RAM16.SLICE\[0\].RAM8.WORD\[5\].W.BYTE\[1\].B.Q_WIRE\[0\]
+ SLICE_16\[0\].RAM16.SLICE\[0\].RAM8.WORD\[5\].W.BYTE\[1\].B.SEL0_B VGND VGND VPWR
+ VPWR SLICE_16\[0\].RAM16.BYTE\[1\].FLOATBUF0\[8\].Z sky130_fd_sc_hd__ebufn_2
XSLICE_16\[1\].RAM16.SLICE\[0\].RAM8.WORD\[4\].W.BYTE\[2\].B.BIT\[7\].OBUF0 SLICE_16\[1\].RAM16.SLICE\[0\].RAM8.WORD\[4\].W.BYTE\[2\].B.Q_WIRE\[7\]
+ SLICE_16\[1\].RAM16.SLICE\[0\].RAM8.WORD\[4\].W.BYTE\[2\].B.SEL0_B VGND VGND VPWR
+ VPWR SLICE_16\[1\].RAM16.BYTE\[2\].FLOATBUF0\[23\].Z sky130_fd_sc_hd__ebufn_2
XSLICE_16\[0\].RAM16.Do0_REG.OUTREG_BYTE\[1\].DIODE\[0\] SLICE_16\[0\].RAM16.BYTE\[1\].FLOATBUF0\[8\].Z
+ VGND VGND VPWR VPWR sky130_fd_sc_hd__diode_2
Xtap_15_9 VGND VPWR sky130_fd_sc_hd__tapvpwrvgnd_1
Xtap_14_12 VGND VPWR sky130_fd_sc_hd__tapvpwrvgnd_1
Xtap_8_8 VGND VPWR sky130_fd_sc_hd__tapvpwrvgnd_1
Xtap_30_33 VGND VPWR sky130_fd_sc_hd__tapvpwrvgnd_1
Xtap_30_22 VGND VPWR sky130_fd_sc_hd__tapvpwrvgnd_1
Xtap_30_11 VGND VPWR sky130_fd_sc_hd__tapvpwrvgnd_1
Xtap_14_34 VGND VPWR sky130_fd_sc_hd__tapvpwrvgnd_1
Xtap_14_23 VGND VPWR sky130_fd_sc_hd__tapvpwrvgnd_1
Xtap_34_1 VGND VPWR sky130_fd_sc_hd__tapvpwrvgnd_1
XDo0MUX.M\[3\].DIODE_A1MUX\[30\] Do0MUX.A1\[30\] VGND VGND VPWR VPWR sky130_fd_sc_hd__diode_2
XDo0MUX.M\[0\].DIODE_A1MUX\[3\] Do0MUX.A1\[3\] VGND VGND VPWR VPWR sky130_fd_sc_hd__diode_2
Xtap_27_0 VGND VPWR sky130_fd_sc_hd__tapvpwrvgnd_1
Xfill_46_109 VGND VGND VPWR VPWR sky130_fd_sc_hd__decap_12
XSLICE_16\[1\].RAM16.SLICE\[1\].RAM8.WORD\[7\].W.BYTE\[0\].B.BIT\[7\].genblk1.STORAGE
+ DIBUF\[7\].X SLICE_16\[1\].RAM16.SLICE\[1\].RAM8.WORD\[7\].W.BYTE\[0\].B.GCLK VGND
+ VGND VPWR VPWR SLICE_16\[1\].RAM16.SLICE\[1\].RAM8.WORD\[7\].W.BYTE\[0\].B.Q_WIRE\[7\]
+ sky130_fd_sc_hd__dlxtp_1
XSLICE_16\[1\].RAM16.SLICE\[0\].RAM8.WORD\[3\].W.BYTE\[0\].B.BIT\[4\].OBUF0 SLICE_16\[1\].RAM16.SLICE\[0\].RAM8.WORD\[3\].W.BYTE\[0\].B.Q_WIRE\[4\]
+ SLICE_16\[1\].RAM16.SLICE\[0\].RAM8.WORD\[3\].W.BYTE\[0\].B.SEL0_B VGND VGND VPWR
+ VPWR SLICE_16\[1\].RAM16.BYTE\[0\].FLOATBUF0\[4\].Z sky130_fd_sc_hd__ebufn_2
XSLICE_16\[0\].RAM16.SLICE\[1\].RAM8.WORD\[0\].W.BYTE\[2\].B.BIT\[3\].OBUF0 SLICE_16\[0\].RAM16.SLICE\[1\].RAM8.WORD\[0\].W.BYTE\[2\].B.Q_WIRE\[3\]
+ SLICE_16\[0\].RAM16.SLICE\[1\].RAM8.WORD\[0\].W.BYTE\[2\].B.SEL0_B VGND VGND VPWR
+ VPWR SLICE_16\[0\].RAM16.BYTE\[2\].FLOATBUF0\[19\].Z sky130_fd_sc_hd__ebufn_2
Xfill_43_95 VGND VGND VPWR VPWR sky130_fd_sc_hd__decap_12
Xfill_43_84 VGND VPWR sky130_fd_sc_hd__tapvpwrvgnd_1
Xfill_43_73 VGND VGND VPWR VPWR sky130_fd_sc_hd__decap_12
Xfill_43_62 VGND VGND VPWR VPWR sky130_fd_sc_hd__decap_12
Xfill_43_51 VGND VPWR sky130_fd_sc_hd__tapvpwrvgnd_1
Xfill_43_40 VGND VGND VPWR VPWR sky130_fd_sc_hd__decap_12
XSLICE_16\[1\].RAM16.SLICE\[0\].RAM8.WORD\[7\].W.BYTE\[3\].B.BIT\[7\].OBUF0 SLICE_16\[1\].RAM16.SLICE\[0\].RAM8.WORD\[7\].W.BYTE\[3\].B.Q_WIRE\[7\]
+ SLICE_16\[1\].RAM16.SLICE\[0\].RAM8.WORD\[7\].W.BYTE\[3\].B.SEL0_B VGND VGND VPWR
+ VPWR SLICE_16\[1\].RAM16.BYTE\[3\].FLOATBUF0\[31\].Z sky130_fd_sc_hd__ebufn_2
XSLICE_16\[1\].RAM16.SLICE\[0\].RAM8.WORD\[2\].W.BYTE\[3\].B.BIT\[4\].genblk1.STORAGE
+ DIBUF\[28\].X SLICE_16\[1\].RAM16.SLICE\[0\].RAM8.WORD\[2\].W.BYTE\[3\].B.GCLK VGND
+ VGND VPWR VPWR SLICE_16\[1\].RAM16.SLICE\[0\].RAM8.WORD\[2\].W.BYTE\[3\].B.Q_WIRE\[4\]
+ sky130_fd_sc_hd__dlxtp_1
XSLICE_16\[1\].RAM16.SLICE\[0\].RAM8.WORD\[6\].W.BYTE\[0\].B.BIT\[2\].genblk1.STORAGE
+ DIBUF\[2\].X SLICE_16\[1\].RAM16.SLICE\[0\].RAM8.WORD\[6\].W.BYTE\[0\].B.GCLK VGND
+ VGND VPWR VPWR SLICE_16\[1\].RAM16.SLICE\[0\].RAM8.WORD\[6\].W.BYTE\[0\].B.Q_WIRE\[2\]
+ sky130_fd_sc_hd__dlxtp_1
XSLICE_16\[1\].RAM16.SLICE\[0\].RAM8.WORD\[0\].W.BYTE\[1\].B.BIT\[3\].genblk1.STORAGE
+ DIBUF\[11\].X SLICE_16\[1\].RAM16.SLICE\[0\].RAM8.WORD\[0\].W.BYTE\[1\].B.GCLK VGND
+ VGND VPWR VPWR SLICE_16\[1\].RAM16.SLICE\[0\].RAM8.WORD\[0\].W.BYTE\[1\].B.Q_WIRE\[3\]
+ sky130_fd_sc_hd__dlxtp_1
XSLICE_16\[0\].RAM16.SLICE\[1\].RAM8.WORD\[4\].W.BYTE\[3\].B.BIT\[5\].genblk1.STORAGE
+ DIBUF\[29\].X SLICE_16\[0\].RAM16.SLICE\[1\].RAM8.WORD\[4\].W.BYTE\[3\].B.GCLK VGND
+ VGND VPWR VPWR SLICE_16\[0\].RAM16.SLICE\[1\].RAM8.WORD\[4\].W.BYTE\[3\].B.Q_WIRE\[5\]
+ sky130_fd_sc_hd__dlxtp_1
XSLICE_16\[0\].RAM16.SLICE\[0\].RAM8.WORD\[3\].W.BYTE\[3\].B.BIT\[0\].genblk1.STORAGE
+ DIBUF\[24\].X SLICE_16\[0\].RAM16.SLICE\[0\].RAM8.WORD\[3\].W.BYTE\[3\].B.GCLK VGND
+ VGND VPWR VPWR SLICE_16\[0\].RAM16.SLICE\[0\].RAM8.WORD\[3\].W.BYTE\[3\].B.Q_WIRE\[0\]
+ sky130_fd_sc_hd__dlxtp_1
XSLICE_16\[0\].RAM16.SLICE\[1\].RAM8.WORD\[2\].W.BYTE\[1\].B.BIT\[4\].genblk1.STORAGE
+ DIBUF\[12\].X SLICE_16\[0\].RAM16.SLICE\[1\].RAM8.WORD\[2\].W.BYTE\[1\].B.GCLK VGND
+ VGND VPWR VPWR SLICE_16\[0\].RAM16.SLICE\[1\].RAM8.WORD\[2\].W.BYTE\[1\].B.Q_WIRE\[4\]
+ sky130_fd_sc_hd__dlxtp_1
XSLICE_16\[0\].RAM16.Do0_REG.OUTREG_BYTE\[0\].Do_FF\[1\] SLICE_16\[0\].RAM16.Do0_REG.CLKBUF\[0\]
+ SLICE_16\[0\].RAM16.BYTE\[0\].FLOATBUF0\[1\].Z VGND VGND VPWR VPWR Do0MUX.A0\[1\]
+ sky130_fd_sc_hd__dfxtp_1
Xfill_3_3 VGND VGND VPWR VPWR sky130_fd_sc_hd__decap_4
Xtap_6_15 VGND VPWR sky130_fd_sc_hd__tapvpwrvgnd_1
Xtap_6_26 VGND VPWR sky130_fd_sc_hd__tapvpwrvgnd_1
Xtap_13_6 VGND VPWR sky130_fd_sc_hd__tapvpwrvgnd_1
XSLICE_16\[1\].RAM16.SLICE\[1\].RAM8.WORD\[4\].W.BYTE\[3\].B.SEL0INV SLICE_16\[1\].RAM16.SLICE\[1\].RAM8.WORD\[4\].W.BYTE\[0\].B.SEL0
+ VGND VGND VPWR VPWR SLICE_16\[1\].RAM16.SLICE\[1\].RAM8.WORD\[4\].W.BYTE\[3\].B.SEL0_B
+ sky130_fd_sc_hd__inv_1
XSLICE_16\[1\].RAM16.SLICE\[0\].RAM8.WORD\[6\].W.BYTE\[1\].B.BIT\[4\].OBUF0 SLICE_16\[1\].RAM16.SLICE\[0\].RAM8.WORD\[6\].W.BYTE\[1\].B.Q_WIRE\[4\]
+ SLICE_16\[1\].RAM16.SLICE\[0\].RAM8.WORD\[6\].W.BYTE\[1\].B.SEL0_B VGND VGND VPWR
+ VPWR SLICE_16\[1\].RAM16.BYTE\[1\].FLOATBUF0\[12\].Z sky130_fd_sc_hd__ebufn_2
Xtap_25_33 VGND VPWR sky130_fd_sc_hd__tapvpwrvgnd_1
Xtap_25_22 VGND VPWR sky130_fd_sc_hd__tapvpwrvgnd_1
Xtap_25_11 VGND VPWR sky130_fd_sc_hd__tapvpwrvgnd_1
XSLICE_16\[0\].RAM16.SLICE\[1\].RAM8.WORD\[4\].W.BYTE\[0\].B.genblk1.CLKINV SLICE_16\[0\].RAM16.SLICE\[1\].RAM8.WORD\[4\].W.BYTE\[0\].B.CLK
+ VGND VGND VPWR VPWR SLICE_16\[0\].RAM16.SLICE\[1\].RAM8.WORD\[4\].W.BYTE\[0\].B.CLK_B
+ sky130_fd_sc_hd__inv_1
XSLICE_16\[0\].RAM16.SLICE\[1\].RAM8.WORD\[3\].W.BYTE\[3\].B.BIT\[3\].OBUF0 SLICE_16\[0\].RAM16.SLICE\[1\].RAM8.WORD\[3\].W.BYTE\[3\].B.Q_WIRE\[3\]
+ SLICE_16\[0\].RAM16.SLICE\[1\].RAM8.WORD\[3\].W.BYTE\[3\].B.SEL0_B VGND VGND VPWR
+ VPWR SLICE_16\[0\].RAM16.BYTE\[3\].FLOATBUF0\[27\].Z sky130_fd_sc_hd__ebufn_2
Xtap_6_5 VGND VPWR sky130_fd_sc_hd__tapvpwrvgnd_1
XSLICE_16\[1\].RAM16.SLICE\[0\].RAM8.WORD\[0\].W.BYTE\[2\].B.SEL0INV SLICE_16\[1\].RAM16.SLICE\[0\].RAM8.WORD\[0\].W.BYTE\[0\].B.SEL0
+ VGND VGND VPWR VPWR SLICE_16\[1\].RAM16.SLICE\[0\].RAM8.WORD\[0\].W.BYTE\[2\].B.SEL0_B
+ sky130_fd_sc_hd__inv_1
XSLICE_16\[0\].RAM16.SLICE\[0\].RAM8.WORD\[6\].W.BYTE\[0\].B.SEL0INV SLICE_16\[0\].RAM16.SLICE\[0\].RAM8.WORD\[6\].W.BYTE\[0\].B.SEL0
+ VGND VGND VPWR VPWR SLICE_16\[0\].RAM16.SLICE\[0\].RAM8.WORD\[6\].W.BYTE\[0\].B.SEL0_B
+ sky130_fd_sc_hd__inv_1
Xfill_42_101 VGND VGND VPWR VPWR sky130_fd_sc_hd__decap_12
XSLICE_16\[0\].RAM16.SLICE\[0\].RAM8.WORD\[4\].W.BYTE\[2\].B.genblk1.CG SLICE_16\[0\].RAM16.SLICE\[0\].RAM8.WORD\[4\].W.BYTE\[2\].B.CLK_B
+ SLICE_16\[0\].RAM16.SLICE\[0\].RAM8.WORD\[4\].W.BYTE\[2\].B.WE0_WIRE VGND VGND VPWR
+ VPWR SLICE_16\[0\].RAM16.SLICE\[0\].RAM8.WORD\[4\].W.BYTE\[2\].B.GCLK sky130_fd_sc_hd__dlclkp_1
XSLICE_16\[0\].RAM16.SLICE\[1\].RAM8.DEC0.AND0 SLICE_16\[0\].RAM16.SLICE\[1\].RAM8.DEC0.A_buf\[0\]
+ SLICE_16\[0\].RAM16.SLICE\[1\].RAM8.DEC0.A_buf\[1\] SLICE_16\[0\].RAM16.SLICE\[1\].RAM8.DEC0.A_buf\[2\]
+ SLICE_16\[0\].RAM16.SLICE\[1\].RAM8.DEC0.EN_buf VGND VGND VPWR VPWR SLICE_16\[0\].RAM16.SLICE\[1\].RAM8.DEC0.SEL\[0\]
+ sky130_fd_sc_hd__nor4b_2
XSLICE_16\[0\].RAM16.SLICE\[1\].RAM8.WORD\[2\].W.BYTE\[1\].B.BIT\[0\].OBUF0 SLICE_16\[0\].RAM16.SLICE\[1\].RAM8.WORD\[2\].W.BYTE\[1\].B.Q_WIRE\[0\]
+ SLICE_16\[0\].RAM16.SLICE\[1\].RAM8.WORD\[2\].W.BYTE\[1\].B.SEL0_B VGND VGND VPWR
+ VPWR SLICE_16\[0\].RAM16.BYTE\[1\].FLOATBUF0\[8\].Z sky130_fd_sc_hd__ebufn_2
Xfill_46_0 VGND VPWR sky130_fd_sc_hd__tapvpwrvgnd_1
XSLICE_16\[1\].RAM16.SLICE\[1\].RAM8.WORD\[2\].W.BYTE\[0\].B.BIT\[7\].genblk1.STORAGE
+ DIBUF\[7\].X SLICE_16\[1\].RAM16.SLICE\[1\].RAM8.WORD\[2\].W.BYTE\[0\].B.GCLK VGND
+ VGND VPWR VPWR SLICE_16\[1\].RAM16.SLICE\[1\].RAM8.WORD\[2\].W.BYTE\[0\].B.Q_WIRE\[7\]
+ sky130_fd_sc_hd__dlxtp_1
XSLICE_16\[1\].RAM16.SLICE\[1\].RAM8.WORD\[1\].W.BYTE\[2\].B.BIT\[7\].OBUF0 SLICE_16\[1\].RAM16.SLICE\[1\].RAM8.WORD\[1\].W.BYTE\[2\].B.Q_WIRE\[7\]
+ SLICE_16\[1\].RAM16.SLICE\[1\].RAM8.WORD\[1\].W.BYTE\[2\].B.SEL0_B VGND VGND VPWR
+ VPWR SLICE_16\[1\].RAM16.BYTE\[2\].FLOATBUF0\[23\].Z sky130_fd_sc_hd__ebufn_2
XSLICE_16\[0\].RAM16.SLICE\[1\].RAM8.WORD\[7\].W.BYTE\[1\].B.genblk1.CLKINV SLICE_16\[0\].RAM16.SLICE\[1\].RAM8.WORD\[7\].W.BYTE\[0\].B.CLK
+ VGND VGND VPWR VPWR SLICE_16\[0\].RAM16.SLICE\[1\].RAM8.WORD\[7\].W.BYTE\[1\].B.CLK_B
+ sky130_fd_sc_hd__inv_1
Xfill_1_0 VGND VPWR sky130_fd_sc_hd__tapvpwrvgnd_1
XSLICE_16\[1\].RAM16.SLICE\[0\].RAM8.WORD\[3\].W.BYTE\[2\].B.BIT\[3\].genblk1.STORAGE
+ DIBUF\[19\].X SLICE_16\[1\].RAM16.SLICE\[0\].RAM8.WORD\[3\].W.BYTE\[2\].B.GCLK VGND
+ VGND VPWR VPWR SLICE_16\[1\].RAM16.SLICE\[0\].RAM8.WORD\[3\].W.BYTE\[2\].B.Q_WIRE\[3\]
+ sky130_fd_sc_hd__dlxtp_1
Xtap_11_13 VGND VPWR sky130_fd_sc_hd__tapvpwrvgnd_1
Xtap_11_24 VGND VPWR sky130_fd_sc_hd__tapvpwrvgnd_1
Xtap_11_35 VGND VPWR sky130_fd_sc_hd__tapvpwrvgnd_1
XSLICE_16\[1\].RAM16.SLICE\[0\].RAM8.WORD\[1\].W.BYTE\[0\].B.BIT\[2\].genblk1.STORAGE
+ DIBUF\[2\].X SLICE_16\[1\].RAM16.SLICE\[0\].RAM8.WORD\[1\].W.BYTE\[0\].B.GCLK VGND
+ VGND VPWR VPWR SLICE_16\[1\].RAM16.SLICE\[0\].RAM8.WORD\[1\].W.BYTE\[0\].B.Q_WIRE\[2\]
+ sky130_fd_sc_hd__dlxtp_1
XSLICE_16\[0\].RAM16.SLICE\[1\].RAM8.WORD\[5\].W.BYTE\[2\].B.BIT\[4\].genblk1.STORAGE
+ DIBUF\[20\].X SLICE_16\[0\].RAM16.SLICE\[1\].RAM8.WORD\[5\].W.BYTE\[2\].B.GCLK VGND
+ VGND VPWR VPWR SLICE_16\[0\].RAM16.SLICE\[1\].RAM8.WORD\[5\].W.BYTE\[2\].B.Q_WIRE\[4\]
+ sky130_fd_sc_hd__dlxtp_1
XSLICE_16\[0\].RAM16.SLICE\[1\].RAM8.WORD\[3\].W.BYTE\[0\].B.BIT\[3\].genblk1.STORAGE
+ DIBUF\[3\].X SLICE_16\[0\].RAM16.SLICE\[1\].RAM8.WORD\[3\].W.BYTE\[0\].B.GCLK VGND
+ VGND VPWR VPWR SLICE_16\[0\].RAM16.SLICE\[1\].RAM8.WORD\[3\].W.BYTE\[0\].B.Q_WIRE\[3\]
+ sky130_fd_sc_hd__dlxtp_1
XSLICE_16\[0\].RAM16.SLICE\[0\].RAM8.WORD\[1\].W.BYTE\[3\].B.BIT\[2\].OBUF0 SLICE_16\[0\].RAM16.SLICE\[0\].RAM8.WORD\[1\].W.BYTE\[3\].B.Q_WIRE\[2\]
+ SLICE_16\[0\].RAM16.SLICE\[0\].RAM8.WORD\[1\].W.BYTE\[3\].B.SEL0_B VGND VGND VPWR
+ VPWR SLICE_16\[0\].RAM16.BYTE\[3\].FLOATBUF0\[26\].Z sky130_fd_sc_hd__ebufn_2
Xtap_36_32 VGND VPWR sky130_fd_sc_hd__tapvpwrvgnd_1
Xtap_36_21 VGND VPWR sky130_fd_sc_hd__tapvpwrvgnd_1
Xtap_36_10 VGND VPWR sky130_fd_sc_hd__tapvpwrvgnd_1
Xtap_4_2 VGND VPWR sky130_fd_sc_hd__tapvpwrvgnd_1
Xtap_11_3 VGND VPWR sky130_fd_sc_hd__tapvpwrvgnd_1
XSLICE_16\[1\].RAM16.SLICE\[0\].RAM8.WORD\[1\].W.BYTE\[1\].B.genblk1.CG SLICE_16\[1\].RAM16.SLICE\[0\].RAM8.WORD\[1\].W.BYTE\[1\].B.CLK_B
+ SLICE_16\[1\].RAM16.SLICE\[0\].RAM8.WORD\[1\].W.BYTE\[1\].B.WE0_WIRE VGND VGND VPWR
+ VPWR SLICE_16\[1\].RAM16.SLICE\[0\].RAM8.WORD\[1\].W.BYTE\[1\].B.GCLK sky130_fd_sc_hd__dlclkp_1
XSLICE_16\[1\].RAM16.SLICE\[1\].RAM8.WORD\[0\].W.BYTE\[0\].B.BIT\[4\].OBUF0 SLICE_16\[1\].RAM16.SLICE\[1\].RAM8.WORD\[0\].W.BYTE\[0\].B.Q_WIRE\[4\]
+ SLICE_16\[1\].RAM16.SLICE\[1\].RAM8.WORD\[0\].W.BYTE\[0\].B.SEL0_B VGND VGND VPWR
+ VPWR SLICE_16\[1\].RAM16.BYTE\[0\].FLOATBUF0\[4\].Z sky130_fd_sc_hd__ebufn_2
XSLICE_16\[0\].RAM16.SLICE\[1\].RAM8.WORD\[5\].W.BYTE\[2\].B.BIT\[0\].OBUF0 SLICE_16\[0\].RAM16.SLICE\[1\].RAM8.WORD\[5\].W.BYTE\[2\].B.Q_WIRE\[0\]
+ SLICE_16\[0\].RAM16.SLICE\[1\].RAM8.WORD\[5\].W.BYTE\[2\].B.SEL0_B VGND VGND VPWR
+ VPWR SLICE_16\[0\].RAM16.BYTE\[2\].FLOATBUF0\[16\].Z sky130_fd_sc_hd__ebufn_2
XSLICE_16\[1\].RAM16.SLICE\[1\].RAM8.WORD\[4\].W.BYTE\[3\].B.BIT\[7\].OBUF0 SLICE_16\[1\].RAM16.SLICE\[1\].RAM8.WORD\[4\].W.BYTE\[3\].B.Q_WIRE\[7\]
+ SLICE_16\[1\].RAM16.SLICE\[1\].RAM8.WORD\[4\].W.BYTE\[3\].B.SEL0_B VGND VGND VPWR
+ VPWR SLICE_16\[1\].RAM16.BYTE\[3\].FLOATBUF0\[31\].Z sky130_fd_sc_hd__ebufn_2
Xfill_32_6 VGND VGND VPWR VPWR sky130_fd_sc_hd__fill_2
Xfill_25_5 VGND VGND VPWR VPWR sky130_fd_sc_hd__decap_6
Xfill_18_4 VGND VGND VPWR VPWR sky130_fd_sc_hd__decap_12
Xtap_3_16 VGND VPWR sky130_fd_sc_hd__tapvpwrvgnd_1
Xtap_3_27 VGND VPWR sky130_fd_sc_hd__tapvpwrvgnd_1
XSLICE_16\[0\].RAM16.SLICE\[1\].RAM8.WORD\[0\].W.BYTE\[3\].B.CGAND SLICE_16\[0\].RAM16.SLICE\[1\].RAM8.WORD\[0\].W.BYTE\[0\].B.SEL0
+ SLICE_16\[0\].RAM16.SLICE\[1\].RAM8.WE0_buf\[3\] VGND VGND VPWR VPWR SLICE_16\[0\].RAM16.SLICE\[1\].RAM8.WORD\[0\].W.BYTE\[3\].B.WE0_WIRE
+ sky130_fd_sc_hd__and2_1
Xfill_45_19 VGND VGND VPWR VPWR sky130_fd_sc_hd__decap_12
XSLICE_16\[0\].RAM16.SLICE\[0\].RAM8.WORD\[1\].W.BYTE\[1\].B.BIT\[7\].OBUF0 SLICE_16\[0\].RAM16.SLICE\[0\].RAM8.WORD\[1\].W.BYTE\[1\].B.Q_WIRE\[7\]
+ SLICE_16\[0\].RAM16.SLICE\[0\].RAM8.WORD\[1\].W.BYTE\[1\].B.SEL0_B VGND VGND VPWR
+ VPWR SLICE_16\[0\].RAM16.BYTE\[1\].FLOATBUF0\[15\].Z sky130_fd_sc_hd__ebufn_2
XSLICE_16\[1\].RAM16.SLICE\[1\].RAM8.WORD\[3\].W.BYTE\[1\].B.BIT\[4\].OBUF0 SLICE_16\[1\].RAM16.SLICE\[1\].RAM8.WORD\[3\].W.BYTE\[1\].B.Q_WIRE\[4\]
+ SLICE_16\[1\].RAM16.SLICE\[1\].RAM8.WORD\[3\].W.BYTE\[1\].B.SEL0_B VGND VGND VPWR
+ VPWR SLICE_16\[1\].RAM16.BYTE\[1\].FLOATBUF0\[12\].Z sky130_fd_sc_hd__ebufn_2
Xfill_21_104 VGND VGND VPWR VPWR sky130_fd_sc_hd__decap_6
XSLICE_16\[1\].RAM16.SLICE\[1\].RAM8.WORD\[5\].W.BYTE\[1\].B.BIT\[7\].genblk1.STORAGE
+ DIBUF\[15\].X SLICE_16\[1\].RAM16.SLICE\[1\].RAM8.WORD\[5\].W.BYTE\[1\].B.GCLK VGND
+ VGND VPWR VPWR SLICE_16\[1\].RAM16.SLICE\[1\].RAM8.WORD\[5\].W.BYTE\[1\].B.Q_WIRE\[7\]
+ sky130_fd_sc_hd__dlxtp_1
XSLICE_16\[1\].RAM16.SLICE\[0\].RAM8.WORD\[6\].W.BYTE\[3\].B.BIT\[3\].genblk1.STORAGE
+ DIBUF\[27\].X SLICE_16\[1\].RAM16.SLICE\[0\].RAM8.WORD\[6\].W.BYTE\[3\].B.GCLK VGND
+ VGND VPWR VPWR SLICE_16\[1\].RAM16.SLICE\[0\].RAM8.WORD\[6\].W.BYTE\[3\].B.Q_WIRE\[3\]
+ sky130_fd_sc_hd__dlxtp_1
XSLICE_16\[1\].RAM16.WEBUF\[1\].__cell__ SLICE_16\[0\].RAM16.WE0\[1\] VGND VGND VPWR
+ VPWR SLICE_16\[1\].RAM16.SLICE\[0\].RAM8.WE0\[1\] sky130_fd_sc_hd__clkbuf_2
XSLICE_16\[1\].RAM16.SLICE\[0\].RAM8.WORD\[4\].W.BYTE\[1\].B.BIT\[2\].genblk1.STORAGE
+ DIBUF\[10\].X SLICE_16\[1\].RAM16.SLICE\[0\].RAM8.WORD\[4\].W.BYTE\[1\].B.GCLK VGND
+ VGND VPWR VPWR SLICE_16\[1\].RAM16.SLICE\[0\].RAM8.WORD\[4\].W.BYTE\[1\].B.Q_WIRE\[2\]
+ sky130_fd_sc_hd__dlxtp_1
Xfill_19_97 VGND VGND VPWR VPWR sky130_fd_sc_hd__decap_12
Xfill_19_86 VGND VGND VPWR VPWR sky130_fd_sc_hd__decap_12
Xfill_19_75 VGND VPWR sky130_fd_sc_hd__tapvpwrvgnd_1
Xfill_19_64 VGND VGND VPWR VPWR sky130_fd_sc_hd__decap_12
Xfill_19_53 VGND VGND VPWR VPWR sky130_fd_sc_hd__decap_12
Xfill_19_42 VGND VPWR sky130_fd_sc_hd__tapvpwrvgnd_1
Xfill_19_31 VGND VGND VPWR VPWR sky130_fd_sc_hd__decap_12
Xfill_19_20 VGND VGND VPWR VPWR sky130_fd_sc_hd__decap_12
XSLICE_16\[0\].RAM16.SLICE\[1\].RAM8.WORD\[6\].W.BYTE\[1\].B.BIT\[3\].genblk1.STORAGE
+ DIBUF\[11\].X SLICE_16\[0\].RAM16.SLICE\[1\].RAM8.WORD\[6\].W.BYTE\[1\].B.GCLK VGND
+ VGND VPWR VPWR SLICE_16\[0\].RAM16.SLICE\[1\].RAM8.WORD\[6\].W.BYTE\[1\].B.Q_WIRE\[3\]
+ sky130_fd_sc_hd__dlxtp_1
XSLICE_16\[0\].RAM16.SLICE\[1\].RAM8.WORD\[5\].W.BYTE\[0\].B.BIT\[5\].OBUF0 SLICE_16\[0\].RAM16.SLICE\[1\].RAM8.WORD\[5\].W.BYTE\[0\].B.Q_WIRE\[5\]
+ SLICE_16\[0\].RAM16.SLICE\[1\].RAM8.WORD\[5\].W.BYTE\[0\].B.SEL0_B VGND VGND VPWR
+ VPWR SLICE_16\[0\].RAM16.BYTE\[0\].FLOATBUF0\[5\].Z sky130_fd_sc_hd__ebufn_2
XSLICE_16\[0\].RAM16.SLICE\[1\].RAM8.WORD\[0\].W.BYTE\[2\].B.BIT\[4\].genblk1.STORAGE
+ DIBUF\[20\].X SLICE_16\[0\].RAM16.SLICE\[1\].RAM8.WORD\[0\].W.BYTE\[2\].B.GCLK VGND
+ VGND VPWR VPWR SLICE_16\[0\].RAM16.SLICE\[1\].RAM8.WORD\[0\].W.BYTE\[2\].B.Q_WIRE\[4\]
+ sky130_fd_sc_hd__dlxtp_1
XSLICE_16\[1\].RAM16.SLICE\[0\].RAM8.WORD\[4\].W.BYTE\[0\].B.SEL0INV SLICE_16\[1\].RAM16.SLICE\[0\].RAM8.WORD\[4\].W.BYTE\[0\].B.SEL0
+ VGND VGND VPWR VPWR SLICE_16\[1\].RAM16.SLICE\[0\].RAM8.WORD\[4\].W.BYTE\[0\].B.SEL0_B
+ sky130_fd_sc_hd__inv_1
XSLICE_16\[1\].RAM16.SLICE\[0\].RAM8.WORD\[2\].W.BYTE\[3\].B.BIT\[6\].OBUF0 SLICE_16\[1\].RAM16.SLICE\[0\].RAM8.WORD\[2\].W.BYTE\[3\].B.Q_WIRE\[6\]
+ SLICE_16\[1\].RAM16.SLICE\[0\].RAM8.WORD\[2\].W.BYTE\[3\].B.SEL0_B VGND VGND VPWR
+ VPWR SLICE_16\[1\].RAM16.BYTE\[3\].FLOATBUF0\[30\].Z sky130_fd_sc_hd__ebufn_2
XSLICE_16\[0\].RAM16.Do0_REG.Do_CLKBUF\[1\] SLICE_16\[0\].RAM16.Do0_REG.CLK_buf VGND
+ VGND VPWR VPWR SLICE_16\[0\].RAM16.Do0_REG.CLKBUF\[1\] sky130_fd_sc_hd__clkbuf_4
XA0BUF\[3\].__cell__ A0[3] VGND VGND VPWR VPWR A0BUF\[3\].X sky130_fd_sc_hd__clkbuf_2
XSLICE_16\[1\].RAM16.SLICE\[1\].RAM8.WORD\[6\].W.BYTE\[1\].B.genblk1.CG SLICE_16\[1\].RAM16.SLICE\[1\].RAM8.WORD\[6\].W.BYTE\[1\].B.CLK_B
+ SLICE_16\[1\].RAM16.SLICE\[1\].RAM8.WORD\[6\].W.BYTE\[1\].B.WE0_WIRE VGND VGND VPWR
+ VPWR SLICE_16\[1\].RAM16.SLICE\[1\].RAM8.WORD\[6\].W.BYTE\[1\].B.GCLK sky130_fd_sc_hd__dlclkp_1
XSLICE_16\[1\].RAM16.SLICE\[1\].RAM8.WORD\[0\].W.CLKBUF SLICE_16\[1\].RAM16.SLICE\[1\].RAM8.CLKBUF.X
+ VGND VGND VPWR VPWR SLICE_16\[1\].RAM16.SLICE\[1\].RAM8.WORD\[0\].W.BYTE\[0\].B.CLK
+ sky130_fd_sc_hd__clkbuf_4
XDIBUF\[31\].__cell__ Di0[31] VGND VGND VPWR VPWR DIBUF\[31\].X sky130_fd_sc_hd__clkbuf_16
Xfill_30_3 VGND VPWR sky130_fd_sc_hd__tapvpwrvgnd_1
Xfill_23_2 VGND VPWR sky130_fd_sc_hd__tapvpwrvgnd_1
Xfill_16_1 VGND VPWR sky130_fd_sc_hd__tapvpwrvgnd_1
XSLICE_16\[0\].RAM16.SLICE\[0\].RAM8.WORD\[4\].W.BYTE\[2\].B.BIT\[7\].OBUF0 SLICE_16\[0\].RAM16.SLICE\[0\].RAM8.WORD\[4\].W.BYTE\[2\].B.Q_WIRE\[7\]
+ SLICE_16\[0\].RAM16.SLICE\[0\].RAM8.WORD\[4\].W.BYTE\[2\].B.SEL0_B VGND VGND VPWR
+ VPWR SLICE_16\[0\].RAM16.BYTE\[2\].FLOATBUF0\[23\].Z sky130_fd_sc_hd__ebufn_2
XSLICE_16\[1\].RAM16.SLICE\[1\].RAM8.WORD\[6\].W.BYTE\[2\].B.BIT\[4\].OBUF0 SLICE_16\[1\].RAM16.SLICE\[1\].RAM8.WORD\[6\].W.BYTE\[2\].B.Q_WIRE\[4\]
+ SLICE_16\[1\].RAM16.SLICE\[1\].RAM8.WORD\[6\].W.BYTE\[2\].B.SEL0_B VGND VGND VPWR
+ VPWR SLICE_16\[1\].RAM16.BYTE\[2\].FLOATBUF0\[20\].Z sky130_fd_sc_hd__ebufn_2
XSLICE_16\[0\].RAM16.SLICE\[1\].RAM8.WORD\[6\].W.BYTE\[2\].B.SEL0INV SLICE_16\[0\].RAM16.SLICE\[1\].RAM8.WORD\[6\].W.BYTE\[0\].B.SEL0
+ VGND VGND VPWR VPWR SLICE_16\[0\].RAM16.SLICE\[1\].RAM8.WORD\[6\].W.BYTE\[2\].B.SEL0_B
+ sky130_fd_sc_hd__inv_1
XSLICE_16\[0\].RAM16.SLICE\[0\].RAM8.WORD\[4\].W.BYTE\[0\].B.CGAND SLICE_16\[0\].RAM16.SLICE\[0\].RAM8.WORD\[4\].W.BYTE\[0\].B.SEL0
+ SLICE_16\[0\].RAM16.SLICE\[0\].RAM8.WE0_buf\[0\] VGND VGND VPWR VPWR SLICE_16\[0\].RAM16.SLICE\[0\].RAM8.WORD\[4\].W.BYTE\[0\].B.WE0_WIRE
+ sky130_fd_sc_hd__and2_1
Xtap_38_8 VGND VPWR sky130_fd_sc_hd__tapvpwrvgnd_1
XSLICE_16\[1\].RAM16.SLICE\[0\].RAM8.WORD\[4\].W.BYTE\[2\].B.DIODE_CLK SLICE_16\[1\].RAM16.SLICE\[0\].RAM8.WORD\[4\].W.BYTE\[0\].B.CLK
+ VGND VGND VPWR VPWR sky130_fd_sc_hd__diode_2
Xtap_33_11 VGND VPWR sky130_fd_sc_hd__tapvpwrvgnd_1
XSLICE_16\[1\].RAM16.Do0_REG.OUTREG_BYTE\[3\].Do_FF\[4\] SLICE_16\[1\].RAM16.Do0_REG.CLKBUF\[3\]
+ SLICE_16\[1\].RAM16.BYTE\[3\].FLOATBUF0\[28\].Z VGND VGND VPWR VPWR Do0MUX.A1\[28\]
+ sky130_fd_sc_hd__dfxtp_1
Xtap_33_33 VGND VPWR sky130_fd_sc_hd__tapvpwrvgnd_1
Xtap_33_22 VGND VPWR sky130_fd_sc_hd__tapvpwrvgnd_1
XSLICE_16\[1\].RAM16.SLICE\[0\].RAM8.WORD\[1\].W.BYTE\[1\].B.BIT\[3\].OBUF0 SLICE_16\[1\].RAM16.SLICE\[0\].RAM8.WORD\[1\].W.BYTE\[1\].B.Q_WIRE\[3\]
+ SLICE_16\[1\].RAM16.SLICE\[0\].RAM8.WORD\[1\].W.BYTE\[1\].B.SEL0_B VGND VGND VPWR
+ VPWR SLICE_16\[1\].RAM16.BYTE\[1\].FLOATBUF0\[11\].Z sky130_fd_sc_hd__ebufn_2
XSLICE_16\[0\].RAM16.SLICE\[0\].RAM8.WORD\[2\].W.BYTE\[1\].B.SEL0INV SLICE_16\[0\].RAM16.SLICE\[0\].RAM8.WORD\[2\].W.BYTE\[0\].B.SEL0
+ VGND VGND VPWR VPWR SLICE_16\[0\].RAM16.SLICE\[0\].RAM8.WORD\[2\].W.BYTE\[1\].B.SEL0_B
+ sky130_fd_sc_hd__inv_1
Xfill_21_98 VGND VGND VPWR VPWR sky130_fd_sc_hd__decap_12
Xfill_21_87 VGND VPWR sky130_fd_sc_hd__tapvpwrvgnd_1
Xfill_21_76 VGND VGND VPWR VPWR sky130_fd_sc_hd__decap_12
Xfill_21_65 VGND VGND VPWR VPWR sky130_fd_sc_hd__decap_12
Xfill_21_54 VGND VPWR sky130_fd_sc_hd__tapvpwrvgnd_1
Xfill_21_43 VGND VGND VPWR VPWR sky130_fd_sc_hd__decap_12
Xfill_21_32 VGND VGND VPWR VPWR sky130_fd_sc_hd__decap_12
Xfill_21_21 VGND VPWR sky130_fd_sc_hd__tapvpwrvgnd_1
Xfill_21_10 VGND VGND VPWR VPWR sky130_fd_sc_hd__decap_12
XSLICE_16\[0\].RAM16.SLICE\[0\].RAM8.WORD\[3\].W.BYTE\[0\].B.BIT\[4\].OBUF0 SLICE_16\[0\].RAM16.SLICE\[0\].RAM8.WORD\[3\].W.BYTE\[0\].B.Q_WIRE\[4\]
+ SLICE_16\[0\].RAM16.SLICE\[0\].RAM8.WORD\[3\].W.BYTE\[0\].B.SEL0_B VGND VGND VPWR
+ VPWR SLICE_16\[0\].RAM16.BYTE\[0\].FLOATBUF0\[4\].Z sky130_fd_sc_hd__ebufn_2
XSLICE_16\[0\].RAM16.SLICE\[0\].RAM8.WORD\[7\].W.BYTE\[1\].B.DIODE_CLK SLICE_16\[0\].RAM16.SLICE\[0\].RAM8.WORD\[7\].W.BYTE\[0\].B.CLK
+ VGND VGND VPWR VPWR sky130_fd_sc_hd__diode_2
XSLICE_16\[0\].RAM16.SLICE\[1\].RAM8.WORD\[1\].W.BYTE\[2\].B.DIODE_CLK SLICE_16\[0\].RAM16.SLICE\[1\].RAM8.WORD\[1\].W.BYTE\[0\].B.CLK
+ VGND VGND VPWR VPWR sky130_fd_sc_hd__diode_2
Xfill_46_95 VGND VGND VPWR VPWR sky130_fd_sc_hd__decap_12
Xfill_46_84 VGND VPWR sky130_fd_sc_hd__tapvpwrvgnd_1
Xfill_46_73 VGND VPWR sky130_fd_sc_hd__tapvpwrvgnd_1
Xfill_46_62 VGND VGND VPWR VPWR sky130_fd_sc_hd__decap_4
Xfill_46_51 VGND VGND VPWR VPWR sky130_fd_sc_hd__decap_4
Xfill_46_40 VGND VPWR sky130_fd_sc_hd__tapvpwrvgnd_1
XSLICE_16\[1\].RAM16.SLICE\[1\].RAM8.WORD\[5\].W.BYTE\[0\].B.BIT\[1\].OBUF0 SLICE_16\[1\].RAM16.SLICE\[1\].RAM8.WORD\[5\].W.BYTE\[0\].B.Q_WIRE\[1\]
+ SLICE_16\[1\].RAM16.SLICE\[1\].RAM8.WORD\[5\].W.BYTE\[0\].B.SEL0_B VGND VGND VPWR
+ VPWR SLICE_16\[1\].RAM16.BYTE\[0\].FLOATBUF0\[1\].Z sky130_fd_sc_hd__ebufn_2
XSLICE_16\[0\].RAM16.SLICE\[0\].RAM8.WORD\[7\].W.BYTE\[3\].B.BIT\[7\].OBUF0 SLICE_16\[0\].RAM16.SLICE\[0\].RAM8.WORD\[7\].W.BYTE\[3\].B.Q_WIRE\[7\]
+ SLICE_16\[0\].RAM16.SLICE\[0\].RAM8.WORD\[7\].W.BYTE\[3\].B.SEL0_B VGND VGND VPWR
+ VPWR SLICE_16\[0\].RAM16.BYTE\[3\].FLOATBUF0\[31\].Z sky130_fd_sc_hd__ebufn_2
XSLICE_16\[1\].RAM16.BYTE\[0\].FLOATBUF0\[2\].__cell__ SLICE_16\[1\].RAM16.BYTE\[0\].FLOATBUF0\[0\].A
+ SLICE_16\[1\].RAM16.BYTE\[0\].FLOATBUF0\[0\].TE_B VGND VGND VPWR VPWR SLICE_16\[1\].RAM16.BYTE\[0\].FLOATBUF0\[2\].Z
+ sky130_fd_sc_hd__ebufn_2
XSLICE_16\[1\].RAM16.SLICE\[1\].RAM8.WORD\[6\].W.BYTE\[0\].B.BIT\[6\].genblk1.STORAGE
+ DIBUF\[6\].X SLICE_16\[1\].RAM16.SLICE\[1\].RAM8.WORD\[6\].W.BYTE\[0\].B.GCLK VGND
+ VGND VPWR VPWR SLICE_16\[1\].RAM16.SLICE\[1\].RAM8.WORD\[6\].W.BYTE\[0\].B.Q_WIRE\[6\]
+ sky130_fd_sc_hd__dlxtp_1
XSLICE_16\[1\].RAM16.SLICE\[1\].RAM8.WORD\[0\].W.BYTE\[1\].B.BIT\[7\].genblk1.STORAGE
+ DIBUF\[15\].X SLICE_16\[1\].RAM16.SLICE\[1\].RAM8.WORD\[0\].W.BYTE\[1\].B.GCLK VGND
+ VGND VPWR VPWR SLICE_16\[1\].RAM16.SLICE\[1\].RAM8.WORD\[0\].W.BYTE\[1\].B.Q_WIRE\[7\]
+ sky130_fd_sc_hd__dlxtp_1
XSLICE_16\[1\].RAM16.SLICE\[0\].RAM8.WORD\[7\].W.BYTE\[2\].B.BIT\[2\].genblk1.STORAGE
+ DIBUF\[18\].X SLICE_16\[1\].RAM16.SLICE\[0\].RAM8.WORD\[7\].W.BYTE\[2\].B.GCLK VGND
+ VGND VPWR VPWR SLICE_16\[1\].RAM16.SLICE\[0\].RAM8.WORD\[7\].W.BYTE\[2\].B.Q_WIRE\[2\]
+ sky130_fd_sc_hd__dlxtp_1
XSLICE_16\[1\].RAM16.SLICE\[0\].RAM8.WORD\[1\].W.BYTE\[3\].B.BIT\[3\].genblk1.STORAGE
+ DIBUF\[27\].X SLICE_16\[1\].RAM16.SLICE\[0\].RAM8.WORD\[1\].W.BYTE\[3\].B.GCLK VGND
+ VGND VPWR VPWR SLICE_16\[1\].RAM16.SLICE\[0\].RAM8.WORD\[1\].W.BYTE\[3\].B.Q_WIRE\[3\]
+ sky130_fd_sc_hd__dlxtp_1
XSLICE_16\[1\].RAM16.SLICE\[0\].RAM8.WORD\[5\].W.BYTE\[0\].B.BIT\[1\].genblk1.STORAGE
+ DIBUF\[1\].X SLICE_16\[1\].RAM16.SLICE\[0\].RAM8.WORD\[5\].W.BYTE\[0\].B.GCLK VGND
+ VGND VPWR VPWR SLICE_16\[1\].RAM16.SLICE\[0\].RAM8.WORD\[5\].W.BYTE\[0\].B.Q_WIRE\[1\]
+ sky130_fd_sc_hd__dlxtp_1
XSLICE_16\[1\].RAM16.SLICE\[0\].RAM8.WORD\[4\].W.BYTE\[2\].B.BIT\[3\].OBUF0 SLICE_16\[1\].RAM16.SLICE\[0\].RAM8.WORD\[4\].W.BYTE\[2\].B.Q_WIRE\[3\]
+ SLICE_16\[1\].RAM16.SLICE\[0\].RAM8.WORD\[4\].W.BYTE\[2\].B.SEL0_B VGND VGND VPWR
+ VPWR SLICE_16\[1\].RAM16.BYTE\[2\].FLOATBUF0\[19\].Z sky130_fd_sc_hd__ebufn_2
XSLICE_16\[0\].RAM16.SLICE\[1\].RAM8.WORD\[3\].W.BYTE\[3\].B.BIT\[4\].genblk1.STORAGE
+ DIBUF\[28\].X SLICE_16\[0\].RAM16.SLICE\[1\].RAM8.WORD\[3\].W.BYTE\[3\].B.GCLK VGND
+ VGND VPWR VPWR SLICE_16\[0\].RAM16.SLICE\[1\].RAM8.WORD\[3\].W.BYTE\[3\].B.Q_WIRE\[4\]
+ sky130_fd_sc_hd__dlxtp_1
Xtap_0_28 VGND VPWR sky130_fd_sc_hd__tapvpwrvgnd_1
Xtap_0_17 VGND VPWR sky130_fd_sc_hd__tapvpwrvgnd_1
XDo0MUX.M\[1\].MUX\[0\] Do0MUX.A0\[8\] Do0MUX.A1\[8\] Do0MUX.SEL\[1\] VGND VGND VPWR
+ VPWR Do0[8] sky130_fd_sc_hd__mux2_1
XSLICE_16\[0\].RAM16.SLICE\[1\].RAM8.WORD\[7\].W.BYTE\[0\].B.BIT\[2\].genblk1.STORAGE
+ DIBUF\[2\].X SLICE_16\[0\].RAM16.SLICE\[1\].RAM8.WORD\[7\].W.BYTE\[0\].B.GCLK VGND
+ VGND VPWR VPWR SLICE_16\[0\].RAM16.SLICE\[1\].RAM8.WORD\[7\].W.BYTE\[0\].B.Q_WIRE\[2\]
+ sky130_fd_sc_hd__dlxtp_1
Xtap_9_15 VGND VPWR sky130_fd_sc_hd__tapvpwrvgnd_1
Xtap_9_26 VGND VPWR sky130_fd_sc_hd__tapvpwrvgnd_1
Xtap_9_37 VGND VPWR sky130_fd_sc_hd__tapvpwrvgnd_1
XSLICE_16\[0\].RAM16.SLICE\[1\].RAM8.WORD\[1\].W.BYTE\[1\].B.BIT\[3\].genblk1.STORAGE
+ DIBUF\[11\].X SLICE_16\[0\].RAM16.SLICE\[1\].RAM8.WORD\[1\].W.BYTE\[1\].B.GCLK VGND
+ VGND VPWR VPWR SLICE_16\[0\].RAM16.SLICE\[1\].RAM8.WORD\[1\].W.BYTE\[1\].B.Q_WIRE\[3\]
+ sky130_fd_sc_hd__dlxtp_1
XSLICE_16\[1\].RAM16.Do0_REG.OUTREG_BYTE\[0\].DIODE\[7\] SLICE_16\[1\].RAM16.BYTE\[0\].FLOATBUF0\[7\].Z
+ VGND VGND VPWR VPWR sky130_fd_sc_hd__diode_2
Xtap_36_5 VGND VPWR sky130_fd_sc_hd__tapvpwrvgnd_1
Xtap_29_4 VGND VPWR sky130_fd_sc_hd__tapvpwrvgnd_1
Xtap_28_33 VGND VPWR sky130_fd_sc_hd__tapvpwrvgnd_1
Xtap_28_22 VGND VPWR sky130_fd_sc_hd__tapvpwrvgnd_1
Xtap_28_11 VGND VPWR sky130_fd_sc_hd__tapvpwrvgnd_1
XSLICE_16\[0\].RAM16.SLICE\[0\].RAM8.WORD\[6\].W.BYTE\[1\].B.BIT\[4\].OBUF0 SLICE_16\[0\].RAM16.SLICE\[0\].RAM8.WORD\[6\].W.BYTE\[1\].B.Q_WIRE\[4\]
+ SLICE_16\[0\].RAM16.SLICE\[0\].RAM8.WORD\[6\].W.BYTE\[1\].B.SEL0_B VGND VGND VPWR
+ VPWR SLICE_16\[0\].RAM16.BYTE\[1\].FLOATBUF0\[12\].Z sky130_fd_sc_hd__ebufn_2
XSLICE_16\[0\].RAM16.BYTE\[2\].FLOATBUF0\[19\].__cell__ SLICE_16\[0\].RAM16.BYTE\[2\].FLOATBUF0\[16\].A
+ SLICE_16\[0\].RAM16.BYTE\[2\].FLOATBUF0\[16\].TE_B VGND VGND VPWR VPWR SLICE_16\[0\].RAM16.BYTE\[2\].FLOATBUF0\[19\].Z
+ sky130_fd_sc_hd__ebufn_2
XDo0MUX.M\[0\].MUX\[2\] Do0MUX.A0\[2\] Do0MUX.A1\[2\] Do0MUX.SEL\[0\] VGND VGND VPWR
+ VPWR Do0[2] sky130_fd_sc_hd__mux2_1
XSLICE_16\[1\].RAM16.SLICE\[0\].RAM8.WORD\[3\].W.BYTE\[0\].B.BIT\[0\].OBUF0 SLICE_16\[1\].RAM16.SLICE\[0\].RAM8.WORD\[3\].W.BYTE\[0\].B.Q_WIRE\[0\]
+ SLICE_16\[1\].RAM16.SLICE\[0\].RAM8.WORD\[3\].W.BYTE\[0\].B.SEL0_B VGND VGND VPWR
+ VPWR SLICE_16\[1\].RAM16.BYTE\[0\].FLOATBUF0\[0\].Z sky130_fd_sc_hd__ebufn_2
XSLICE_16\[0\].RAM16.SLICE\[0\].RAM8.WORD\[0\].W.BYTE\[1\].B.genblk1.CG SLICE_16\[0\].RAM16.SLICE\[0\].RAM8.WORD\[0\].W.BYTE\[1\].B.CLK_B
+ SLICE_16\[0\].RAM16.SLICE\[0\].RAM8.WORD\[0\].W.BYTE\[1\].B.WE0_WIRE VGND VGND VPWR
+ VPWR SLICE_16\[0\].RAM16.SLICE\[0\].RAM8.WORD\[0\].W.BYTE\[1\].B.GCLK sky130_fd_sc_hd__dlclkp_1
XSLICE_16\[1\].RAM16.SLICE\[0\].RAM8.WORD\[7\].W.BYTE\[3\].B.BIT\[3\].OBUF0 SLICE_16\[1\].RAM16.SLICE\[0\].RAM8.WORD\[7\].W.BYTE\[3\].B.Q_WIRE\[3\]
+ SLICE_16\[1\].RAM16.SLICE\[0\].RAM8.WORD\[7\].W.BYTE\[3\].B.SEL0_B VGND VGND VPWR
+ VPWR SLICE_16\[1\].RAM16.BYTE\[3\].FLOATBUF0\[27\].Z sky130_fd_sc_hd__ebufn_2
XSLICE_16\[0\].RAM16.Do0_REG.OUTREG_BYTE\[2\].DIODE\[4\] SLICE_16\[0\].RAM16.BYTE\[2\].FLOATBUF0\[20\].Z
+ VGND VGND VPWR VPWR sky130_fd_sc_hd__diode_2
XSLICE_16\[0\].RAM16.SLICE\[1\].RAM8.WORD\[1\].W.BYTE\[2\].B.BIT\[7\].OBUF0 SLICE_16\[0\].RAM16.SLICE\[1\].RAM8.WORD\[1\].W.BYTE\[2\].B.Q_WIRE\[7\]
+ SLICE_16\[0\].RAM16.SLICE\[1\].RAM8.WORD\[1\].W.BYTE\[2\].B.SEL0_B VGND VGND VPWR
+ VPWR SLICE_16\[0\].RAM16.BYTE\[2\].FLOATBUF0\[23\].Z sky130_fd_sc_hd__ebufn_2
XSLICE_16\[0\].RAM16.FBUFENBUF0\[1\].__cell__ DEC0.SEL\[0\] VGND VGND VPWR VPWR SLICE_16\[0\].RAM16.BYTE\[1\].FLOATBUF0\[10\].TE_B
+ sky130_fd_sc_hd__clkbuf_2
XSLICE_16\[1\].RAM16.SLICE\[1\].RAM8.WORD\[6\].W.BYTE\[2\].B.DIODE_CLK SLICE_16\[1\].RAM16.SLICE\[1\].RAM8.WORD\[6\].W.BYTE\[0\].B.CLK
+ VGND VGND VPWR VPWR sky130_fd_sc_hd__diode_2
XSLICE_16\[1\].RAM16.SLICE\[1\].RAM8.WORD\[4\].W.BYTE\[2\].B.SEL0INV SLICE_16\[1\].RAM16.SLICE\[1\].RAM8.WORD\[4\].W.BYTE\[0\].B.SEL0
+ VGND VGND VPWR VPWR SLICE_16\[1\].RAM16.SLICE\[1\].RAM8.WORD\[4\].W.BYTE\[2\].B.SEL0_B
+ sky130_fd_sc_hd__inv_1
XSLICE_16\[1\].RAM16.SLICE\[1\].RAM8.WORD\[3\].W.BYTE\[2\].B.BIT\[7\].genblk1.STORAGE
+ DIBUF\[23\].X SLICE_16\[1\].RAM16.SLICE\[1\].RAM8.WORD\[3\].W.BYTE\[2\].B.GCLK VGND
+ VGND VPWR VPWR SLICE_16\[1\].RAM16.SLICE\[1\].RAM8.WORD\[3\].W.BYTE\[2\].B.Q_WIRE\[7\]
+ sky130_fd_sc_hd__dlxtp_1
Xtap_14_35 VGND VPWR sky130_fd_sc_hd__tapvpwrvgnd_1
Xtap_14_24 VGND VPWR sky130_fd_sc_hd__tapvpwrvgnd_1
Xtap_14_13 VGND VPWR sky130_fd_sc_hd__tapvpwrvgnd_1
Xtap_8_9 VGND VPWR sky130_fd_sc_hd__tapvpwrvgnd_1
XSLICE_16\[1\].RAM16.SLICE\[1\].RAM8.WORD\[1\].W.BYTE\[0\].B.BIT\[6\].genblk1.STORAGE
+ DIBUF\[6\].X SLICE_16\[1\].RAM16.SLICE\[1\].RAM8.WORD\[1\].W.BYTE\[0\].B.GCLK VGND
+ VGND VPWR VPWR SLICE_16\[1\].RAM16.SLICE\[1\].RAM8.WORD\[1\].W.BYTE\[0\].B.Q_WIRE\[6\]
+ sky130_fd_sc_hd__dlxtp_1
Xtap_30_34 VGND VPWR sky130_fd_sc_hd__tapvpwrvgnd_1
Xtap_30_23 VGND VPWR sky130_fd_sc_hd__tapvpwrvgnd_1
Xtap_30_12 VGND VPWR sky130_fd_sc_hd__tapvpwrvgnd_1
Xtap_39_10 VGND VPWR sky130_fd_sc_hd__tapvpwrvgnd_1
Xtap_34_2 VGND VPWR sky130_fd_sc_hd__tapvpwrvgnd_1
XSLICE_16\[1\].RAM16.SLICE\[0\].RAM8.WORD\[6\].W.BYTE\[1\].B.BIT\[0\].OBUF0 SLICE_16\[1\].RAM16.SLICE\[0\].RAM8.WORD\[6\].W.BYTE\[1\].B.Q_WIRE\[0\]
+ SLICE_16\[1\].RAM16.SLICE\[0\].RAM8.WORD\[6\].W.BYTE\[1\].B.SEL0_B VGND VGND VPWR
+ VPWR SLICE_16\[1\].RAM16.BYTE\[1\].FLOATBUF0\[8\].Z sky130_fd_sc_hd__ebufn_2
Xtap_27_1 VGND VPWR sky130_fd_sc_hd__tapvpwrvgnd_1
XSLICE_16\[1\].RAM16.SLICE\[0\].RAM8.WORD\[2\].W.BYTE\[2\].B.BIT\[2\].genblk1.STORAGE
+ DIBUF\[18\].X SLICE_16\[1\].RAM16.SLICE\[0\].RAM8.WORD\[2\].W.BYTE\[2\].B.GCLK VGND
+ VGND VPWR VPWR SLICE_16\[1\].RAM16.SLICE\[0\].RAM8.WORD\[2\].W.BYTE\[2\].B.Q_WIRE\[2\]
+ sky130_fd_sc_hd__dlxtp_1
XSLICE_16\[1\].RAM16.SLICE\[0\].RAM8.WORD\[0\].W.BYTE\[1\].B.SEL0INV SLICE_16\[1\].RAM16.SLICE\[0\].RAM8.WORD\[0\].W.BYTE\[0\].B.SEL0
+ VGND VGND VPWR VPWR SLICE_16\[1\].RAM16.SLICE\[0\].RAM8.WORD\[0\].W.BYTE\[1\].B.SEL0_B
+ sky130_fd_sc_hd__inv_1
XSLICE_16\[1\].RAM16.SLICE\[0\].RAM8.WORD\[0\].W.BYTE\[0\].B.BIT\[1\].genblk1.STORAGE
+ DIBUF\[1\].X SLICE_16\[1\].RAM16.SLICE\[0\].RAM8.WORD\[0\].W.BYTE\[0\].B.GCLK VGND
+ VGND VPWR VPWR SLICE_16\[1\].RAM16.SLICE\[0\].RAM8.WORD\[0\].W.BYTE\[0\].B.Q_WIRE\[1\]
+ sky130_fd_sc_hd__dlxtp_1
XSLICE_16\[0\].RAM16.SLICE\[1\].RAM8.WORD\[4\].W.BYTE\[2\].B.BIT\[3\].genblk1.STORAGE
+ DIBUF\[19\].X SLICE_16\[0\].RAM16.SLICE\[1\].RAM8.WORD\[4\].W.BYTE\[2\].B.GCLK VGND
+ VGND VPWR VPWR SLICE_16\[0\].RAM16.SLICE\[1\].RAM8.WORD\[4\].W.BYTE\[2\].B.Q_WIRE\[3\]
+ sky130_fd_sc_hd__dlxtp_1
Xfill_43_41 VGND VGND VPWR VPWR sky130_fd_sc_hd__decap_12
Xfill_43_30 VGND VPWR sky130_fd_sc_hd__tapvpwrvgnd_1
XSLICE_16\[1\].RAM16.SLICE\[0\].RAM8.WORD\[6\].W.BYTE\[3\].B.CGAND SLICE_16\[1\].RAM16.SLICE\[0\].RAM8.WORD\[6\].W.BYTE\[0\].B.SEL0
+ SLICE_16\[1\].RAM16.SLICE\[0\].RAM8.WE0_buf\[3\] VGND VGND VPWR VPWR SLICE_16\[1\].RAM16.SLICE\[0\].RAM8.WORD\[6\].W.BYTE\[3\].B.WE0_WIRE
+ sky130_fd_sc_hd__and2_1
XSLICE_16\[0\].RAM16.SLICE\[1\].RAM8.WORD\[0\].W.BYTE\[0\].B.BIT\[4\].OBUF0 SLICE_16\[0\].RAM16.SLICE\[1\].RAM8.WORD\[0\].W.BYTE\[0\].B.Q_WIRE\[4\]
+ SLICE_16\[0\].RAM16.SLICE\[1\].RAM8.WORD\[0\].W.BYTE\[0\].B.SEL0_B VGND VGND VPWR
+ VPWR SLICE_16\[0\].RAM16.BYTE\[0\].FLOATBUF0\[4\].Z sky130_fd_sc_hd__ebufn_2
XSLICE_16\[0\].RAM16.SLICE\[1\].RAM8.WORD\[2\].W.BYTE\[0\].B.BIT\[2\].genblk1.STORAGE
+ DIBUF\[2\].X SLICE_16\[0\].RAM16.SLICE\[1\].RAM8.WORD\[2\].W.BYTE\[0\].B.GCLK VGND
+ VGND VPWR VPWR SLICE_16\[0\].RAM16.SLICE\[1\].RAM8.WORD\[2\].W.BYTE\[0\].B.Q_WIRE\[2\]
+ sky130_fd_sc_hd__dlxtp_1
Xfill_43_96 VGND VPWR sky130_fd_sc_hd__tapvpwrvgnd_1
Xfill_43_85 VGND VGND VPWR VPWR sky130_fd_sc_hd__decap_12
Xfill_43_74 VGND VGND VPWR VPWR sky130_fd_sc_hd__decap_12
Xfill_43_63 VGND VPWR sky130_fd_sc_hd__tapvpwrvgnd_1
Xfill_43_52 VGND VGND VPWR VPWR sky130_fd_sc_hd__decap_12
XSLICE_16\[0\].RAM16.SLICE\[1\].RAM8.WORD\[4\].W.BYTE\[3\].B.BIT\[7\].OBUF0 SLICE_16\[0\].RAM16.SLICE\[1\].RAM8.WORD\[4\].W.BYTE\[3\].B.Q_WIRE\[7\]
+ SLICE_16\[0\].RAM16.SLICE\[1\].RAM8.WORD\[4\].W.BYTE\[3\].B.SEL0_B VGND VGND VPWR
+ VPWR SLICE_16\[0\].RAM16.BYTE\[3\].FLOATBUF0\[31\].Z sky130_fd_sc_hd__ebufn_2
XSLICE_16\[0\].RAM16.Do0_REG.OUTREG_BYTE\[1\].Do_FF\[5\] SLICE_16\[0\].RAM16.Do0_REG.CLKBUF\[1\]
+ SLICE_16\[0\].RAM16.BYTE\[1\].FLOATBUF0\[13\].Z VGND VGND VPWR VPWR Do0MUX.A0\[13\]
+ sky130_fd_sc_hd__dfxtp_1
XSLICE_16\[0\].RAM16.SLICE\[1\].RAM8.WORD\[2\].W.BYTE\[3\].B.SEL0INV SLICE_16\[0\].RAM16.SLICE\[1\].RAM8.WORD\[2\].W.BYTE\[0\].B.SEL0
+ VGND VGND VPWR VPWR SLICE_16\[0\].RAM16.SLICE\[1\].RAM8.WORD\[2\].W.BYTE\[3\].B.SEL0_B
+ sky130_fd_sc_hd__inv_1
Xfill_3_4 VGND VPWR sky130_fd_sc_hd__tapvpwrvgnd_1
XDo0MUX.M\[3\].MUX\[7\] Do0MUX.A0\[31\] Do0MUX.A1\[31\] Do0MUX.SEL\[3\] VGND VGND
+ VPWR VPWR Do0[31] sky130_fd_sc_hd__mux2_1
XSLICE_16\[0\].RAM16.BYTE\[1\].FLOATBUF0\[10\].__cell__ SLICE_16\[0\].RAM16.BYTE\[1\].FLOATBUF0\[10\].A
+ SLICE_16\[0\].RAM16.BYTE\[1\].FLOATBUF0\[10\].TE_B VGND VGND VPWR VPWR SLICE_16\[0\].RAM16.BYTE\[1\].FLOATBUF0\[10\].Z
+ sky130_fd_sc_hd__ebufn_2
XSLICE_16\[0\].RAM16.SLICE\[1\].RAM8.WORD\[5\].W.BYTE\[1\].B.genblk1.CG SLICE_16\[0\].RAM16.SLICE\[1\].RAM8.WORD\[5\].W.BYTE\[1\].B.CLK_B
+ SLICE_16\[0\].RAM16.SLICE\[1\].RAM8.WORD\[5\].W.BYTE\[1\].B.WE0_WIRE VGND VGND VPWR
+ VPWR SLICE_16\[0\].RAM16.SLICE\[1\].RAM8.WORD\[5\].W.BYTE\[1\].B.GCLK sky130_fd_sc_hd__dlclkp_1
Xtap_6_16 VGND VPWR sky130_fd_sc_hd__tapvpwrvgnd_1
Xtap_6_27 VGND VPWR sky130_fd_sc_hd__tapvpwrvgnd_1
XSLICE_16\[1\].RAM16.SLICE\[1\].RAM8.WORD\[1\].W.BYTE\[2\].B.BIT\[3\].OBUF0 SLICE_16\[1\].RAM16.SLICE\[1\].RAM8.WORD\[1\].W.BYTE\[2\].B.Q_WIRE\[3\]
+ SLICE_16\[1\].RAM16.SLICE\[1\].RAM8.WORD\[1\].W.BYTE\[2\].B.SEL0_B VGND VGND VPWR
+ VPWR SLICE_16\[1\].RAM16.BYTE\[2\].FLOATBUF0\[19\].Z sky130_fd_sc_hd__ebufn_2
Xtap_25_12 VGND VPWR sky130_fd_sc_hd__tapvpwrvgnd_1
Xtap_13_7 VGND VPWR sky130_fd_sc_hd__tapvpwrvgnd_1
Xtap_25_34 VGND VPWR sky130_fd_sc_hd__tapvpwrvgnd_1
Xtap_25_23 VGND VPWR sky130_fd_sc_hd__tapvpwrvgnd_1
XSLICE_16\[0\].RAM16.SLICE\[1\].RAM8.WORD\[3\].W.BYTE\[1\].B.BIT\[4\].OBUF0 SLICE_16\[0\].RAM16.SLICE\[1\].RAM8.WORD\[3\].W.BYTE\[1\].B.Q_WIRE\[4\]
+ SLICE_16\[0\].RAM16.SLICE\[1\].RAM8.WORD\[3\].W.BYTE\[1\].B.SEL0_B VGND VGND VPWR
+ VPWR SLICE_16\[0\].RAM16.BYTE\[1\].FLOATBUF0\[12\].Z sky130_fd_sc_hd__ebufn_2
Xtap_6_6 VGND VPWR sky130_fd_sc_hd__tapvpwrvgnd_1
XSLICE_16\[1\].RAM16.SLICE\[1\].RAM8.WORD\[6\].W.BYTE\[3\].B.BIT\[7\].genblk1.STORAGE
+ DIBUF\[31\].X SLICE_16\[1\].RAM16.SLICE\[1\].RAM8.WORD\[6\].W.BYTE\[3\].B.GCLK VGND
+ VGND VPWR VPWR SLICE_16\[1\].RAM16.SLICE\[1\].RAM8.WORD\[6\].W.BYTE\[3\].B.Q_WIRE\[7\]
+ sky130_fd_sc_hd__dlxtp_1
XSLICE_16\[1\].RAM16.SLICE\[1\].RAM8.WORD\[4\].W.BYTE\[1\].B.BIT\[6\].genblk1.STORAGE
+ DIBUF\[14\].X SLICE_16\[1\].RAM16.SLICE\[1\].RAM8.WORD\[4\].W.BYTE\[1\].B.GCLK VGND
+ VGND VPWR VPWR SLICE_16\[1\].RAM16.SLICE\[1\].RAM8.WORD\[4\].W.BYTE\[1\].B.Q_WIRE\[6\]
+ sky130_fd_sc_hd__dlxtp_1
XSLICE_16\[1\].RAM16.SLICE\[1\].RAM8.WORD\[2\].W.BYTE\[0\].B.genblk1.CG SLICE_16\[1\].RAM16.SLICE\[1\].RAM8.WORD\[2\].W.BYTE\[0\].B.CLK_B
+ SLICE_16\[1\].RAM16.SLICE\[1\].RAM8.WORD\[2\].W.BYTE\[0\].B.WE0_WIRE VGND VGND VPWR
+ VPWR SLICE_16\[1\].RAM16.SLICE\[1\].RAM8.WORD\[2\].W.BYTE\[0\].B.GCLK sky130_fd_sc_hd__dlclkp_1
XSLICE_16\[0\].RAM16.SLICE\[0\].RAM8.WORD\[2\].W.BYTE\[3\].B.BIT\[6\].OBUF0 SLICE_16\[0\].RAM16.SLICE\[0\].RAM8.WORD\[2\].W.BYTE\[3\].B.Q_WIRE\[6\]
+ SLICE_16\[0\].RAM16.SLICE\[0\].RAM8.WORD\[2\].W.BYTE\[3\].B.SEL0_B VGND VGND VPWR
+ VPWR SLICE_16\[0\].RAM16.BYTE\[3\].FLOATBUF0\[30\].Z sky130_fd_sc_hd__ebufn_2
Xfill_42_102 VGND VPWR sky130_fd_sc_hd__tapvpwrvgnd_1
XSLICE_16\[1\].RAM16.SLICE\[1\].RAM8.WORD\[7\].W.BYTE\[2\].B.CGAND SLICE_16\[1\].RAM16.SLICE\[1\].RAM8.WORD\[7\].W.BYTE\[0\].B.SEL0
+ SLICE_16\[1\].RAM16.SLICE\[1\].RAM8.WE0_buf\[2\] VGND VGND VPWR VPWR SLICE_16\[1\].RAM16.SLICE\[1\].RAM8.WORD\[7\].W.BYTE\[2\].B.WE0_WIRE
+ sky130_fd_sc_hd__and2_1
XSLICE_16\[1\].RAM16.SLICE\[1\].RAM8.WORD\[5\].W.BYTE\[0\].B.genblk1.CLKINV SLICE_16\[1\].RAM16.SLICE\[1\].RAM8.WORD\[5\].W.BYTE\[0\].B.CLK
+ VGND VGND VPWR VPWR SLICE_16\[1\].RAM16.SLICE\[1\].RAM8.WORD\[5\].W.BYTE\[0\].B.CLK_B
+ sky130_fd_sc_hd__inv_1
XSLICE_16\[1\].RAM16.SLICE\[1\].RAM8.WORD\[0\].W.BYTE\[0\].B.BIT\[0\].OBUF0 SLICE_16\[1\].RAM16.SLICE\[1\].RAM8.WORD\[0\].W.BYTE\[0\].B.Q_WIRE\[0\]
+ SLICE_16\[1\].RAM16.SLICE\[1\].RAM8.WORD\[0\].W.BYTE\[0\].B.SEL0_B VGND VGND VPWR
+ VPWR SLICE_16\[1\].RAM16.BYTE\[0\].FLOATBUF0\[0\].Z sky130_fd_sc_hd__ebufn_2
XSLICE_16\[1\].RAM16.SLICE\[0\].RAM8.WORD\[5\].W.BYTE\[3\].B.BIT\[2\].genblk1.STORAGE
+ DIBUF\[26\].X SLICE_16\[1\].RAM16.SLICE\[0\].RAM8.WORD\[5\].W.BYTE\[3\].B.GCLK VGND
+ VGND VPWR VPWR SLICE_16\[1\].RAM16.SLICE\[0\].RAM8.WORD\[5\].W.BYTE\[3\].B.Q_WIRE\[2\]
+ sky130_fd_sc_hd__dlxtp_1
XSLICE_16\[1\].RAM16.SLICE\[1\].RAM8.WORD\[4\].W.BYTE\[3\].B.BIT\[3\].OBUF0 SLICE_16\[1\].RAM16.SLICE\[1\].RAM8.WORD\[4\].W.BYTE\[3\].B.Q_WIRE\[3\]
+ SLICE_16\[1\].RAM16.SLICE\[1\].RAM8.WORD\[4\].W.BYTE\[3\].B.SEL0_B VGND VGND VPWR
+ VPWR SLICE_16\[1\].RAM16.BYTE\[3\].FLOATBUF0\[27\].Z sky130_fd_sc_hd__ebufn_2
XSLICE_16\[1\].RAM16.SLICE\[0\].RAM8.WORD\[3\].W.BYTE\[1\].B.BIT\[1\].genblk1.STORAGE
+ DIBUF\[9\].X SLICE_16\[1\].RAM16.SLICE\[0\].RAM8.WORD\[3\].W.BYTE\[1\].B.GCLK VGND
+ VGND VPWR VPWR SLICE_16\[1\].RAM16.SLICE\[0\].RAM8.WORD\[3\].W.BYTE\[1\].B.Q_WIRE\[1\]
+ sky130_fd_sc_hd__dlxtp_1
XSLICE_16\[0\].RAM16.SLICE\[1\].RAM8.WORD\[7\].W.BYTE\[3\].B.BIT\[3\].genblk1.STORAGE
+ DIBUF\[27\].X SLICE_16\[0\].RAM16.SLICE\[1\].RAM8.WORD\[7\].W.BYTE\[3\].B.GCLK VGND
+ VGND VPWR VPWR SLICE_16\[0\].RAM16.SLICE\[1\].RAM8.WORD\[7\].W.BYTE\[3\].B.Q_WIRE\[3\]
+ sky130_fd_sc_hd__dlxtp_1
XSLICE_16\[0\].RAM16.SLICE\[1\].RAM8.WORD\[5\].W.BYTE\[1\].B.BIT\[2\].genblk1.STORAGE
+ DIBUF\[10\].X SLICE_16\[0\].RAM16.SLICE\[1\].RAM8.WORD\[5\].W.BYTE\[1\].B.GCLK VGND
+ VGND VPWR VPWR SLICE_16\[0\].RAM16.SLICE\[1\].RAM8.WORD\[5\].W.BYTE\[1\].B.Q_WIRE\[2\]
+ sky130_fd_sc_hd__dlxtp_1
Xfill_46_1 VGND VGND VPWR VPWR sky130_fd_sc_hd__decap_12
XSLICE_16\[0\].RAM16.SLICE\[1\].RAM8.DEC0.AND1 SLICE_16\[0\].RAM16.SLICE\[1\].RAM8.DEC0.A_buf\[2\]
+ SLICE_16\[0\].RAM16.SLICE\[1\].RAM8.DEC0.A_buf\[1\] SLICE_16\[0\].RAM16.SLICE\[1\].RAM8.DEC0.A_buf\[0\]
+ SLICE_16\[0\].RAM16.SLICE\[1\].RAM8.DEC0.EN_buf VGND VGND VPWR VPWR SLICE_16\[0\].RAM16.SLICE\[1\].RAM8.DEC0.SEL\[1\]
+ sky130_fd_sc_hd__and4bb_2
Xfill_39_0 VGND VPWR sky130_fd_sc_hd__tapvpwrvgnd_1
XSLICE_16\[0\].RAM16.SLICE\[1\].RAM8.WORD\[6\].W.BYTE\[2\].B.BIT\[4\].OBUF0 SLICE_16\[0\].RAM16.SLICE\[1\].RAM8.WORD\[6\].W.BYTE\[2\].B.Q_WIRE\[4\]
+ SLICE_16\[0\].RAM16.SLICE\[1\].RAM8.WORD\[6\].W.BYTE\[2\].B.SEL0_B VGND VGND VPWR
+ VPWR SLICE_16\[0\].RAM16.BYTE\[2\].FLOATBUF0\[20\].Z sky130_fd_sc_hd__ebufn_2
Xfill_1_1 VGND VPWR sky130_fd_sc_hd__tapvpwrvgnd_1
XSLICE_16\[1\].RAM16.Do0_REG.OUTREG_BYTE\[1\].DIODE\[0\] SLICE_16\[1\].RAM16.BYTE\[1\].FLOATBUF0\[8\].Z
+ VGND VGND VPWR VPWR sky130_fd_sc_hd__diode_2
Xtap_11_36 VGND VPWR sky130_fd_sc_hd__tapvpwrvgnd_1
Xtap_11_14 VGND VPWR sky130_fd_sc_hd__tapvpwrvgnd_1
Xtap_11_25 VGND VPWR sky130_fd_sc_hd__tapvpwrvgnd_1
XSLICE_16\[0\].RAM16.SLICE\[0\].RAM8.WORD\[1\].W.BYTE\[1\].B.BIT\[3\].OBUF0 SLICE_16\[0\].RAM16.SLICE\[0\].RAM8.WORD\[1\].W.BYTE\[1\].B.Q_WIRE\[3\]
+ SLICE_16\[0\].RAM16.SLICE\[0\].RAM8.WORD\[1\].W.BYTE\[1\].B.SEL0_B VGND VGND VPWR
+ VPWR SLICE_16\[0\].RAM16.BYTE\[1\].FLOATBUF0\[11\].Z sky130_fd_sc_hd__ebufn_2
Xtap_36_33 VGND VPWR sky130_fd_sc_hd__tapvpwrvgnd_1
Xtap_36_22 VGND VPWR sky130_fd_sc_hd__tapvpwrvgnd_1
Xtap_36_11 VGND VPWR sky130_fd_sc_hd__tapvpwrvgnd_1
XSLICE_16\[1\].RAM16.SLICE\[1\].RAM8.WORD\[3\].W.BYTE\[1\].B.BIT\[0\].OBUF0 SLICE_16\[1\].RAM16.SLICE\[1\].RAM8.WORD\[3\].W.BYTE\[1\].B.Q_WIRE\[0\]
+ SLICE_16\[1\].RAM16.SLICE\[1\].RAM8.WORD\[3\].W.BYTE\[1\].B.SEL0_B VGND VGND VPWR
+ VPWR SLICE_16\[1\].RAM16.BYTE\[1\].FLOATBUF0\[8\].Z sky130_fd_sc_hd__ebufn_2
Xtap_4_3 VGND VPWR sky130_fd_sc_hd__tapvpwrvgnd_1
Xtap_11_4 VGND VPWR sky130_fd_sc_hd__tapvpwrvgnd_1
Xfill_40_20 VGND VGND VPWR VPWR sky130_fd_sc_hd__decap_12
XSLICE_16\[1\].RAM16.SLICE\[0\].RAM8.WORD\[3\].W.CLKBUF SLICE_16\[1\].RAM16.SLICE\[0\].RAM8.CLKBUF.X
+ VGND VGND VPWR VPWR SLICE_16\[1\].RAM16.SLICE\[0\].RAM8.WORD\[3\].W.BYTE\[0\].B.CLK
+ sky130_fd_sc_hd__clkbuf_4
XSLICE_16\[0\].RAM16.SLICE\[1\].RAM8.WORD\[5\].W.BYTE\[0\].B.BIT\[1\].OBUF0 SLICE_16\[0\].RAM16.SLICE\[1\].RAM8.WORD\[5\].W.BYTE\[0\].B.Q_WIRE\[1\]
+ SLICE_16\[0\].RAM16.SLICE\[1\].RAM8.WORD\[5\].W.BYTE\[0\].B.SEL0_B VGND VGND VPWR
+ VPWR SLICE_16\[0\].RAM16.BYTE\[0\].FLOATBUF0\[1\].Z sky130_fd_sc_hd__ebufn_2
XDIBUF\[21\].__cell__ Di0[21] VGND VGND VPWR VPWR DIBUF\[21\].X sky130_fd_sc_hd__clkbuf_16
XSLICE_16\[1\].RAM16.SLICE\[0\].RAM8.WORD\[2\].W.BYTE\[3\].B.BIT\[2\].OBUF0 SLICE_16\[1\].RAM16.SLICE\[0\].RAM8.WORD\[2\].W.BYTE\[3\].B.Q_WIRE\[2\]
+ SLICE_16\[1\].RAM16.SLICE\[0\].RAM8.WORD\[2\].W.BYTE\[3\].B.SEL0_B VGND VGND VPWR
+ VPWR SLICE_16\[1\].RAM16.BYTE\[3\].FLOATBUF0\[26\].Z sky130_fd_sc_hd__ebufn_2
Xfill_18_5 VGND VGND VPWR VPWR sky130_fd_sc_hd__decap_12
XSLICE_16\[0\].RAM16.SLICE\[1\].RAM8.WORD\[6\].W.BYTE\[1\].B.SEL0INV SLICE_16\[0\].RAM16.SLICE\[1\].RAM8.WORD\[6\].W.BYTE\[0\].B.SEL0
+ VGND VGND VPWR VPWR SLICE_16\[0\].RAM16.SLICE\[1\].RAM8.WORD\[6\].W.BYTE\[1\].B.SEL0_B
+ sky130_fd_sc_hd__inv_1
XSLICE_16\[1\].RAM16.SLICE\[1\].RAM8.WORD\[0\].W.BYTE\[3\].B.SEL0INV SLICE_16\[1\].RAM16.SLICE\[1\].RAM8.WORD\[0\].W.BYTE\[0\].B.SEL0
+ VGND VGND VPWR VPWR SLICE_16\[1\].RAM16.SLICE\[1\].RAM8.WORD\[0\].W.BYTE\[3\].B.SEL0_B
+ sky130_fd_sc_hd__inv_1
XSLICE_16\[1\].RAM16.SLICE\[1\].RAM8.WORD\[7\].W.BYTE\[2\].B.BIT\[6\].genblk1.STORAGE
+ DIBUF\[22\].X SLICE_16\[1\].RAM16.SLICE\[1\].RAM8.WORD\[7\].W.BYTE\[2\].B.GCLK VGND
+ VGND VPWR VPWR SLICE_16\[1\].RAM16.SLICE\[1\].RAM8.WORD\[7\].W.BYTE\[2\].B.Q_WIRE\[6\]
+ sky130_fd_sc_hd__dlxtp_1
XSLICE_16\[1\].RAM16.SLICE\[1\].RAM8.WORD\[1\].W.BYTE\[3\].B.BIT\[7\].genblk1.STORAGE
+ DIBUF\[31\].X SLICE_16\[1\].RAM16.SLICE\[1\].RAM8.WORD\[1\].W.BYTE\[3\].B.GCLK VGND
+ VGND VPWR VPWR SLICE_16\[1\].RAM16.SLICE\[1\].RAM8.WORD\[1\].W.BYTE\[3\].B.Q_WIRE\[7\]
+ sky130_fd_sc_hd__dlxtp_1
Xtap_3_17 VGND VPWR sky130_fd_sc_hd__tapvpwrvgnd_1
Xtap_3_28 VGND VPWR sky130_fd_sc_hd__tapvpwrvgnd_1
XSLICE_16\[0\].RAM16.SLICE\[0\].RAM8.WORD\[4\].W.BYTE\[2\].B.BIT\[3\].OBUF0 SLICE_16\[0\].RAM16.SLICE\[0\].RAM8.WORD\[4\].W.BYTE\[2\].B.Q_WIRE\[3\]
+ SLICE_16\[0\].RAM16.SLICE\[0\].RAM8.WORD\[4\].W.BYTE\[2\].B.SEL0_B VGND VGND VPWR
+ VPWR SLICE_16\[0\].RAM16.BYTE\[2\].FLOATBUF0\[19\].Z sky130_fd_sc_hd__ebufn_2
XSLICE_16\[1\].RAM16.Do0_REG.OUTREG_BYTE\[0\].Do_FF\[1\] SLICE_16\[1\].RAM16.Do0_REG.CLKBUF\[0\]
+ SLICE_16\[1\].RAM16.BYTE\[0\].FLOATBUF0\[1\].Z VGND VGND VPWR VPWR Do0MUX.A1\[1\]
+ sky130_fd_sc_hd__dfxtp_1
XSLICE_16\[1\].RAM16.SLICE\[1\].RAM8.WORD\[6\].W.BYTE\[2\].B.BIT\[0\].OBUF0 SLICE_16\[1\].RAM16.SLICE\[1\].RAM8.WORD\[6\].W.BYTE\[2\].B.Q_WIRE\[0\]
+ SLICE_16\[1\].RAM16.SLICE\[1\].RAM8.WORD\[6\].W.BYTE\[2\].B.SEL0_B VGND VGND VPWR
+ VPWR SLICE_16\[1\].RAM16.BYTE\[2\].FLOATBUF0\[16\].Z sky130_fd_sc_hd__ebufn_2
XSLICE_16\[1\].RAM16.SLICE\[1\].RAM8.WORD\[5\].W.BYTE\[0\].B.BIT\[5\].genblk1.STORAGE
+ DIBUF\[5\].X SLICE_16\[1\].RAM16.SLICE\[1\].RAM8.WORD\[5\].W.BYTE\[0\].B.GCLK VGND
+ VGND VPWR VPWR SLICE_16\[1\].RAM16.SLICE\[1\].RAM8.WORD\[5\].W.BYTE\[0\].B.Q_WIRE\[5\]
+ sky130_fd_sc_hd__dlxtp_1
XSLICE_16\[1\].RAM16.SLICE\[0\].RAM8.WORD\[6\].W.BYTE\[2\].B.BIT\[1\].genblk1.STORAGE
+ DIBUF\[17\].X SLICE_16\[1\].RAM16.SLICE\[0\].RAM8.WORD\[6\].W.BYTE\[2\].B.GCLK VGND
+ VGND VPWR VPWR SLICE_16\[1\].RAM16.SLICE\[0\].RAM8.WORD\[6\].W.BYTE\[2\].B.Q_WIRE\[1\]
+ sky130_fd_sc_hd__dlxtp_1
XSLICE_16\[1\].RAM16.SLICE\[0\].RAM8.WORD\[0\].W.BYTE\[3\].B.BIT\[2\].genblk1.STORAGE
+ DIBUF\[26\].X SLICE_16\[1\].RAM16.SLICE\[0\].RAM8.WORD\[0\].W.BYTE\[3\].B.GCLK VGND
+ VGND VPWR VPWR SLICE_16\[1\].RAM16.SLICE\[0\].RAM8.WORD\[0\].W.BYTE\[3\].B.Q_WIRE\[2\]
+ sky130_fd_sc_hd__dlxtp_1
XSLICE_16\[1\].RAM16.SLICE\[0\].RAM8.WORD\[4\].W.BYTE\[0\].B.BIT\[0\].genblk1.STORAGE
+ DIBUF\[0\].X SLICE_16\[1\].RAM16.SLICE\[0\].RAM8.WORD\[4\].W.BYTE\[0\].B.GCLK VGND
+ VGND VPWR VPWR SLICE_16\[1\].RAM16.SLICE\[0\].RAM8.WORD\[4\].W.BYTE\[0\].B.Q_WIRE\[0\]
+ sky130_fd_sc_hd__dlxtp_1
XSLICE_16\[0\].RAM16.SLICE\[0\].RAM8.WORD\[2\].W.BYTE\[0\].B.SEL0INV SLICE_16\[0\].RAM16.SLICE\[0\].RAM8.WORD\[2\].W.BYTE\[0\].B.SEL0
+ VGND VGND VPWR VPWR SLICE_16\[0\].RAM16.SLICE\[0\].RAM8.WORD\[2\].W.BYTE\[0\].B.SEL0_B
+ sky130_fd_sc_hd__inv_1
XSLICE_16\[0\].RAM16.SLICE\[1\].RAM8.WORD\[2\].W.BYTE\[3\].B.BIT\[3\].genblk1.STORAGE
+ DIBUF\[27\].X SLICE_16\[0\].RAM16.SLICE\[1\].RAM8.WORD\[2\].W.BYTE\[3\].B.GCLK VGND
+ VGND VPWR VPWR SLICE_16\[0\].RAM16.SLICE\[1\].RAM8.WORD\[2\].W.BYTE\[3\].B.Q_WIRE\[3\]
+ sky130_fd_sc_hd__dlxtp_1
XSLICE_16\[1\].RAM16.SLICE\[0\].RAM8.WORD\[2\].W.BYTE\[2\].B.CGAND SLICE_16\[1\].RAM16.SLICE\[0\].RAM8.WORD\[2\].W.BYTE\[0\].B.SEL0
+ SLICE_16\[1\].RAM16.SLICE\[0\].RAM8.WE0_buf\[2\] VGND VGND VPWR VPWR SLICE_16\[1\].RAM16.SLICE\[0\].RAM8.WORD\[2\].W.BYTE\[2\].B.WE0_WIRE
+ sky130_fd_sc_hd__and2_1
XSLICE_16\[0\].RAM16.SLICE\[1\].RAM8.WORD\[6\].W.BYTE\[0\].B.BIT\[1\].genblk1.STORAGE
+ DIBUF\[1\].X SLICE_16\[0\].RAM16.SLICE\[1\].RAM8.WORD\[6\].W.BYTE\[0\].B.GCLK VGND
+ VGND VPWR VPWR SLICE_16\[0\].RAM16.SLICE\[1\].RAM8.WORD\[6\].W.BYTE\[0\].B.Q_WIRE\[1\]
+ sky130_fd_sc_hd__dlxtp_1
XSLICE_16\[0\].RAM16.SLICE\[1\].RAM8.WORD\[0\].W.BYTE\[1\].B.BIT\[2\].genblk1.STORAGE
+ DIBUF\[10\].X SLICE_16\[0\].RAM16.SLICE\[1\].RAM8.WORD\[0\].W.BYTE\[1\].B.GCLK VGND
+ VGND VPWR VPWR SLICE_16\[0\].RAM16.SLICE\[1\].RAM8.WORD\[0\].W.BYTE\[1\].B.Q_WIRE\[2\]
+ sky130_fd_sc_hd__dlxtp_1
Xtap_47_10 VGND VPWR sky130_fd_sc_hd__tapvpwrvgnd_1
Xfill_19_32 VGND VGND VPWR VPWR sky130_fd_sc_hd__decap_12
Xfill_19_21 VGND VPWR sky130_fd_sc_hd__tapvpwrvgnd_1
Xfill_19_10 VGND VGND VPWR VPWR sky130_fd_sc_hd__decap_12
Xfill_19_98 VGND VGND VPWR VPWR sky130_fd_sc_hd__decap_12
Xfill_19_87 VGND VPWR sky130_fd_sc_hd__tapvpwrvgnd_1
Xfill_19_76 VGND VGND VPWR VPWR sky130_fd_sc_hd__decap_12
Xfill_19_65 VGND VGND VPWR VPWR sky130_fd_sc_hd__decap_12
Xfill_19_54 VGND VPWR sky130_fd_sc_hd__tapvpwrvgnd_1
Xfill_19_43 VGND VGND VPWR VPWR sky130_fd_sc_hd__decap_12
Xtap_2_0 VGND VPWR sky130_fd_sc_hd__tapvpwrvgnd_1
XSLICE_16\[0\].RAM16.SLICE\[0\].RAM8.WORD\[3\].W.BYTE\[0\].B.BIT\[0\].OBUF0 SLICE_16\[0\].RAM16.SLICE\[0\].RAM8.WORD\[3\].W.BYTE\[0\].B.Q_WIRE\[0\]
+ SLICE_16\[0\].RAM16.SLICE\[0\].RAM8.WORD\[3\].W.BYTE\[0\].B.SEL0_B VGND VGND VPWR
+ VPWR SLICE_16\[0\].RAM16.BYTE\[0\].FLOATBUF0\[0\].Z sky130_fd_sc_hd__ebufn_2
XSLICE_16\[1\].RAM16.SLICE\[0\].RAM8.WORD\[2\].W.BYTE\[1\].B.BIT\[7\].OBUF0 SLICE_16\[1\].RAM16.SLICE\[0\].RAM8.WORD\[2\].W.BYTE\[1\].B.Q_WIRE\[7\]
+ SLICE_16\[1\].RAM16.SLICE\[0\].RAM8.WORD\[2\].W.BYTE\[1\].B.SEL0_B VGND VGND VPWR
+ VPWR SLICE_16\[1\].RAM16.BYTE\[1\].FLOATBUF0\[15\].Z sky130_fd_sc_hd__ebufn_2
XSLICE_16\[0\].RAM16.SLICE\[0\].RAM8.WORD\[3\].W.BYTE\[0\].B.BIT\[7\].genblk1.STORAGE
+ DIBUF\[7\].X SLICE_16\[0\].RAM16.SLICE\[0\].RAM8.WORD\[3\].W.BYTE\[0\].B.GCLK VGND
+ VGND VPWR VPWR SLICE_16\[0\].RAM16.SLICE\[0\].RAM8.WORD\[3\].W.BYTE\[0\].B.Q_WIRE\[7\]
+ sky130_fd_sc_hd__dlxtp_1
XSLICE_16\[0\].RAM16.SLICE\[0\].RAM8.WORD\[7\].W.BYTE\[3\].B.BIT\[3\].OBUF0 SLICE_16\[0\].RAM16.SLICE\[0\].RAM8.WORD\[7\].W.BYTE\[3\].B.Q_WIRE\[3\]
+ SLICE_16\[0\].RAM16.SLICE\[0\].RAM8.WORD\[7\].W.BYTE\[3\].B.SEL0_B VGND VGND VPWR
+ VPWR SLICE_16\[0\].RAM16.BYTE\[3\].FLOATBUF0\[27\].Z sky130_fd_sc_hd__ebufn_2
Xfill_30_4 VGND VGND VPWR VPWR sky130_fd_sc_hd__decap_6
Xfill_23_3 VGND VGND VPWR VPWR sky130_fd_sc_hd__decap_6
Xfill_16_2 VGND VGND VPWR VPWR sky130_fd_sc_hd__decap_3
XSLICE_16\[1\].RAM16.SLICE\[1\].RAM8.WORD\[6\].W.BYTE\[0\].B.BIT\[5\].OBUF0 SLICE_16\[1\].RAM16.SLICE\[1\].RAM8.WORD\[6\].W.BYTE\[0\].B.Q_WIRE\[5\]
+ SLICE_16\[1\].RAM16.SLICE\[1\].RAM8.WORD\[6\].W.BYTE\[0\].B.SEL0_B VGND VGND VPWR
+ VPWR SLICE_16\[1\].RAM16.BYTE\[0\].FLOATBUF0\[5\].Z sky130_fd_sc_hd__ebufn_2
Xtap_38_9 VGND VPWR sky130_fd_sc_hd__tapvpwrvgnd_1
Xtap_33_34 VGND VPWR sky130_fd_sc_hd__tapvpwrvgnd_1
Xtap_33_23 VGND VPWR sky130_fd_sc_hd__tapvpwrvgnd_1
Xtap_33_12 VGND VPWR sky130_fd_sc_hd__tapvpwrvgnd_1
XDIBUF\[5\].__cell__ Di0[5] VGND VGND VPWR VPWR DIBUF\[5\].X sky130_fd_sc_hd__clkbuf_16
XSLICE_16\[0\].RAM16.SLICE\[0\].RAM8.WORD\[6\].W.BYTE\[1\].B.BIT\[0\].OBUF0 SLICE_16\[0\].RAM16.SLICE\[0\].RAM8.WORD\[6\].W.BYTE\[1\].B.Q_WIRE\[0\]
+ SLICE_16\[0\].RAM16.SLICE\[0\].RAM8.WORD\[6\].W.BYTE\[1\].B.SEL0_B VGND VGND VPWR
+ VPWR SLICE_16\[0\].RAM16.BYTE\[1\].FLOATBUF0\[8\].Z sky130_fd_sc_hd__ebufn_2
XSLICE_16\[1\].RAM16.BYTE\[3\].FLOATBUF0\[29\].__cell__ SLICE_16\[1\].RAM16.BYTE\[3\].FLOATBUF0\[24\].A
+ SLICE_16\[1\].RAM16.BYTE\[3\].FLOATBUF0\[24\].TE_B VGND VGND VPWR VPWR SLICE_16\[1\].RAM16.BYTE\[3\].FLOATBUF0\[29\].Z
+ sky130_fd_sc_hd__ebufn_2
XSLICE_16\[1\].RAM16.SLICE\[1\].RAM8.WORD\[2\].W.BYTE\[2\].B.BIT\[6\].genblk1.STORAGE
+ DIBUF\[22\].X SLICE_16\[1\].RAM16.SLICE\[1\].RAM8.WORD\[2\].W.BYTE\[2\].B.GCLK VGND
+ VGND VPWR VPWR SLICE_16\[1\].RAM16.SLICE\[1\].RAM8.WORD\[2\].W.BYTE\[2\].B.Q_WIRE\[6\]
+ sky130_fd_sc_hd__dlxtp_1
XSLICE_16\[1\].RAM16.SLICE\[1\].RAM8.WORD\[3\].W.BYTE\[1\].B.CGAND SLICE_16\[1\].RAM16.SLICE\[1\].RAM8.WORD\[3\].W.BYTE\[0\].B.SEL0
+ SLICE_16\[1\].RAM16.SLICE\[1\].RAM8.WE0_buf\[1\] VGND VGND VPWR VPWR SLICE_16\[1\].RAM16.SLICE\[1\].RAM8.WORD\[3\].W.BYTE\[1\].B.WE0_WIRE
+ sky130_fd_sc_hd__and2_1
XSLICE_16\[1\].RAM16.SLICE\[0\].RAM8.WORD\[5\].W.BYTE\[2\].B.BIT\[7\].OBUF0 SLICE_16\[1\].RAM16.SLICE\[0\].RAM8.WORD\[5\].W.BYTE\[2\].B.Q_WIRE\[7\]
+ SLICE_16\[1\].RAM16.SLICE\[0\].RAM8.WORD\[5\].W.BYTE\[2\].B.SEL0_B VGND VGND VPWR
+ VPWR SLICE_16\[1\].RAM16.BYTE\[2\].FLOATBUF0\[23\].Z sky130_fd_sc_hd__ebufn_2
Xfill_21_99 VGND VPWR sky130_fd_sc_hd__tapvpwrvgnd_1
Xfill_21_88 VGND VGND VPWR VPWR sky130_fd_sc_hd__decap_12
Xfill_21_77 VGND VGND VPWR VPWR sky130_fd_sc_hd__decap_12
Xfill_21_66 VGND VPWR sky130_fd_sc_hd__tapvpwrvgnd_1
Xfill_21_55 VGND VGND VPWR VPWR sky130_fd_sc_hd__decap_12
Xfill_21_44 VGND VGND VPWR VPWR sky130_fd_sc_hd__decap_12
Xfill_21_33 VGND VPWR sky130_fd_sc_hd__tapvpwrvgnd_1
Xfill_21_22 VGND VGND VPWR VPWR sky130_fd_sc_hd__decap_12
Xfill_21_11 VGND VGND VPWR VPWR sky130_fd_sc_hd__decap_12
XSLICE_16\[1\].RAM16.SLICE\[1\].RAM8.WORD\[0\].W.BYTE\[0\].B.BIT\[5\].genblk1.STORAGE
+ DIBUF\[5\].X SLICE_16\[1\].RAM16.SLICE\[1\].RAM8.WORD\[0\].W.BYTE\[0\].B.GCLK VGND
+ VGND VPWR VPWR SLICE_16\[1\].RAM16.SLICE\[1\].RAM8.WORD\[0\].W.BYTE\[0\].B.Q_WIRE\[5\]
+ sky130_fd_sc_hd__dlxtp_1
XSLICE_16\[1\].RAM16.SLICE\[0\].RAM8.WORD\[7\].W.BYTE\[1\].B.BIT\[0\].genblk1.STORAGE
+ DIBUF\[8\].X SLICE_16\[1\].RAM16.SLICE\[0\].RAM8.WORD\[7\].W.BYTE\[1\].B.GCLK VGND
+ VGND VPWR VPWR SLICE_16\[1\].RAM16.SLICE\[0\].RAM8.WORD\[7\].W.BYTE\[1\].B.Q_WIRE\[0\]
+ sky130_fd_sc_hd__dlxtp_1
XSLICE_16\[1\].RAM16.SLICE\[0\].RAM8.WORD\[1\].W.BYTE\[2\].B.BIT\[1\].genblk1.STORAGE
+ DIBUF\[17\].X SLICE_16\[1\].RAM16.SLICE\[0\].RAM8.WORD\[1\].W.BYTE\[2\].B.GCLK VGND
+ VGND VPWR VPWR SLICE_16\[1\].RAM16.SLICE\[0\].RAM8.WORD\[1\].W.BYTE\[2\].B.Q_WIRE\[1\]
+ sky130_fd_sc_hd__dlxtp_1
Xfill_46_96 VGND VPWR sky130_fd_sc_hd__tapvpwrvgnd_1
Xfill_46_85 VGND VGND VPWR VPWR sky130_fd_sc_hd__decap_12
Xfill_46_74 VGND VGND VPWR VPWR sky130_fd_sc_hd__decap_4
Xfill_46_63 VGND VPWR sky130_fd_sc_hd__tapvpwrvgnd_1
Xfill_46_52 VGND VPWR sky130_fd_sc_hd__tapvpwrvgnd_1
Xfill_46_41 VGND VGND VPWR VPWR sky130_fd_sc_hd__decap_4
Xfill_46_30 VGND VGND VPWR VPWR sky130_fd_sc_hd__decap_4
XSLICE_16\[0\].RAM16.SLICE\[1\].RAM8.WORD\[3\].W.BYTE\[2\].B.BIT\[2\].genblk1.STORAGE
+ DIBUF\[18\].X SLICE_16\[0\].RAM16.SLICE\[1\].RAM8.WORD\[3\].W.BYTE\[2\].B.GCLK VGND
+ VGND VPWR VPWR SLICE_16\[0\].RAM16.SLICE\[1\].RAM8.WORD\[3\].W.BYTE\[2\].B.Q_WIRE\[2\]
+ sky130_fd_sc_hd__dlxtp_1
XSLICE_16\[0\].RAM16.SLICE\[1\].RAM8.WORD\[1\].W.BYTE\[0\].B.BIT\[1\].genblk1.STORAGE
+ DIBUF\[1\].X SLICE_16\[0\].RAM16.SLICE\[1\].RAM8.WORD\[1\].W.BYTE\[0\].B.GCLK VGND
+ VGND VPWR VPWR SLICE_16\[0\].RAM16.SLICE\[1\].RAM8.WORD\[1\].W.BYTE\[0\].B.Q_WIRE\[1\]
+ sky130_fd_sc_hd__dlxtp_1
XSLICE_16\[0\].RAM16.SLICE\[1\].RAM8.WORD\[1\].W.BYTE\[0\].B.genblk1.CG SLICE_16\[0\].RAM16.SLICE\[1\].RAM8.WORD\[1\].W.BYTE\[0\].B.CLK_B
+ SLICE_16\[0\].RAM16.SLICE\[1\].RAM8.WORD\[1\].W.BYTE\[0\].B.WE0_WIRE VGND VGND VPWR
+ VPWR SLICE_16\[0\].RAM16.SLICE\[1\].RAM8.WORD\[1\].W.BYTE\[0\].B.GCLK sky130_fd_sc_hd__dlclkp_1
XSLICE_16\[1\].RAM16.SLICE\[1\].RAM8.WORD\[4\].W.BYTE\[1\].B.SEL0INV SLICE_16\[1\].RAM16.SLICE\[1\].RAM8.WORD\[4\].W.BYTE\[0\].B.SEL0
+ VGND VGND VPWR VPWR SLICE_16\[1\].RAM16.SLICE\[1\].RAM8.WORD\[4\].W.BYTE\[1\].B.SEL0_B
+ sky130_fd_sc_hd__inv_1
XSLICE_16\[1\].RAM16.SLICE\[0\].RAM8.WORD\[4\].W.BYTE\[0\].B.BIT\[4\].OBUF0 SLICE_16\[1\].RAM16.SLICE\[0\].RAM8.WORD\[4\].W.BYTE\[0\].B.Q_WIRE\[4\]
+ SLICE_16\[1\].RAM16.SLICE\[0\].RAM8.WORD\[4\].W.BYTE\[0\].B.SEL0_B VGND VGND VPWR
+ VPWR SLICE_16\[1\].RAM16.BYTE\[0\].FLOATBUF0\[4\].Z sky130_fd_sc_hd__ebufn_2
Xfill_21_0 VGND VPWR sky130_fd_sc_hd__tapvpwrvgnd_1
Xtap_0_29 VGND VPWR sky130_fd_sc_hd__tapvpwrvgnd_1
Xtap_0_18 VGND VPWR sky130_fd_sc_hd__tapvpwrvgnd_1
Xtap_9_16 VGND VPWR sky130_fd_sc_hd__tapvpwrvgnd_1
XSLICE_16\[0\].RAM16.SLICE\[1\].RAM8.WORD\[1\].W.BYTE\[2\].B.BIT\[3\].OBUF0 SLICE_16\[0\].RAM16.SLICE\[1\].RAM8.WORD\[1\].W.BYTE\[2\].B.Q_WIRE\[3\]
+ SLICE_16\[0\].RAM16.SLICE\[1\].RAM8.WORD\[1\].W.BYTE\[2\].B.SEL0_B VGND VGND VPWR
+ VPWR SLICE_16\[0\].RAM16.BYTE\[2\].FLOATBUF0\[19\].Z sky130_fd_sc_hd__ebufn_2
XSLICE_16\[1\].RAM16.SLICE\[1\].RAM8.WORD\[3\].W.BYTE\[3\].B.genblk1.CG SLICE_16\[1\].RAM16.SLICE\[1\].RAM8.WORD\[3\].W.BYTE\[3\].B.CLK_B
+ SLICE_16\[1\].RAM16.SLICE\[1\].RAM8.WORD\[3\].W.BYTE\[3\].B.WE0_WIRE VGND VGND VPWR
+ VPWR SLICE_16\[1\].RAM16.SLICE\[1\].RAM8.WORD\[3\].W.BYTE\[3\].B.GCLK sky130_fd_sc_hd__dlclkp_1
XSLICE_16\[1\].RAM16.SLICE\[1\].RAM8.DEC0.ABUF\[1\] SLICE_16\[1\].RAM16.A0BUF\[1\].X
+ VGND VGND VPWR VPWR SLICE_16\[1\].RAM16.SLICE\[1\].RAM8.DEC0.A_buf\[1\] sky130_fd_sc_hd__clkbuf_2
XSLICE_16\[0\].RAM16.SLICE\[0\].RAM8.WORD\[6\].W.BYTE\[1\].B.BIT\[7\].genblk1.STORAGE
+ DIBUF\[15\].X SLICE_16\[0\].RAM16.SLICE\[0\].RAM8.WORD\[6\].W.BYTE\[1\].B.GCLK VGND
+ VGND VPWR VPWR SLICE_16\[0\].RAM16.SLICE\[0\].RAM8.WORD\[6\].W.BYTE\[1\].B.Q_WIRE\[7\]
+ sky130_fd_sc_hd__dlxtp_1
Xtap_9_27 VGND VPWR sky130_fd_sc_hd__tapvpwrvgnd_1
Xtap_36_6 VGND VPWR sky130_fd_sc_hd__tapvpwrvgnd_1
Xtap_29_5 VGND VPWR sky130_fd_sc_hd__tapvpwrvgnd_1
Xtap_28_34 VGND VPWR sky130_fd_sc_hd__tapvpwrvgnd_1
Xtap_28_23 VGND VPWR sky130_fd_sc_hd__tapvpwrvgnd_1
Xtap_28_12 VGND VPWR sky130_fd_sc_hd__tapvpwrvgnd_1
XSLICE_16\[1\].RAM16.SLICE\[0\].RAM8.WORD\[0\].W.BYTE\[0\].B.SEL0INV SLICE_16\[1\].RAM16.SLICE\[0\].RAM8.WORD\[0\].W.BYTE\[0\].B.SEL0
+ VGND VGND VPWR VPWR SLICE_16\[1\].RAM16.SLICE\[0\].RAM8.WORD\[0\].W.BYTE\[0\].B.SEL0_B
+ sky130_fd_sc_hd__inv_1
XSLICE_16\[0\].RAM16.SLICE\[1\].RAM8.WORD\[5\].W.BYTE\[3\].B.CGAND SLICE_16\[0\].RAM16.SLICE\[1\].RAM8.WORD\[5\].W.BYTE\[0\].B.SEL0
+ SLICE_16\[0\].RAM16.SLICE\[1\].RAM8.WE0_buf\[3\] VGND VGND VPWR VPWR SLICE_16\[0\].RAM16.SLICE\[1\].RAM8.WORD\[5\].W.BYTE\[3\].B.WE0_WIRE
+ sky130_fd_sc_hd__and2_1
XWEBUF\[1\].__cell__ WE0[1] VGND VGND VPWR VPWR SLICE_16\[0\].RAM16.WE0\[1\] sky130_fd_sc_hd__clkbuf_2
XSLICE_16\[0\].RAM16.SLICE\[0\].RAM8.WORD\[1\].W.BYTE\[3\].B.DIODE_CLK SLICE_16\[0\].RAM16.SLICE\[0\].RAM8.WORD\[1\].W.BYTE\[0\].B.CLK
+ VGND VGND VPWR VPWR sky130_fd_sc_hd__diode_2
XSLICE_16\[1\].RAM16.SLICE\[0\].RAM8.WORD\[3\].W.BYTE\[0\].B.DIODE_CLK SLICE_16\[1\].RAM16.SLICE\[0\].RAM8.WORD\[3\].W.BYTE\[0\].B.CLK
+ VGND VGND VPWR VPWR sky130_fd_sc_hd__diode_2
XSLICE_16\[0\].RAM16.SLICE\[1\].RAM8.WORD\[0\].W.BYTE\[0\].B.BIT\[0\].OBUF0 SLICE_16\[0\].RAM16.SLICE\[1\].RAM8.WORD\[0\].W.BYTE\[0\].B.Q_WIRE\[0\]
+ SLICE_16\[0\].RAM16.SLICE\[1\].RAM8.WORD\[0\].W.BYTE\[0\].B.SEL0_B VGND VGND VPWR
+ VPWR SLICE_16\[0\].RAM16.BYTE\[0\].FLOATBUF0\[0\].Z sky130_fd_sc_hd__ebufn_2
XSLICE_16\[0\].RAM16.SLICE\[1\].RAM8.WORD\[2\].W.BYTE\[2\].B.SEL0INV SLICE_16\[0\].RAM16.SLICE\[1\].RAM8.WORD\[2\].W.BYTE\[0\].B.SEL0
+ VGND VGND VPWR VPWR SLICE_16\[0\].RAM16.SLICE\[1\].RAM8.WORD\[2\].W.BYTE\[2\].B.SEL0_B
+ sky130_fd_sc_hd__inv_1
XSLICE_16\[1\].RAM16.SLICE\[1\].RAM8.WORD\[5\].W.BYTE\[3\].B.BIT\[6\].genblk1.STORAGE
+ DIBUF\[30\].X SLICE_16\[1\].RAM16.SLICE\[1\].RAM8.WORD\[5\].W.BYTE\[3\].B.GCLK VGND
+ VGND VPWR VPWR SLICE_16\[1\].RAM16.SLICE\[1\].RAM8.WORD\[5\].W.BYTE\[3\].B.Q_WIRE\[6\]
+ sky130_fd_sc_hd__dlxtp_1
XSLICE_16\[1\].RAM16.SLICE\[0\].RAM8.WORD\[7\].W.BYTE\[1\].B.BIT\[4\].OBUF0 SLICE_16\[1\].RAM16.SLICE\[0\].RAM8.WORD\[7\].W.BYTE\[1\].B.Q_WIRE\[4\]
+ SLICE_16\[1\].RAM16.SLICE\[0\].RAM8.WORD\[7\].W.BYTE\[1\].B.SEL0_B VGND VGND VPWR
+ VPWR SLICE_16\[1\].RAM16.BYTE\[1\].FLOATBUF0\[12\].Z sky130_fd_sc_hd__ebufn_2
XSLICE_16\[0\].RAM16.SLICE\[1\].RAM8.WORD\[4\].W.BYTE\[3\].B.BIT\[3\].OBUF0 SLICE_16\[0\].RAM16.SLICE\[1\].RAM8.WORD\[4\].W.BYTE\[3\].B.Q_WIRE\[3\]
+ SLICE_16\[0\].RAM16.SLICE\[1\].RAM8.WORD\[4\].W.BYTE\[3\].B.SEL0_B VGND VGND VPWR
+ VPWR SLICE_16\[0\].RAM16.BYTE\[3\].FLOATBUF0\[27\].Z sky130_fd_sc_hd__ebufn_2
XSLICE_16\[0\].RAM16.SLICE\[1\].RAM8.WORD\[5\].W.BYTE\[0\].B.genblk1.CLKINV SLICE_16\[0\].RAM16.SLICE\[1\].RAM8.WORD\[5\].W.BYTE\[0\].B.CLK
+ VGND VGND VPWR VPWR SLICE_16\[0\].RAM16.SLICE\[1\].RAM8.WORD\[5\].W.BYTE\[0\].B.CLK_B
+ sky130_fd_sc_hd__inv_1
XSLICE_16\[1\].RAM16.SLICE\[1\].RAM8.WORD\[3\].W.BYTE\[1\].B.BIT\[5\].genblk1.STORAGE
+ DIBUF\[13\].X SLICE_16\[1\].RAM16.SLICE\[1\].RAM8.WORD\[3\].W.BYTE\[1\].B.GCLK VGND
+ VGND VPWR VPWR SLICE_16\[1\].RAM16.SLICE\[1\].RAM8.WORD\[3\].W.BYTE\[1\].B.Q_WIRE\[5\]
+ sky130_fd_sc_hd__dlxtp_1
XSLICE_16\[1\].RAM16.BYTE\[2\].FLOATBUF0\[20\].__cell__ SLICE_16\[1\].RAM16.BYTE\[2\].FLOATBUF0\[16\].A
+ SLICE_16\[1\].RAM16.BYTE\[2\].FLOATBUF0\[16\].TE_B VGND VGND VPWR VPWR SLICE_16\[1\].RAM16.BYTE\[2\].FLOATBUF0\[20\].Z
+ sky130_fd_sc_hd__ebufn_2
XSLICE_16\[1\].RAM16.SLICE\[0\].RAM8.WORD\[4\].W.BYTE\[3\].B.BIT\[1\].genblk1.STORAGE
+ DIBUF\[25\].X SLICE_16\[1\].RAM16.SLICE\[0\].RAM8.WORD\[4\].W.BYTE\[3\].B.GCLK VGND
+ VGND VPWR VPWR SLICE_16\[1\].RAM16.SLICE\[0\].RAM8.WORD\[4\].W.BYTE\[3\].B.Q_WIRE\[1\]
+ sky130_fd_sc_hd__dlxtp_1
XSLICE_16\[0\].RAM16.SLICE\[1\].RAM8.WORD\[0\].W.BYTE\[0\].B.DIODE_CLK SLICE_16\[0\].RAM16.SLICE\[1\].RAM8.WORD\[0\].W.BYTE\[0\].B.CLK
+ VGND VGND VPWR VPWR sky130_fd_sc_hd__diode_2
XSLICE_16\[1\].RAM16.SLICE\[0\].RAM8.CLKBUF.__cell__ SLICE_16\[1\].RAM16.CLKBUF.X
+ VGND VGND VPWR VPWR SLICE_16\[1\].RAM16.SLICE\[0\].RAM8.CLKBUF.X sky130_fd_sc_hd__clkbuf_2
XSLICE_16\[1\].RAM16.SLICE\[0\].RAM8.WORD\[2\].W.BYTE\[1\].B.BIT\[0\].genblk1.STORAGE
+ DIBUF\[8\].X SLICE_16\[1\].RAM16.SLICE\[0\].RAM8.WORD\[2\].W.BYTE\[1\].B.GCLK VGND
+ VGND VPWR VPWR SLICE_16\[1\].RAM16.SLICE\[0\].RAM8.WORD\[2\].W.BYTE\[1\].B.Q_WIRE\[0\]
+ sky130_fd_sc_hd__dlxtp_1
XSLICE_16\[0\].RAM16.SLICE\[1\].RAM8.WORD\[6\].W.BYTE\[3\].B.BIT\[2\].genblk1.STORAGE
+ DIBUF\[26\].X SLICE_16\[0\].RAM16.SLICE\[1\].RAM8.WORD\[6\].W.BYTE\[3\].B.GCLK VGND
+ VGND VPWR VPWR SLICE_16\[0\].RAM16.SLICE\[1\].RAM8.WORD\[6\].W.BYTE\[3\].B.Q_WIRE\[2\]
+ sky130_fd_sc_hd__dlxtp_1
Xtap_14_25 VGND VPWR sky130_fd_sc_hd__tapvpwrvgnd_1
Xtap_14_14 VGND VPWR sky130_fd_sc_hd__tapvpwrvgnd_1
XSLICE_16\[0\].RAM16.SLICE\[1\].RAM8.WORD\[4\].W.BYTE\[1\].B.BIT\[1\].genblk1.STORAGE
+ DIBUF\[9\].X SLICE_16\[0\].RAM16.SLICE\[1\].RAM8.WORD\[4\].W.BYTE\[1\].B.GCLK VGND
+ VGND VPWR VPWR SLICE_16\[0\].RAM16.SLICE\[1\].RAM8.WORD\[4\].W.BYTE\[1\].B.Q_WIRE\[1\]
+ sky130_fd_sc_hd__dlxtp_1
Xtap_30_35 VGND VPWR sky130_fd_sc_hd__tapvpwrvgnd_1
Xtap_30_24 VGND VPWR sky130_fd_sc_hd__tapvpwrvgnd_1
Xtap_30_13 VGND VPWR sky130_fd_sc_hd__tapvpwrvgnd_1
Xtap_34_3 VGND VPWR sky130_fd_sc_hd__tapvpwrvgnd_1
Xtap_27_2 VGND VPWR sky130_fd_sc_hd__tapvpwrvgnd_1
XSLICE_16\[0\].RAM16.SLICE\[1\].RAM8.WORD\[3\].W.BYTE\[1\].B.BIT\[0\].OBUF0 SLICE_16\[0\].RAM16.SLICE\[1\].RAM8.WORD\[3\].W.BYTE\[1\].B.Q_WIRE\[0\]
+ SLICE_16\[0\].RAM16.SLICE\[1\].RAM8.WORD\[3\].W.BYTE\[1\].B.SEL0_B VGND VGND VPWR
+ VPWR SLICE_16\[0\].RAM16.BYTE\[1\].FLOATBUF0\[8\].Z sky130_fd_sc_hd__ebufn_2
XSLICE_16\[1\].RAM16.SLICE\[1\].RAM8.WORD\[2\].W.BYTE\[2\].B.BIT\[7\].OBUF0 SLICE_16\[1\].RAM16.SLICE\[1\].RAM8.WORD\[2\].W.BYTE\[2\].B.Q_WIRE\[7\]
+ SLICE_16\[1\].RAM16.SLICE\[1\].RAM8.WORD\[2\].W.BYTE\[2\].B.SEL0_B VGND VGND VPWR
+ VPWR SLICE_16\[1\].RAM16.BYTE\[2\].FLOATBUF0\[23\].Z sky130_fd_sc_hd__ebufn_2
Xfill_43_75 VGND VPWR sky130_fd_sc_hd__tapvpwrvgnd_1
Xfill_43_64 VGND VGND VPWR VPWR sky130_fd_sc_hd__decap_12
Xfill_43_53 VGND VGND VPWR VPWR sky130_fd_sc_hd__decap_12
Xfill_43_42 VGND VPWR sky130_fd_sc_hd__tapvpwrvgnd_1
Xfill_43_31 VGND VGND VPWR VPWR sky130_fd_sc_hd__decap_12
Xfill_43_20 VGND VGND VPWR VPWR sky130_fd_sc_hd__decap_12
XSLICE_16\[0\].RAM16.SLICE\[0\].RAM8.WORD\[1\].W.BYTE\[1\].B.BIT\[7\].genblk1.STORAGE
+ DIBUF\[15\].X SLICE_16\[0\].RAM16.SLICE\[0\].RAM8.WORD\[1\].W.BYTE\[1\].B.GCLK VGND
+ VGND VPWR VPWR SLICE_16\[0\].RAM16.SLICE\[0\].RAM8.WORD\[1\].W.BYTE\[1\].B.Q_WIRE\[7\]
+ sky130_fd_sc_hd__dlxtp_1
XSLICE_16\[0\].RAM16.SLICE\[0\].RAM8.WORD\[7\].W.BYTE\[0\].B.BIT\[6\].genblk1.STORAGE
+ DIBUF\[6\].X SLICE_16\[0\].RAM16.SLICE\[0\].RAM8.WORD\[7\].W.BYTE\[0\].B.GCLK VGND
+ VGND VPWR VPWR SLICE_16\[0\].RAM16.SLICE\[0\].RAM8.WORD\[7\].W.BYTE\[0\].B.Q_WIRE\[6\]
+ sky130_fd_sc_hd__dlxtp_1
Xfill_43_97 VGND VGND VPWR VPWR sky130_fd_sc_hd__decap_12
Xfill_43_86 VGND VGND VPWR VPWR sky130_fd_sc_hd__decap_12
XSLICE_16\[0\].RAM16.SLICE\[0\].RAM8.WORD\[2\].W.BYTE\[3\].B.BIT\[2\].OBUF0 SLICE_16\[0\].RAM16.SLICE\[0\].RAM8.WORD\[2\].W.BYTE\[3\].B.Q_WIRE\[2\]
+ SLICE_16\[0\].RAM16.SLICE\[0\].RAM8.WORD\[2\].W.BYTE\[3\].B.SEL0_B VGND VGND VPWR
+ VPWR SLICE_16\[0\].RAM16.BYTE\[3\].FLOATBUF0\[26\].Z sky130_fd_sc_hd__ebufn_2
XSLICE_16\[0\].RAM16.SLICE\[0\].RAM8.WORD\[0\].W.BYTE\[3\].B.CGAND SLICE_16\[0\].RAM16.SLICE\[0\].RAM8.WORD\[0\].W.BYTE\[0\].B.SEL0
+ SLICE_16\[0\].RAM16.SLICE\[0\].RAM8.WE0_buf\[3\] VGND VGND VPWR VPWR SLICE_16\[0\].RAM16.SLICE\[0\].RAM8.WORD\[0\].W.BYTE\[3\].B.WE0_WIRE
+ sky130_fd_sc_hd__and2_1
Xfill_45_100 VGND VGND VPWR VPWR sky130_fd_sc_hd__decap_12
XSLICE_16\[1\].RAM16.SLICE\[0\].RAM8.WORD\[6\].W.BYTE\[3\].B.DIODE_CLK SLICE_16\[1\].RAM16.SLICE\[0\].RAM8.WORD\[6\].W.BYTE\[0\].B.CLK
+ VGND VGND VPWR VPWR sky130_fd_sc_hd__diode_2
Xfill_3_5 VGND VGND VPWR VPWR sky130_fd_sc_hd__decap_6
Xtap_6_17 VGND VPWR sky130_fd_sc_hd__tapvpwrvgnd_1
Xtap_6_28 VGND VPWR sky130_fd_sc_hd__tapvpwrvgnd_1
XSLICE_16\[1\].RAM16.SLICE\[1\].RAM8.WORD\[1\].W.BYTE\[0\].B.BIT\[4\].OBUF0 SLICE_16\[1\].RAM16.SLICE\[1\].RAM8.WORD\[1\].W.BYTE\[0\].B.Q_WIRE\[4\]
+ SLICE_16\[1\].RAM16.SLICE\[1\].RAM8.WORD\[1\].W.BYTE\[0\].B.SEL0_B VGND VGND VPWR
+ VPWR SLICE_16\[1\].RAM16.BYTE\[0\].FLOATBUF0\[4\].Z sky130_fd_sc_hd__ebufn_2
XSLICE_16\[0\].RAM16.SLICE\[1\].RAM8.WORD\[6\].W.BYTE\[2\].B.BIT\[0\].OBUF0 SLICE_16\[0\].RAM16.SLICE\[1\].RAM8.WORD\[6\].W.BYTE\[2\].B.Q_WIRE\[0\]
+ SLICE_16\[0\].RAM16.SLICE\[1\].RAM8.WORD\[6\].W.BYTE\[2\].B.SEL0_B VGND VGND VPWR
+ VPWR SLICE_16\[0\].RAM16.BYTE\[2\].FLOATBUF0\[16\].Z sky130_fd_sc_hd__ebufn_2
XSLICE_16\[1\].RAM16.SLICE\[1\].RAM8.WORD\[6\].W.BYTE\[2\].B.BIT\[5\].genblk1.STORAGE
+ DIBUF\[21\].X SLICE_16\[1\].RAM16.SLICE\[1\].RAM8.WORD\[6\].W.BYTE\[2\].B.GCLK VGND
+ VGND VPWR VPWR SLICE_16\[1\].RAM16.SLICE\[1\].RAM8.WORD\[6\].W.BYTE\[2\].B.Q_WIRE\[5\]
+ sky130_fd_sc_hd__dlxtp_1
XSLICE_16\[1\].RAM16.SLICE\[1\].RAM8.WORD\[5\].W.BYTE\[3\].B.BIT\[7\].OBUF0 SLICE_16\[1\].RAM16.SLICE\[1\].RAM8.WORD\[5\].W.BYTE\[3\].B.Q_WIRE\[7\]
+ SLICE_16\[1\].RAM16.SLICE\[1\].RAM8.WORD\[5\].W.BYTE\[3\].B.SEL0_B VGND VGND VPWR
+ VPWR SLICE_16\[1\].RAM16.BYTE\[3\].FLOATBUF0\[31\].Z sky130_fd_sc_hd__ebufn_2
XSLICE_16\[1\].RAM16.SLICE\[1\].RAM8.WORD\[0\].W.BYTE\[3\].B.BIT\[6\].genblk1.STORAGE
+ DIBUF\[30\].X SLICE_16\[1\].RAM16.SLICE\[1\].RAM8.WORD\[0\].W.BYTE\[3\].B.GCLK VGND
+ VGND VPWR VPWR SLICE_16\[1\].RAM16.SLICE\[1\].RAM8.WORD\[0\].W.BYTE\[3\].B.Q_WIRE\[6\]
+ sky130_fd_sc_hd__dlxtp_1
Xtap_25_35 VGND VPWR sky130_fd_sc_hd__tapvpwrvgnd_1
Xtap_25_24 VGND VPWR sky130_fd_sc_hd__tapvpwrvgnd_1
Xtap_25_13 VGND VPWR sky130_fd_sc_hd__tapvpwrvgnd_1
Xtap_13_8 VGND VPWR sky130_fd_sc_hd__tapvpwrvgnd_1
XSLICE_16\[0\].RAM16.SLICE\[1\].RAM8.WORD\[3\].W.BYTE\[3\].B.DIODE_CLK SLICE_16\[0\].RAM16.SLICE\[1\].RAM8.WORD\[3\].W.BYTE\[0\].B.CLK
+ VGND VGND VPWR VPWR sky130_fd_sc_hd__diode_2
Xtap_6_7 VGND VPWR sky130_fd_sc_hd__tapvpwrvgnd_1
XSLICE_16\[1\].RAM16.SLICE\[1\].RAM8.WORD\[4\].W.BYTE\[0\].B.BIT\[4\].genblk1.STORAGE
+ DIBUF\[4\].X SLICE_16\[1\].RAM16.SLICE\[1\].RAM8.WORD\[4\].W.BYTE\[0\].B.GCLK VGND
+ VGND VPWR VPWR SLICE_16\[1\].RAM16.SLICE\[1\].RAM8.WORD\[4\].W.BYTE\[0\].B.Q_WIRE\[4\]
+ sky130_fd_sc_hd__dlxtp_1
XSLICE_16\[1\].RAM16.SLICE\[1\].RAM8.WORD\[5\].W.BYTE\[0\].B.DIODE_CLK SLICE_16\[1\].RAM16.SLICE\[1\].RAM8.WORD\[5\].W.BYTE\[0\].B.CLK
+ VGND VGND VPWR VPWR sky130_fd_sc_hd__diode_2
XSLICE_16\[1\].RAM16.SLICE\[0\].RAM8.WORD\[5\].W.BYTE\[2\].B.BIT\[0\].genblk1.STORAGE
+ DIBUF\[16\].X SLICE_16\[1\].RAM16.SLICE\[0\].RAM8.WORD\[5\].W.BYTE\[2\].B.GCLK VGND
+ VGND VPWR VPWR SLICE_16\[1\].RAM16.SLICE\[0\].RAM8.WORD\[5\].W.BYTE\[2\].B.Q_WIRE\[0\]
+ sky130_fd_sc_hd__dlxtp_1
XSLICE_16\[1\].RAM16.SLICE\[0\].RAM8.WORD\[0\].W.BYTE\[2\].B.BIT\[6\].OBUF0 SLICE_16\[1\].RAM16.SLICE\[0\].RAM8.WORD\[0\].W.BYTE\[2\].B.Q_WIRE\[6\]
+ SLICE_16\[1\].RAM16.SLICE\[0\].RAM8.WORD\[0\].W.BYTE\[2\].B.SEL0_B VGND VGND VPWR
+ VPWR SLICE_16\[1\].RAM16.BYTE\[2\].FLOATBUF0\[22\].Z sky130_fd_sc_hd__ebufn_2
XSLICE_16\[0\].RAM16.SLICE\[1\].RAM8.WORD\[7\].W.BYTE\[2\].B.BIT\[1\].genblk1.STORAGE
+ DIBUF\[17\].X SLICE_16\[0\].RAM16.SLICE\[1\].RAM8.WORD\[7\].W.BYTE\[2\].B.GCLK VGND
+ VGND VPWR VPWR SLICE_16\[0\].RAM16.SLICE\[1\].RAM8.WORD\[7\].W.BYTE\[2\].B.Q_WIRE\[1\]
+ sky130_fd_sc_hd__dlxtp_1
Xtap_32_0 VGND VPWR sky130_fd_sc_hd__tapvpwrvgnd_1
XSLICE_16\[0\].RAM16.SLICE\[1\].RAM8.WORD\[5\].W.BYTE\[0\].B.BIT\[0\].genblk1.STORAGE
+ DIBUF\[0\].X SLICE_16\[0\].RAM16.SLICE\[1\].RAM8.WORD\[5\].W.BYTE\[0\].B.GCLK VGND
+ VGND VPWR VPWR SLICE_16\[0\].RAM16.SLICE\[1\].RAM8.WORD\[5\].W.BYTE\[0\].B.Q_WIRE\[0\]
+ sky130_fd_sc_hd__dlxtp_1
XDIBUF\[11\].__cell__ Di0[11] VGND VGND VPWR VPWR DIBUF\[11\].X sky130_fd_sc_hd__clkbuf_16
XSLICE_16\[0\].RAM16.SLICE\[1\].RAM8.WORD\[1\].W.BYTE\[3\].B.BIT\[2\].genblk1.STORAGE
+ DIBUF\[26\].X SLICE_16\[0\].RAM16.SLICE\[1\].RAM8.WORD\[1\].W.BYTE\[3\].B.GCLK VGND
+ VGND VPWR VPWR SLICE_16\[0\].RAM16.SLICE\[1\].RAM8.WORD\[1\].W.BYTE\[3\].B.Q_WIRE\[2\]
+ sky130_fd_sc_hd__dlxtp_1
XSLICE_16\[1\].RAM16.SLICE\[1\].RAM8.WORD\[0\].W.BYTE\[2\].B.SEL0INV SLICE_16\[1\].RAM16.SLICE\[1\].RAM8.WORD\[0\].W.BYTE\[0\].B.SEL0
+ VGND VGND VPWR VPWR SLICE_16\[1\].RAM16.SLICE\[1\].RAM8.WORD\[0\].W.BYTE\[2\].B.SEL0_B
+ sky130_fd_sc_hd__inv_1
XSLICE_16\[0\].RAM16.SLICE\[1\].RAM8.WORD\[6\].W.BYTE\[0\].B.SEL0INV SLICE_16\[0\].RAM16.SLICE\[1\].RAM8.WORD\[6\].W.BYTE\[0\].B.SEL0
+ VGND VGND VPWR VPWR SLICE_16\[0\].RAM16.SLICE\[1\].RAM8.WORD\[6\].W.BYTE\[0\].B.SEL0_B
+ sky130_fd_sc_hd__inv_1
XSLICE_16\[0\].RAM16.SLICE\[0\].RAM8.WORD\[2\].W.BYTE\[1\].B.BIT\[7\].OBUF0 SLICE_16\[0\].RAM16.SLICE\[0\].RAM8.WORD\[2\].W.BYTE\[1\].B.Q_WIRE\[7\]
+ SLICE_16\[0\].RAM16.SLICE\[0\].RAM8.WORD\[2\].W.BYTE\[1\].B.SEL0_B VGND VGND VPWR
+ VPWR SLICE_16\[0\].RAM16.BYTE\[1\].FLOATBUF0\[15\].Z sky130_fd_sc_hd__ebufn_2
Xfill_42_103 VGND VGND VPWR VPWR sky130_fd_sc_hd__decap_6
XDo0MUX.M\[3\].DIODE_A0MUX\[29\] Do0MUX.A0\[29\] VGND VGND VPWR VPWR sky130_fd_sc_hd__diode_2
XSLICE_16\[1\].RAM16.Do0_REG.OUTREG_BYTE\[2\].DIODE\[4\] SLICE_16\[1\].RAM16.BYTE\[2\].FLOATBUF0\[20\].Z
+ VGND VGND VPWR VPWR sky130_fd_sc_hd__diode_2
XSLICE_16\[1\].RAM16.SLICE\[1\].RAM8.WORD\[4\].W.BYTE\[1\].B.BIT\[4\].OBUF0 SLICE_16\[1\].RAM16.SLICE\[1\].RAM8.WORD\[4\].W.BYTE\[1\].B.Q_WIRE\[4\]
+ SLICE_16\[1\].RAM16.SLICE\[1\].RAM8.WORD\[4\].W.BYTE\[1\].B.SEL0_B VGND VGND VPWR
+ VPWR SLICE_16\[1\].RAM16.BYTE\[1\].FLOATBUF0\[12\].Z sky130_fd_sc_hd__ebufn_2
Xfill_46_2 VGND VGND VPWR VPWR sky130_fd_sc_hd__decap_4
Xfill_39_1 VGND VGND VPWR VPWR sky130_fd_sc_hd__decap_12
XSLICE_16\[0\].RAM16.SLICE\[1\].RAM8.DEC0.AND2 SLICE_16\[0\].RAM16.SLICE\[1\].RAM8.DEC0.A_buf\[2\]
+ SLICE_16\[0\].RAM16.SLICE\[1\].RAM8.DEC0.A_buf\[0\] SLICE_16\[0\].RAM16.SLICE\[1\].RAM8.DEC0.A_buf\[1\]
+ SLICE_16\[0\].RAM16.SLICE\[1\].RAM8.DEC0.EN_buf VGND VGND VPWR VPWR SLICE_16\[0\].RAM16.SLICE\[1\].RAM8.DEC0.SEL\[2\]
+ sky130_fd_sc_hd__and4bb_2
XSLICE_16\[0\].RAM16.SLICE\[0\].RAM8.WORD\[4\].W.BYTE\[2\].B.BIT\[7\].genblk1.STORAGE
+ DIBUF\[23\].X SLICE_16\[0\].RAM16.SLICE\[0\].RAM8.WORD\[4\].W.BYTE\[2\].B.GCLK VGND
+ VGND VPWR VPWR SLICE_16\[0\].RAM16.SLICE\[0\].RAM8.WORD\[4\].W.BYTE\[2\].B.Q_WIRE\[7\]
+ sky130_fd_sc_hd__dlxtp_1
XSLICE_16\[0\].RAM16.SLICE\[1\].RAM8.WORD\[6\].W.BYTE\[0\].B.BIT\[5\].OBUF0 SLICE_16\[0\].RAM16.SLICE\[1\].RAM8.WORD\[6\].W.BYTE\[0\].B.Q_WIRE\[5\]
+ SLICE_16\[0\].RAM16.SLICE\[1\].RAM8.WORD\[6\].W.BYTE\[0\].B.SEL0_B VGND VGND VPWR
+ VPWR SLICE_16\[0\].RAM16.BYTE\[0\].FLOATBUF0\[5\].Z sky130_fd_sc_hd__ebufn_2
XSLICE_16\[0\].RAM16.SLICE\[0\].RAM8.WORD\[2\].W.BYTE\[0\].B.BIT\[6\].genblk1.STORAGE
+ DIBUF\[6\].X SLICE_16\[0\].RAM16.SLICE\[0\].RAM8.WORD\[2\].W.BYTE\[0\].B.GCLK VGND
+ VGND VPWR VPWR SLICE_16\[0\].RAM16.SLICE\[0\].RAM8.WORD\[2\].W.BYTE\[0\].B.Q_WIRE\[6\]
+ sky130_fd_sc_hd__dlxtp_1
Xfill_1_2 VGND VPWR sky130_fd_sc_hd__tapvpwrvgnd_1
XSLICE_16\[0\].RAM16.SLICE\[1\].RAM8.WORD\[1\].W.BYTE\[2\].B.CGAND SLICE_16\[0\].RAM16.SLICE\[1\].RAM8.WORD\[1\].W.BYTE\[0\].B.SEL0
+ SLICE_16\[0\].RAM16.SLICE\[1\].RAM8.WE0_buf\[2\] VGND VGND VPWR VPWR SLICE_16\[0\].RAM16.SLICE\[1\].RAM8.WORD\[1\].W.BYTE\[2\].B.WE0_WIRE
+ sky130_fd_sc_hd__and2_1
XSLICE_16\[1\].RAM16.SLICE\[0\].RAM8.WORD\[3\].W.BYTE\[3\].B.BIT\[6\].OBUF0 SLICE_16\[1\].RAM16.SLICE\[0\].RAM8.WORD\[3\].W.BYTE\[3\].B.Q_WIRE\[6\]
+ SLICE_16\[1\].RAM16.SLICE\[0\].RAM8.WORD\[3\].W.BYTE\[3\].B.SEL0_B VGND VGND VPWR
+ VPWR SLICE_16\[1\].RAM16.BYTE\[3\].FLOATBUF0\[30\].Z sky130_fd_sc_hd__ebufn_2
Xtap_11_15 VGND VPWR sky130_fd_sc_hd__tapvpwrvgnd_1
Xtap_11_26 VGND VPWR sky130_fd_sc_hd__tapvpwrvgnd_1
XSLICE_16\[1\].RAM16.Do0_REG.Do_CLKBUF\[1\] SLICE_16\[1\].RAM16.Do0_REG.CLK_buf VGND
+ VGND VPWR VPWR SLICE_16\[1\].RAM16.Do0_REG.CLKBUF\[1\] sky130_fd_sc_hd__clkbuf_4
Xtap_36_12 VGND VPWR sky130_fd_sc_hd__tapvpwrvgnd_1
Xtap_11_5 VGND VPWR sky130_fd_sc_hd__tapvpwrvgnd_1
XSLICE_16\[0\].RAM16.SLICE\[1\].RAM8.WORD\[2\].W.BYTE\[3\].B.genblk1.CG SLICE_16\[0\].RAM16.SLICE\[1\].RAM8.WORD\[2\].W.BYTE\[3\].B.CLK_B
+ SLICE_16\[0\].RAM16.SLICE\[1\].RAM8.WORD\[2\].W.BYTE\[3\].B.WE0_WIRE VGND VGND VPWR
+ VPWR SLICE_16\[0\].RAM16.SLICE\[1\].RAM8.WORD\[2\].W.BYTE\[3\].B.GCLK sky130_fd_sc_hd__dlclkp_1
Xtap_36_34 VGND VPWR sky130_fd_sc_hd__tapvpwrvgnd_1
Xtap_36_23 VGND VPWR sky130_fd_sc_hd__tapvpwrvgnd_1
Xtap_4_4 VGND VPWR sky130_fd_sc_hd__tapvpwrvgnd_1
XSLICE_16\[0\].RAM16.SLICE\[0\].RAM8.WORD\[5\].W.BYTE\[2\].B.BIT\[7\].OBUF0 SLICE_16\[0\].RAM16.SLICE\[0\].RAM8.WORD\[5\].W.BYTE\[2\].B.Q_WIRE\[7\]
+ SLICE_16\[0\].RAM16.SLICE\[0\].RAM8.WORD\[5\].W.BYTE\[2\].B.SEL0_B VGND VGND VPWR
+ VPWR SLICE_16\[0\].RAM16.BYTE\[2\].FLOATBUF0\[23\].Z sky130_fd_sc_hd__ebufn_2
XSLICE_16\[1\].RAM16.SLICE\[1\].RAM8.WORD\[7\].W.BYTE\[2\].B.BIT\[4\].OBUF0 SLICE_16\[1\].RAM16.SLICE\[1\].RAM8.WORD\[7\].W.BYTE\[2\].B.Q_WIRE\[4\]
+ SLICE_16\[1\].RAM16.SLICE\[1\].RAM8.WORD\[7\].W.BYTE\[2\].B.SEL0_B VGND VGND VPWR
+ VPWR SLICE_16\[1\].RAM16.BYTE\[2\].FLOATBUF0\[20\].Z sky130_fd_sc_hd__ebufn_2
Xfill_40_21 VGND VPWR sky130_fd_sc_hd__tapvpwrvgnd_1
Xfill_40_10 VGND VGND VPWR VPWR sky130_fd_sc_hd__decap_12
XSLICE_16\[1\].RAM16.SLICE\[1\].RAM8.WORD\[7\].W.BYTE\[1\].B.BIT\[4\].genblk1.STORAGE
+ DIBUF\[12\].X SLICE_16\[1\].RAM16.SLICE\[1\].RAM8.WORD\[7\].W.BYTE\[1\].B.GCLK VGND
+ VGND VPWR VPWR SLICE_16\[1\].RAM16.SLICE\[1\].RAM8.WORD\[7\].W.BYTE\[1\].B.Q_WIRE\[4\]
+ sky130_fd_sc_hd__dlxtp_1
XSLICE_16\[1\].RAM16.SLICE\[1\].RAM8.WORD\[1\].W.BYTE\[2\].B.BIT\[5\].genblk1.STORAGE
+ DIBUF\[21\].X SLICE_16\[1\].RAM16.SLICE\[1\].RAM8.WORD\[1\].W.BYTE\[2\].B.GCLK VGND
+ VGND VPWR VPWR SLICE_16\[1\].RAM16.SLICE\[1\].RAM8.WORD\[1\].W.BYTE\[2\].B.Q_WIRE\[5\]
+ sky130_fd_sc_hd__dlxtp_1
XSLICE_16\[1\].RAM16.SLICE\[0\].RAM8.WORD\[2\].W.BYTE\[1\].B.BIT\[3\].OBUF0 SLICE_16\[1\].RAM16.SLICE\[0\].RAM8.WORD\[2\].W.BYTE\[1\].B.Q_WIRE\[3\]
+ SLICE_16\[1\].RAM16.SLICE\[0\].RAM8.WORD\[2\].W.BYTE\[1\].B.SEL0_B VGND VGND VPWR
+ VPWR SLICE_16\[1\].RAM16.BYTE\[1\].FLOATBUF0\[11\].Z sky130_fd_sc_hd__ebufn_2
XSLICE_16\[1\].RAM16.SLICE\[0\].RAM8.WORD\[0\].W.BYTE\[2\].B.BIT\[0\].genblk1.STORAGE
+ DIBUF\[16\].X SLICE_16\[1\].RAM16.SLICE\[0\].RAM8.WORD\[0\].W.BYTE\[2\].B.GCLK VGND
+ VGND VPWR VPWR SLICE_16\[1\].RAM16.SLICE\[0\].RAM8.WORD\[0\].W.BYTE\[2\].B.Q_WIRE\[0\]
+ sky130_fd_sc_hd__dlxtp_1
Xfill_18_6 VGND VPWR sky130_fd_sc_hd__tapvpwrvgnd_1
XSLICE_16\[0\].RAM16.SLICE\[1\].RAM8.DEC0.ENBUF SLICE_16\[0\].RAM16.DEC0.SEL\[1\]
+ VGND VGND VPWR VPWR SLICE_16\[0\].RAM16.SLICE\[1\].RAM8.DEC0.EN_buf sky130_fd_sc_hd__clkbuf_2
XSLICE_16\[1\].RAM16.Do0_REG.OUTREG_BYTE\[1\].Do_FF\[5\] SLICE_16\[1\].RAM16.Do0_REG.CLKBUF\[1\]
+ SLICE_16\[1\].RAM16.BYTE\[1\].FLOATBUF0\[13\].Z VGND VGND VPWR VPWR Do0MUX.A1\[13\]
+ sky130_fd_sc_hd__dfxtp_1
XSLICE_16\[0\].RAM16.SLICE\[1\].RAM8.WORD\[2\].W.BYTE\[2\].B.BIT\[1\].genblk1.STORAGE
+ DIBUF\[17\].X SLICE_16\[0\].RAM16.SLICE\[1\].RAM8.WORD\[2\].W.BYTE\[2\].B.GCLK VGND
+ VGND VPWR VPWR SLICE_16\[0\].RAM16.SLICE\[1\].RAM8.WORD\[2\].W.BYTE\[2\].B.Q_WIRE\[1\]
+ sky130_fd_sc_hd__dlxtp_1
Xtap_3_18 VGND VPWR sky130_fd_sc_hd__tapvpwrvgnd_1
Xtap_3_29 VGND VPWR sky130_fd_sc_hd__tapvpwrvgnd_1
XSLICE_16\[0\].RAM16.SLICE\[0\].RAM8.WORD\[4\].W.BYTE\[0\].B.BIT\[4\].OBUF0 SLICE_16\[0\].RAM16.SLICE\[0\].RAM8.WORD\[4\].W.BYTE\[0\].B.Q_WIRE\[4\]
+ SLICE_16\[0\].RAM16.SLICE\[0\].RAM8.WORD\[4\].W.BYTE\[0\].B.SEL0_B VGND VGND VPWR
+ VPWR SLICE_16\[0\].RAM16.BYTE\[0\].FLOATBUF0\[4\].Z sky130_fd_sc_hd__ebufn_2
XSLICE_16\[0\].RAM16.SLICE\[1\].RAM8.WORD\[0\].W.BYTE\[0\].B.BIT\[0\].genblk1.STORAGE
+ DIBUF\[0\].X SLICE_16\[0\].RAM16.SLICE\[1\].RAM8.WORD\[0\].W.BYTE\[0\].B.GCLK VGND
+ VGND VPWR VPWR SLICE_16\[0\].RAM16.SLICE\[1\].RAM8.WORD\[0\].W.BYTE\[0\].B.Q_WIRE\[0\]
+ sky130_fd_sc_hd__dlxtp_1
XSLICE_16\[1\].RAM16.SLICE\[1\].RAM8.WORD\[6\].W.BYTE\[0\].B.BIT\[1\].OBUF0 SLICE_16\[1\].RAM16.SLICE\[1\].RAM8.WORD\[6\].W.BYTE\[0\].B.Q_WIRE\[1\]
+ SLICE_16\[1\].RAM16.SLICE\[1\].RAM8.WORD\[6\].W.BYTE\[0\].B.SEL0_B VGND VGND VPWR
+ VPWR SLICE_16\[1\].RAM16.BYTE\[0\].FLOATBUF0\[1\].Z sky130_fd_sc_hd__ebufn_2
XSLICE_16\[0\].RAM16.SLICE\[0\].RAM8.WORD\[7\].W.BYTE\[3\].B.BIT\[7\].genblk1.STORAGE
+ DIBUF\[31\].X SLICE_16\[0\].RAM16.SLICE\[0\].RAM8.WORD\[7\].W.BYTE\[3\].B.GCLK VGND
+ VGND VPWR VPWR SLICE_16\[0\].RAM16.SLICE\[0\].RAM8.WORD\[7\].W.BYTE\[3\].B.Q_WIRE\[7\]
+ sky130_fd_sc_hd__dlxtp_1
XSLICE_16\[1\].RAM16.SLICE\[0\].RAM8.WORD\[6\].W.BYTE\[1\].B.genblk1.CG SLICE_16\[1\].RAM16.SLICE\[0\].RAM8.WORD\[6\].W.BYTE\[1\].B.CLK_B
+ SLICE_16\[1\].RAM16.SLICE\[0\].RAM8.WORD\[6\].W.BYTE\[1\].B.WE0_WIRE VGND VGND VPWR
+ VPWR SLICE_16\[1\].RAM16.SLICE\[0\].RAM8.WORD\[6\].W.BYTE\[1\].B.GCLK sky130_fd_sc_hd__dlclkp_1
XSLICE_16\[0\].RAM16.Do0_REG.OUTREG_BYTE\[3\].Do_FF\[2\] SLICE_16\[0\].RAM16.Do0_REG.CLKBUF\[3\]
+ SLICE_16\[0\].RAM16.BYTE\[3\].FLOATBUF0\[26\].Z VGND VGND VPWR VPWR Do0MUX.A0\[26\]
+ sky130_fd_sc_hd__dfxtp_1
XSLICE_16\[0\].RAM16.SLICE\[0\].RAM8.WORD\[5\].W.BYTE\[1\].B.BIT\[6\].genblk1.STORAGE
+ DIBUF\[14\].X SLICE_16\[0\].RAM16.SLICE\[0\].RAM8.WORD\[5\].W.BYTE\[1\].B.GCLK VGND
+ VGND VPWR VPWR SLICE_16\[0\].RAM16.SLICE\[0\].RAM8.WORD\[5\].W.BYTE\[1\].B.Q_WIRE\[6\]
+ sky130_fd_sc_hd__dlxtp_1
Xtap_47_11 VGND VPWR sky130_fd_sc_hd__tapvpwrvgnd_1
XSLICE_16\[1\].RAM16.SLICE\[0\].RAM8.WORD\[5\].W.BYTE\[2\].B.BIT\[3\].OBUF0 SLICE_16\[1\].RAM16.SLICE\[0\].RAM8.WORD\[5\].W.BYTE\[2\].B.Q_WIRE\[3\]
+ SLICE_16\[1\].RAM16.SLICE\[0\].RAM8.WORD\[5\].W.BYTE\[2\].B.SEL0_B VGND VGND VPWR
+ VPWR SLICE_16\[1\].RAM16.BYTE\[2\].FLOATBUF0\[19\].Z sky130_fd_sc_hd__ebufn_2
Xfill_19_66 VGND VPWR sky130_fd_sc_hd__tapvpwrvgnd_1
Xfill_19_55 VGND VGND VPWR VPWR sky130_fd_sc_hd__decap_12
Xfill_19_44 VGND VGND VPWR VPWR sky130_fd_sc_hd__decap_12
Xfill_19_33 VGND VPWR sky130_fd_sc_hd__tapvpwrvgnd_1
Xfill_19_22 VGND VGND VPWR VPWR sky130_fd_sc_hd__decap_12
Xfill_19_11 VGND VGND VPWR VPWR sky130_fd_sc_hd__decap_12
XSLICE_16\[1\].RAM16.A0BUF\[2\].__cell__ A0BUF\[2\].X VGND VGND VPWR VPWR SLICE_16\[1\].RAM16.A0BUF\[2\].X
+ sky130_fd_sc_hd__clkbuf_2
XSLICE_16\[1\].RAM16.FBUFENBUF0\[3\].__cell__ DEC0.SEL\[1\] VGND VGND VPWR VPWR SLICE_16\[1\].RAM16.BYTE\[3\].FLOATBUF0\[24\].TE_B
+ sky130_fd_sc_hd__clkbuf_2
Xfill_19_99 VGND VPWR sky130_fd_sc_hd__tapvpwrvgnd_1
Xfill_19_88 VGND VGND VPWR VPWR sky130_fd_sc_hd__decap_12
Xfill_19_77 VGND VGND VPWR VPWR sky130_fd_sc_hd__decap_12
Xtap_2_1 VGND VPWR sky130_fd_sc_hd__tapvpwrvgnd_1
XSLICE_16\[1\].RAM16.SLICE\[1\].RAM8.WORD\[4\].W.BYTE\[0\].B.SEL0INV SLICE_16\[1\].RAM16.SLICE\[1\].RAM8.WORD\[4\].W.BYTE\[0\].B.SEL0
+ VGND VGND VPWR VPWR SLICE_16\[1\].RAM16.SLICE\[1\].RAM8.WORD\[4\].W.BYTE\[0\].B.SEL0_B
+ sky130_fd_sc_hd__inv_1
XSLICE_16\[0\].RAM16.SLICE\[0\].RAM8.WORD\[7\].W.BYTE\[1\].B.BIT\[4\].OBUF0 SLICE_16\[0\].RAM16.SLICE\[0\].RAM8.WORD\[7\].W.BYTE\[1\].B.Q_WIRE\[4\]
+ SLICE_16\[0\].RAM16.SLICE\[0\].RAM8.WORD\[7\].W.BYTE\[1\].B.SEL0_B VGND VGND VPWR
+ VPWR SLICE_16\[0\].RAM16.BYTE\[1\].FLOATBUF0\[12\].Z sky130_fd_sc_hd__ebufn_2
Xfill_30_5 VGND VPWR sky130_fd_sc_hd__tapvpwrvgnd_1
Xfill_16_3 VGND VPWR sky130_fd_sc_hd__tapvpwrvgnd_1
XSLICE_16\[1\].RAM16.SLICE\[1\].RAM8.WORD\[4\].W.BYTE\[3\].B.BIT\[5\].genblk1.STORAGE
+ DIBUF\[29\].X SLICE_16\[1\].RAM16.SLICE\[1\].RAM8.WORD\[4\].W.BYTE\[3\].B.GCLK VGND
+ VGND VPWR VPWR SLICE_16\[1\].RAM16.SLICE\[1\].RAM8.WORD\[4\].W.BYTE\[3\].B.Q_WIRE\[5\]
+ sky130_fd_sc_hd__dlxtp_1
XSLICE_16\[1\].RAM16.SLICE\[0\].RAM8.WORD\[4\].W.BYTE\[0\].B.BIT\[0\].OBUF0 SLICE_16\[1\].RAM16.SLICE\[0\].RAM8.WORD\[4\].W.BYTE\[0\].B.Q_WIRE\[0\]
+ SLICE_16\[1\].RAM16.SLICE\[0\].RAM8.WORD\[4\].W.BYTE\[0\].B.SEL0_B VGND VGND VPWR
+ VPWR SLICE_16\[1\].RAM16.BYTE\[0\].FLOATBUF0\[0\].Z sky130_fd_sc_hd__ebufn_2
XSLICE_16\[1\].RAM16.SLICE\[1\].RAM8.WORD\[2\].W.BYTE\[1\].B.BIT\[4\].genblk1.STORAGE
+ DIBUF\[12\].X SLICE_16\[1\].RAM16.SLICE\[1\].RAM8.WORD\[2\].W.BYTE\[1\].B.GCLK VGND
+ VGND VPWR VPWR SLICE_16\[1\].RAM16.SLICE\[1\].RAM8.WORD\[2\].W.BYTE\[1\].B.Q_WIRE\[4\]
+ sky130_fd_sc_hd__dlxtp_1
XSLICE_16\[1\].RAM16.SLICE\[1\].RAM8.WORD\[0\].W.BYTE\[3\].B.BIT\[6\].OBUF0 SLICE_16\[1\].RAM16.SLICE\[1\].RAM8.WORD\[0\].W.BYTE\[3\].B.Q_WIRE\[6\]
+ SLICE_16\[1\].RAM16.SLICE\[1\].RAM8.WORD\[0\].W.BYTE\[3\].B.SEL0_B VGND VGND VPWR
+ VPWR SLICE_16\[1\].RAM16.BYTE\[3\].FLOATBUF0\[30\].Z sky130_fd_sc_hd__ebufn_2
XSLICE_16\[1\].RAM16.SLICE\[0\].RAM8.WORD\[3\].W.BYTE\[3\].B.BIT\[0\].genblk1.STORAGE
+ DIBUF\[24\].X SLICE_16\[1\].RAM16.SLICE\[0\].RAM8.WORD\[3\].W.BYTE\[3\].B.GCLK VGND
+ VGND VPWR VPWR SLICE_16\[1\].RAM16.SLICE\[0\].RAM8.WORD\[3\].W.BYTE\[3\].B.Q_WIRE\[0\]
+ sky130_fd_sc_hd__dlxtp_1
Xtap_33_35 VGND VPWR sky130_fd_sc_hd__tapvpwrvgnd_1
Xtap_33_24 VGND VPWR sky130_fd_sc_hd__tapvpwrvgnd_1
Xtap_33_13 VGND VPWR sky130_fd_sc_hd__tapvpwrvgnd_1
XSLICE_16\[0\].RAM16.Do0_REG.OUTREG_BYTE\[0\].DIODE\[5\] SLICE_16\[0\].RAM16.BYTE\[0\].FLOATBUF0\[5\].Z
+ VGND VGND VPWR VPWR sky130_fd_sc_hd__diode_2
XSLICE_16\[0\].RAM16.BYTE\[0\].FLOATBUF0\[2\].__cell__ SLICE_16\[0\].RAM16.BYTE\[0\].FLOATBUF0\[0\].A
+ SLICE_16\[0\].RAM16.BYTE\[0\].FLOATBUF0\[0\].TE_B VGND VGND VPWR VPWR SLICE_16\[0\].RAM16.BYTE\[0\].FLOATBUF0\[2\].Z
+ sky130_fd_sc_hd__ebufn_2
XSLICE_16\[0\].RAM16.SLICE\[1\].RAM8.WORD\[5\].W.BYTE\[3\].B.BIT\[1\].genblk1.STORAGE
+ DIBUF\[25\].X SLICE_16\[0\].RAM16.SLICE\[1\].RAM8.WORD\[5\].W.BYTE\[3\].B.GCLK VGND
+ VGND VPWR VPWR SLICE_16\[0\].RAM16.SLICE\[1\].RAM8.WORD\[5\].W.BYTE\[3\].B.Q_WIRE\[1\]
+ sky130_fd_sc_hd__dlxtp_1
Xfill_21_23 VGND VGND VPWR VPWR sky130_fd_sc_hd__decap_12
Xfill_21_12 VGND VPWR sky130_fd_sc_hd__tapvpwrvgnd_1
XSLICE_16\[0\].RAM16.SLICE\[1\].RAM8.WORD\[3\].W.BYTE\[1\].B.BIT\[0\].genblk1.STORAGE
+ DIBUF\[8\].X SLICE_16\[0\].RAM16.SLICE\[1\].RAM8.WORD\[3\].W.BYTE\[1\].B.GCLK VGND
+ VGND VPWR VPWR SLICE_16\[0\].RAM16.SLICE\[1\].RAM8.WORD\[3\].W.BYTE\[1\].B.Q_WIRE\[0\]
+ sky130_fd_sc_hd__dlxtp_1
XSLICE_16\[0\].RAM16.SLICE\[1\].RAM8.WORD\[2\].W.BYTE\[1\].B.SEL0INV SLICE_16\[0\].RAM16.SLICE\[1\].RAM8.WORD\[2\].W.BYTE\[0\].B.SEL0
+ VGND VGND VPWR VPWR SLICE_16\[0\].RAM16.SLICE\[1\].RAM8.WORD\[2\].W.BYTE\[1\].B.SEL0_B
+ sky130_fd_sc_hd__inv_1
Xfill_21_89 VGND VGND VPWR VPWR sky130_fd_sc_hd__decap_12
Xfill_21_78 VGND VPWR sky130_fd_sc_hd__tapvpwrvgnd_1
Xfill_21_67 VGND VGND VPWR VPWR sky130_fd_sc_hd__decap_12
Xfill_21_56 VGND VGND VPWR VPWR sky130_fd_sc_hd__decap_12
Xfill_21_45 VGND VPWR sky130_fd_sc_hd__tapvpwrvgnd_1
Xfill_21_34 VGND VGND VPWR VPWR sky130_fd_sc_hd__decap_12
XSLICE_16\[0\].RAM16.CLKBUF.__cell__ CLK VGND VGND VPWR VPWR SLICE_16\[0\].RAM16.CLKBUF.X
+ sky130_fd_sc_hd__clkbuf_4
XSLICE_16\[0\].RAM16.SLICE\[1\].RAM8.WORD\[2\].W.BYTE\[2\].B.BIT\[7\].OBUF0 SLICE_16\[0\].RAM16.SLICE\[1\].RAM8.WORD\[2\].W.BYTE\[2\].B.Q_WIRE\[7\]
+ SLICE_16\[0\].RAM16.SLICE\[1\].RAM8.WORD\[2\].W.BYTE\[2\].B.SEL0_B VGND VGND VPWR
+ VPWR SLICE_16\[0\].RAM16.BYTE\[2\].FLOATBUF0\[23\].Z sky130_fd_sc_hd__ebufn_2
Xfill_46_53 VGND VGND VPWR VPWR sky130_fd_sc_hd__decap_4
Xfill_46_42 VGND VPWR sky130_fd_sc_hd__tapvpwrvgnd_1
Xfill_46_31 VGND VPWR sky130_fd_sc_hd__tapvpwrvgnd_1
Xfill_46_20 VGND VGND VPWR VPWR sky130_fd_sc_hd__decap_4
Xfill_46_97 VGND VGND VPWR VPWR sky130_fd_sc_hd__decap_12
Xfill_46_86 VGND VGND VPWR VPWR sky130_fd_sc_hd__decap_12
Xfill_46_75 VGND VPWR sky130_fd_sc_hd__tapvpwrvgnd_1
Xfill_46_64 VGND VPWR sky130_fd_sc_hd__tapvpwrvgnd_1
XSLICE_16\[0\].RAM16.SLICE\[0\].RAM8.WORD\[2\].W.BYTE\[3\].B.BIT\[7\].genblk1.STORAGE
+ DIBUF\[31\].X SLICE_16\[0\].RAM16.SLICE\[0\].RAM8.WORD\[2\].W.BYTE\[3\].B.GCLK VGND
+ VGND VPWR VPWR SLICE_16\[0\].RAM16.SLICE\[0\].RAM8.WORD\[2\].W.BYTE\[3\].B.Q_WIRE\[7\]
+ sky130_fd_sc_hd__dlxtp_1
XSLICE_16\[1\].RAM16.SLICE\[0\].RAM8.WORD\[7\].W.BYTE\[1\].B.BIT\[0\].OBUF0 SLICE_16\[1\].RAM16.SLICE\[0\].RAM8.WORD\[7\].W.BYTE\[1\].B.Q_WIRE\[0\]
+ SLICE_16\[1\].RAM16.SLICE\[0\].RAM8.WORD\[7\].W.BYTE\[1\].B.SEL0_B VGND VGND VPWR
+ VPWR SLICE_16\[1\].RAM16.BYTE\[1\].FLOATBUF0\[8\].Z sky130_fd_sc_hd__ebufn_2
XSLICE_16\[0\].RAM16.SLICE\[0\].RAM8.WORD\[0\].W.BYTE\[1\].B.BIT\[6\].genblk1.STORAGE
+ DIBUF\[14\].X SLICE_16\[0\].RAM16.SLICE\[0\].RAM8.WORD\[0\].W.BYTE\[1\].B.GCLK VGND
+ VGND VPWR VPWR SLICE_16\[0\].RAM16.SLICE\[0\].RAM8.WORD\[0\].W.BYTE\[1\].B.Q_WIRE\[6\]
+ sky130_fd_sc_hd__dlxtp_1
XSLICE_16\[0\].RAM16.SLICE\[0\].RAM8.WORD\[6\].W.BYTE\[0\].B.BIT\[5\].genblk1.STORAGE
+ DIBUF\[5\].X SLICE_16\[0\].RAM16.SLICE\[0\].RAM8.WORD\[6\].W.BYTE\[0\].B.GCLK VGND
+ VGND VPWR VPWR SLICE_16\[0\].RAM16.SLICE\[0\].RAM8.WORD\[6\].W.BYTE\[0\].B.Q_WIRE\[5\]
+ sky130_fd_sc_hd__dlxtp_1
Xtap_0_19 VGND VPWR sky130_fd_sc_hd__tapvpwrvgnd_1
Xfill_21_1 VGND VGND VPWR VPWR sky130_fd_sc_hd__decap_12
Xfill_14_0 VGND VPWR sky130_fd_sc_hd__tapvpwrvgnd_1
Xtap_9_17 VGND VPWR sky130_fd_sc_hd__tapvpwrvgnd_1
Xtap_9_28 VGND VPWR sky130_fd_sc_hd__tapvpwrvgnd_1
XSLICE_16\[0\].RAM16.SLICE\[1\].RAM8.WORD\[1\].W.BYTE\[0\].B.BIT\[4\].OBUF0 SLICE_16\[0\].RAM16.SLICE\[1\].RAM8.WORD\[1\].W.BYTE\[0\].B.Q_WIRE\[4\]
+ SLICE_16\[0\].RAM16.SLICE\[1\].RAM8.WORD\[1\].W.BYTE\[0\].B.SEL0_B VGND VGND VPWR
+ VPWR SLICE_16\[0\].RAM16.BYTE\[0\].FLOATBUF0\[4\].Z sky130_fd_sc_hd__ebufn_2
XSLICE_16\[0\].RAM16.SLICE\[1\].RAM8.WORD\[5\].W.BYTE\[3\].B.BIT\[7\].OBUF0 SLICE_16\[0\].RAM16.SLICE\[1\].RAM8.WORD\[5\].W.BYTE\[3\].B.Q_WIRE\[7\]
+ SLICE_16\[0\].RAM16.SLICE\[1\].RAM8.WORD\[5\].W.BYTE\[3\].B.SEL0_B VGND VGND VPWR
+ VPWR SLICE_16\[0\].RAM16.BYTE\[3\].FLOATBUF0\[31\].Z sky130_fd_sc_hd__ebufn_2
XSLICE_16\[0\].RAM16.SLICE\[0\].RAM8.WORD\[0\].W.CLKBUF SLICE_16\[0\].RAM16.SLICE\[0\].RAM8.CLKBUF.X
+ VGND VGND VPWR VPWR SLICE_16\[0\].RAM16.SLICE\[0\].RAM8.WORD\[0\].W.BYTE\[0\].B.CLK
+ sky130_fd_sc_hd__clkbuf_4
Xtap_36_7 VGND VPWR sky130_fd_sc_hd__tapvpwrvgnd_1
Xtap_29_6 VGND VPWR sky130_fd_sc_hd__tapvpwrvgnd_1
Xtap_28_24 VGND VPWR sky130_fd_sc_hd__tapvpwrvgnd_1
Xtap_28_13 VGND VPWR sky130_fd_sc_hd__tapvpwrvgnd_1
Xtap_28_35 VGND VPWR sky130_fd_sc_hd__tapvpwrvgnd_1
XSLICE_16\[1\].RAM16.SLICE\[1\].RAM8.WORD\[5\].W.BYTE\[2\].B.BIT\[4\].genblk1.STORAGE
+ DIBUF\[20\].X SLICE_16\[1\].RAM16.SLICE\[1\].RAM8.WORD\[5\].W.BYTE\[2\].B.GCLK VGND
+ VGND VPWR VPWR SLICE_16\[1\].RAM16.SLICE\[1\].RAM8.WORD\[5\].W.BYTE\[2\].B.Q_WIRE\[4\]
+ sky130_fd_sc_hd__dlxtp_1
XSLICE_16\[1\].RAM16.SLICE\[0\].RAM8.WORD\[7\].W.BYTE\[2\].B.CGAND SLICE_16\[1\].RAM16.SLICE\[0\].RAM8.WORD\[7\].W.BYTE\[0\].B.SEL0
+ SLICE_16\[1\].RAM16.SLICE\[0\].RAM8.WE0_buf\[2\] VGND VGND VPWR VPWR SLICE_16\[1\].RAM16.SLICE\[0\].RAM8.WORD\[7\].W.BYTE\[2\].B.WE0_WIRE
+ sky130_fd_sc_hd__and2_1
XSLICE_16\[0\].RAM16.SLICE\[0\].RAM8.WORD\[0\].W.BYTE\[2\].B.BIT\[6\].OBUF0 SLICE_16\[0\].RAM16.SLICE\[0\].RAM8.WORD\[0\].W.BYTE\[2\].B.Q_WIRE\[6\]
+ SLICE_16\[0\].RAM16.SLICE\[0\].RAM8.WORD\[0\].W.BYTE\[2\].B.SEL0_B VGND VGND VPWR
+ VPWR SLICE_16\[0\].RAM16.BYTE\[2\].FLOATBUF0\[22\].Z sky130_fd_sc_hd__ebufn_2
XDo0MUX.M\[0\].DIODE_A0MUX\[7\] Do0MUX.A0\[7\] VGND VGND VPWR VPWR sky130_fd_sc_hd__diode_2
XSLICE_16\[1\].RAM16.SLICE\[1\].RAM8.WORD\[2\].W.BYTE\[2\].B.BIT\[3\].OBUF0 SLICE_16\[1\].RAM16.SLICE\[1\].RAM8.WORD\[2\].W.BYTE\[2\].B.Q_WIRE\[3\]
+ SLICE_16\[1\].RAM16.SLICE\[1\].RAM8.WORD\[2\].W.BYTE\[2\].B.SEL0_B VGND VGND VPWR
+ VPWR SLICE_16\[1\].RAM16.BYTE\[2\].FLOATBUF0\[19\].Z sky130_fd_sc_hd__ebufn_2
XSLICE_16\[1\].RAM16.SLICE\[1\].RAM8.WORD\[3\].W.BYTE\[0\].B.BIT\[3\].genblk1.STORAGE
+ DIBUF\[3\].X SLICE_16\[1\].RAM16.SLICE\[1\].RAM8.WORD\[3\].W.BYTE\[0\].B.GCLK VGND
+ VGND VPWR VPWR SLICE_16\[1\].RAM16.SLICE\[1\].RAM8.WORD\[3\].W.BYTE\[0\].B.Q_WIRE\[3\]
+ sky130_fd_sc_hd__dlxtp_1
XSLICE_16\[1\].RAM16.SLICE\[0\].RAM8.DEC0.ENBUF SLICE_16\[1\].RAM16.DEC0.SEL\[0\]
+ VGND VGND VPWR VPWR SLICE_16\[1\].RAM16.SLICE\[0\].RAM8.DEC0.EN_buf sky130_fd_sc_hd__clkbuf_2
XSLICE_16\[0\].RAM16.SLICE\[1\].RAM8.WORD\[6\].W.BYTE\[2\].B.BIT\[0\].genblk1.STORAGE
+ DIBUF\[16\].X SLICE_16\[0\].RAM16.SLICE\[1\].RAM8.WORD\[6\].W.BYTE\[2\].B.GCLK VGND
+ VGND VPWR VPWR SLICE_16\[0\].RAM16.SLICE\[1\].RAM8.WORD\[6\].W.BYTE\[2\].B.Q_WIRE\[0\]
+ sky130_fd_sc_hd__dlxtp_1
XSLICE_16\[0\].RAM16.SLICE\[1\].RAM8.WORD\[4\].W.BYTE\[1\].B.BIT\[4\].OBUF0 SLICE_16\[0\].RAM16.SLICE\[1\].RAM8.WORD\[4\].W.BYTE\[1\].B.Q_WIRE\[4\]
+ SLICE_16\[0\].RAM16.SLICE\[1\].RAM8.WORD\[4\].W.BYTE\[1\].B.SEL0_B VGND VGND VPWR
+ VPWR SLICE_16\[0\].RAM16.BYTE\[1\].FLOATBUF0\[12\].Z sky130_fd_sc_hd__ebufn_2
XSLICE_16\[0\].RAM16.SLICE\[1\].RAM8.WORD\[0\].W.BYTE\[3\].B.BIT\[1\].genblk1.STORAGE
+ DIBUF\[25\].X SLICE_16\[0\].RAM16.SLICE\[1\].RAM8.WORD\[0\].W.BYTE\[3\].B.GCLK VGND
+ VGND VPWR VPWR SLICE_16\[0\].RAM16.SLICE\[1\].RAM8.WORD\[0\].W.BYTE\[3\].B.Q_WIRE\[1\]
+ sky130_fd_sc_hd__dlxtp_1
XSLICE_16\[1\].RAM16.BYTE\[1\].FLOATBUF0\[12\].__cell__ SLICE_16\[1\].RAM16.BYTE\[1\].FLOATBUF0\[10\].A
+ SLICE_16\[1\].RAM16.BYTE\[1\].FLOATBUF0\[10\].TE_B VGND VGND VPWR VPWR SLICE_16\[1\].RAM16.BYTE\[1\].FLOATBUF0\[12\].Z
+ sky130_fd_sc_hd__ebufn_2
XSLICE_16\[1\].RAM16.SLICE\[1\].RAM8.WORD\[6\].W.BYTE\[0\].B.genblk1.CLKINV SLICE_16\[1\].RAM16.SLICE\[1\].RAM8.WORD\[6\].W.BYTE\[0\].B.CLK
+ VGND VGND VPWR VPWR SLICE_16\[1\].RAM16.SLICE\[1\].RAM8.WORD\[6\].W.BYTE\[0\].B.CLK_B
+ sky130_fd_sc_hd__inv_1
XSLICE_16\[1\].RAM16.SLICE\[1\].RAM8.WORD\[1\].W.BYTE\[0\].B.BIT\[0\].OBUF0 SLICE_16\[1\].RAM16.SLICE\[1\].RAM8.WORD\[1\].W.BYTE\[0\].B.Q_WIRE\[0\]
+ SLICE_16\[1\].RAM16.SLICE\[1\].RAM8.WORD\[1\].W.BYTE\[0\].B.SEL0_B VGND VGND VPWR
+ VPWR SLICE_16\[1\].RAM16.BYTE\[0\].FLOATBUF0\[0\].Z sky130_fd_sc_hd__ebufn_2
Xtap_14_26 VGND VPWR sky130_fd_sc_hd__tapvpwrvgnd_1
Xtap_14_15 VGND VPWR sky130_fd_sc_hd__tapvpwrvgnd_1
XSLICE_16\[0\].RAM16.SLICE\[0\].RAM8.WORD\[3\].W.BYTE\[2\].B.BIT\[6\].genblk1.STORAGE
+ DIBUF\[22\].X SLICE_16\[0\].RAM16.SLICE\[0\].RAM8.WORD\[3\].W.BYTE\[2\].B.GCLK VGND
+ VGND VPWR VPWR SLICE_16\[0\].RAM16.SLICE\[0\].RAM8.WORD\[3\].W.BYTE\[2\].B.Q_WIRE\[6\]
+ sky130_fd_sc_hd__dlxtp_1
XSLICE_16\[0\].RAM16.SLICE\[0\].RAM8.WORD\[3\].W.BYTE\[3\].B.BIT\[6\].OBUF0 SLICE_16\[0\].RAM16.SLICE\[0\].RAM8.WORD\[3\].W.BYTE\[3\].B.Q_WIRE\[6\]
+ SLICE_16\[0\].RAM16.SLICE\[0\].RAM8.WORD\[3\].W.BYTE\[3\].B.SEL0_B VGND VGND VPWR
+ VPWR SLICE_16\[0\].RAM16.BYTE\[3\].FLOATBUF0\[30\].Z sky130_fd_sc_hd__ebufn_2
XSLICE_16\[1\].RAM16.SLICE\[1\].RAM8.WORD\[5\].W.BYTE\[3\].B.BIT\[3\].OBUF0 SLICE_16\[1\].RAM16.SLICE\[1\].RAM8.WORD\[5\].W.BYTE\[3\].B.Q_WIRE\[3\]
+ SLICE_16\[1\].RAM16.SLICE\[1\].RAM8.WORD\[5\].W.BYTE\[3\].B.SEL0_B VGND VGND VPWR
+ VPWR SLICE_16\[1\].RAM16.BYTE\[3\].FLOATBUF0\[27\].Z sky130_fd_sc_hd__ebufn_2
Xtap_30_25 VGND VPWR sky130_fd_sc_hd__tapvpwrvgnd_1
Xtap_30_14 VGND VPWR sky130_fd_sc_hd__tapvpwrvgnd_1
XSLICE_16\[0\].RAM16.SLICE\[0\].RAM8.WORD\[1\].W.BYTE\[0\].B.BIT\[5\].genblk1.STORAGE
+ DIBUF\[5\].X SLICE_16\[0\].RAM16.SLICE\[0\].RAM8.WORD\[1\].W.BYTE\[0\].B.GCLK VGND
+ VGND VPWR VPWR SLICE_16\[0\].RAM16.SLICE\[0\].RAM8.WORD\[1\].W.BYTE\[0\].B.Q_WIRE\[5\]
+ sky130_fd_sc_hd__dlxtp_1
Xtap_34_4 VGND VPWR sky130_fd_sc_hd__tapvpwrvgnd_1
Xtap_27_3 VGND VPWR sky130_fd_sc_hd__tapvpwrvgnd_1
XSLICE_16\[1\].RAM16.SLICE\[1\].RAM8.WORD\[0\].W.BYTE\[1\].B.SEL0INV SLICE_16\[1\].RAM16.SLICE\[1\].RAM8.WORD\[0\].W.BYTE\[0\].B.SEL0
+ VGND VGND VPWR VPWR SLICE_16\[1\].RAM16.SLICE\[1\].RAM8.WORD\[0\].W.BYTE\[1\].B.SEL0_B
+ sky130_fd_sc_hd__inv_1
XSLICE_16\[1\].RAM16.SLICE\[0\].RAM8.WORD\[0\].W.BYTE\[2\].B.BIT\[2\].OBUF0 SLICE_16\[1\].RAM16.SLICE\[0\].RAM8.WORD\[0\].W.BYTE\[2\].B.Q_WIRE\[2\]
+ SLICE_16\[1\].RAM16.SLICE\[0\].RAM8.WORD\[0\].W.BYTE\[2\].B.SEL0_B VGND VGND VPWR
+ VPWR SLICE_16\[1\].RAM16.BYTE\[2\].FLOATBUF0\[18\].Z sky130_fd_sc_hd__ebufn_2
XSLICE_16\[0\].RAM16.SLICE\[1\].RAM8.WORD\[7\].W.BYTE\[2\].B.BIT\[4\].OBUF0 SLICE_16\[0\].RAM16.SLICE\[1\].RAM8.WORD\[7\].W.BYTE\[2\].B.Q_WIRE\[4\]
+ SLICE_16\[0\].RAM16.SLICE\[1\].RAM8.WORD\[7\].W.BYTE\[2\].B.SEL0_B VGND VGND VPWR
+ VPWR SLICE_16\[0\].RAM16.BYTE\[2\].FLOATBUF0\[20\].Z sky130_fd_sc_hd__ebufn_2
XSLICE_16\[0\].RAM16.SLICE\[0\].RAM8.WORD\[5\].W.BYTE\[1\].B.genblk1.CG SLICE_16\[0\].RAM16.SLICE\[0\].RAM8.WORD\[5\].W.BYTE\[1\].B.CLK_B
+ SLICE_16\[0\].RAM16.SLICE\[0\].RAM8.WORD\[5\].W.BYTE\[1\].B.WE0_WIRE VGND VGND VPWR
+ VPWR SLICE_16\[0\].RAM16.SLICE\[0\].RAM8.WORD\[5\].W.BYTE\[1\].B.GCLK sky130_fd_sc_hd__dlclkp_1
Xfill_43_98 VGND VGND VPWR VPWR sky130_fd_sc_hd__decap_12
Xfill_43_87 VGND VPWR sky130_fd_sc_hd__tapvpwrvgnd_1
Xfill_43_76 VGND VGND VPWR VPWR sky130_fd_sc_hd__decap_12
Xfill_43_65 VGND VGND VPWR VPWR sky130_fd_sc_hd__decap_12
Xfill_43_54 VGND VPWR sky130_fd_sc_hd__tapvpwrvgnd_1
Xfill_43_43 VGND VGND VPWR VPWR sky130_fd_sc_hd__decap_12
Xfill_43_32 VGND VGND VPWR VPWR sky130_fd_sc_hd__decap_12
Xfill_43_21 VGND VPWR sky130_fd_sc_hd__tapvpwrvgnd_1
Xfill_43_10 VGND VGND VPWR VPWR sky130_fd_sc_hd__decap_12
XSLICE_16\[0\].RAM16.SLICE\[0\].RAM8.WORD\[2\].W.BYTE\[1\].B.BIT\[3\].OBUF0 SLICE_16\[0\].RAM16.SLICE\[0\].RAM8.WORD\[2\].W.BYTE\[1\].B.Q_WIRE\[3\]
+ SLICE_16\[0\].RAM16.SLICE\[0\].RAM8.WORD\[2\].W.BYTE\[1\].B.SEL0_B VGND VGND VPWR
+ VPWR SLICE_16\[0\].RAM16.BYTE\[1\].FLOATBUF0\[11\].Z sky130_fd_sc_hd__ebufn_2
XDo0MUX.M\[1\].DIODE_A0MUX\[14\] Do0MUX.A0\[14\] VGND VGND VPWR VPWR sky130_fd_sc_hd__diode_2
XSLICE_16\[1\].RAM16.SLICE\[1\].RAM8.WORD\[4\].W.BYTE\[1\].B.BIT\[0\].OBUF0 SLICE_16\[1\].RAM16.SLICE\[1\].RAM8.WORD\[4\].W.BYTE\[1\].B.Q_WIRE\[0\]
+ SLICE_16\[1\].RAM16.SLICE\[1\].RAM8.WORD\[4\].W.BYTE\[1\].B.SEL0_B VGND VGND VPWR
+ VPWR SLICE_16\[1\].RAM16.BYTE\[1\].FLOATBUF0\[8\].Z sky130_fd_sc_hd__ebufn_2
XSLICE_16\[0\].RAM16.SLICE\[0\].RAM8.WORD\[0\].W.BYTE\[1\].B.DIODE_CLK SLICE_16\[0\].RAM16.SLICE\[0\].RAM8.WORD\[0\].W.BYTE\[0\].B.CLK
+ VGND VGND VPWR VPWR sky130_fd_sc_hd__diode_2
Xfill_45_101 VGND VGND VPWR VPWR sky130_fd_sc_hd__decap_12
XSLICE_16\[1\].RAM16.SLICE\[1\].RAM8.WORD\[6\].W.BYTE\[1\].B.BIT\[3\].genblk1.STORAGE
+ DIBUF\[11\].X SLICE_16\[1\].RAM16.SLICE\[1\].RAM8.WORD\[6\].W.BYTE\[1\].B.GCLK VGND
+ VGND VPWR VPWR SLICE_16\[1\].RAM16.SLICE\[1\].RAM8.WORD\[6\].W.BYTE\[1\].B.Q_WIRE\[3\]
+ sky130_fd_sc_hd__dlxtp_1
XSLICE_16\[1\].RAM16.SLICE\[1\].RAM8.WORD\[0\].W.BYTE\[2\].B.BIT\[4\].genblk1.STORAGE
+ DIBUF\[20\].X SLICE_16\[1\].RAM16.SLICE\[1\].RAM8.WORD\[0\].W.BYTE\[2\].B.GCLK VGND
+ VGND VPWR VPWR SLICE_16\[1\].RAM16.SLICE\[1\].RAM8.WORD\[0\].W.BYTE\[2\].B.Q_WIRE\[4\]
+ sky130_fd_sc_hd__dlxtp_1
XSLICE_16\[0\].RAM16.BYTE\[3\].FLOATBUF0\[26\].__cell__ SLICE_16\[0\].RAM16.BYTE\[3\].FLOATBUF0\[24\].A
+ SLICE_16\[0\].RAM16.BYTE\[3\].FLOATBUF0\[24\].TE_B VGND VGND VPWR VPWR SLICE_16\[0\].RAM16.BYTE\[3\].FLOATBUF0\[26\].Z
+ sky130_fd_sc_hd__ebufn_2
Xtap_6_18 VGND VPWR sky130_fd_sc_hd__tapvpwrvgnd_1
Xtap_6_29 VGND VPWR sky130_fd_sc_hd__tapvpwrvgnd_1
XSLICE_16\[0\].RAM16.SLICE\[1\].RAM8.WORD\[6\].W.BYTE\[0\].B.BIT\[1\].OBUF0 SLICE_16\[0\].RAM16.SLICE\[1\].RAM8.WORD\[6\].W.BYTE\[0\].B.Q_WIRE\[1\]
+ SLICE_16\[0\].RAM16.SLICE\[1\].RAM8.WORD\[6\].W.BYTE\[0\].B.SEL0_B VGND VGND VPWR
+ VPWR SLICE_16\[0\].RAM16.BYTE\[0\].FLOATBUF0\[1\].Z sky130_fd_sc_hd__ebufn_2
Xtap_13_9 VGND VPWR sky130_fd_sc_hd__tapvpwrvgnd_1
XSLICE_16\[1\].RAM16.SLICE\[0\].RAM8.WORD\[3\].W.BYTE\[3\].B.BIT\[2\].OBUF0 SLICE_16\[1\].RAM16.SLICE\[0\].RAM8.WORD\[3\].W.BYTE\[3\].B.Q_WIRE\[2\]
+ SLICE_16\[1\].RAM16.SLICE\[0\].RAM8.WORD\[3\].W.BYTE\[3\].B.SEL0_B VGND VGND VPWR
+ VPWR SLICE_16\[1\].RAM16.BYTE\[3\].FLOATBUF0\[26\].Z sky130_fd_sc_hd__ebufn_2
Xtap_25_36 VGND VPWR sky130_fd_sc_hd__tapvpwrvgnd_1
Xtap_25_25 VGND VPWR sky130_fd_sc_hd__tapvpwrvgnd_1
Xtap_25_14 VGND VPWR sky130_fd_sc_hd__tapvpwrvgnd_1
XSLICE_16\[1\].RAM16.SLICE\[0\].RAM8.WORD\[2\].W.BYTE\[0\].B.genblk1.CG SLICE_16\[1\].RAM16.SLICE\[0\].RAM8.WORD\[2\].W.BYTE\[0\].B.CLK_B
+ SLICE_16\[1\].RAM16.SLICE\[0\].RAM8.WORD\[2\].W.BYTE\[0\].B.WE0_WIRE VGND VGND VPWR
+ VPWR SLICE_16\[1\].RAM16.SLICE\[0\].RAM8.WORD\[2\].W.BYTE\[0\].B.GCLK sky130_fd_sc_hd__dlclkp_1
Xtap_6_8 VGND VPWR sky130_fd_sc_hd__tapvpwrvgnd_1
XSLICE_16\[0\].RAM16.SLICE\[1\].RAM8.WORD\[1\].W.BYTE\[2\].B.BIT\[0\].genblk1.STORAGE
+ DIBUF\[16\].X SLICE_16\[0\].RAM16.SLICE\[1\].RAM8.WORD\[1\].W.BYTE\[2\].B.GCLK VGND
+ VGND VPWR VPWR SLICE_16\[0\].RAM16.SLICE\[1\].RAM8.WORD\[1\].W.BYTE\[2\].B.Q_WIRE\[0\]
+ sky130_fd_sc_hd__dlxtp_1
XDo0MUX.M\[2\].DIODE_A0MUX\[18\] Do0MUX.A0\[18\] VGND VGND VPWR VPWR sky130_fd_sc_hd__diode_2
Xtap_32_1 VGND VPWR sky130_fd_sc_hd__tapvpwrvgnd_1
XSLICE_16\[1\].RAM16.SLICE\[0\].RAM8.WORD\[0\].W.BYTE\[0\].B.BIT\[7\].OBUF0 SLICE_16\[1\].RAM16.SLICE\[0\].RAM8.WORD\[0\].W.BYTE\[0\].B.Q_WIRE\[7\]
+ SLICE_16\[1\].RAM16.SLICE\[0\].RAM8.WORD\[0\].W.BYTE\[0\].B.SEL0_B VGND VGND VPWR
+ VPWR SLICE_16\[1\].RAM16.BYTE\[0\].FLOATBUF0\[7\].Z sky130_fd_sc_hd__ebufn_2
XSLICE_16\[0\].RAM16.SLICE\[0\].RAM8.WORD\[5\].W.BYTE\[2\].B.BIT\[3\].OBUF0 SLICE_16\[0\].RAM16.SLICE\[0\].RAM8.WORD\[5\].W.BYTE\[2\].B.Q_WIRE\[3\]
+ SLICE_16\[0\].RAM16.SLICE\[0\].RAM8.WORD\[5\].W.BYTE\[2\].B.SEL0_B VGND VGND VPWR
+ VPWR SLICE_16\[0\].RAM16.BYTE\[2\].FLOATBUF0\[19\].Z sky130_fd_sc_hd__ebufn_2
XDo0MUX.M\[0\].DIODE_A1MUX\[1\] Do0MUX.A1\[1\] VGND VGND VPWR VPWR sky130_fd_sc_hd__diode_2
XSLICE_16\[1\].RAM16.BYTE\[1\].FLOATBUF0\[9\].__cell__ SLICE_16\[1\].RAM16.BYTE\[1\].FLOATBUF0\[10\].A
+ SLICE_16\[1\].RAM16.BYTE\[1\].FLOATBUF0\[10\].TE_B VGND VGND VPWR VPWR SLICE_16\[1\].RAM16.BYTE\[1\].FLOATBUF0\[9\].Z
+ sky130_fd_sc_hd__ebufn_2
XSLICE_16\[1\].RAM16.SLICE\[1\].RAM8.WORD\[7\].W.BYTE\[2\].B.BIT\[0\].OBUF0 SLICE_16\[1\].RAM16.SLICE\[1\].RAM8.WORD\[7\].W.BYTE\[2\].B.Q_WIRE\[0\]
+ SLICE_16\[1\].RAM16.SLICE\[1\].RAM8.WORD\[7\].W.BYTE\[2\].B.SEL0_B VGND VGND VPWR
+ VPWR SLICE_16\[1\].RAM16.BYTE\[2\].FLOATBUF0\[16\].Z sky130_fd_sc_hd__ebufn_2
Xtap_25_0 VGND VPWR sky130_fd_sc_hd__tapvpwrvgnd_1
XSLICE_16\[0\].RAM16.SLICE\[0\].RAM8.WORD\[6\].W.BYTE\[3\].B.BIT\[6\].genblk1.STORAGE
+ DIBUF\[30\].X SLICE_16\[0\].RAM16.SLICE\[0\].RAM8.WORD\[6\].W.BYTE\[3\].B.GCLK VGND
+ VGND VPWR VPWR SLICE_16\[0\].RAM16.SLICE\[0\].RAM8.WORD\[6\].W.BYTE\[3\].B.Q_WIRE\[6\]
+ sky130_fd_sc_hd__dlxtp_1
XSLICE_16\[1\].RAM16.EN0BUF.__cell__ DEC0.SEL\[1\] VGND VGND VPWR VPWR SLICE_16\[1\].RAM16.DEC0.EN
+ sky130_fd_sc_hd__clkbuf_2
XSLICE_16\[0\].RAM16.SLICE\[0\].RAM8.WORD\[4\].W.BYTE\[1\].B.BIT\[5\].genblk1.STORAGE
+ DIBUF\[13\].X SLICE_16\[0\].RAM16.SLICE\[0\].RAM8.WORD\[4\].W.BYTE\[1\].B.GCLK VGND
+ VGND VPWR VPWR SLICE_16\[0\].RAM16.SLICE\[0\].RAM8.WORD\[4\].W.BYTE\[1\].B.Q_WIRE\[5\]
+ sky130_fd_sc_hd__dlxtp_1
Xfill_46_3 VGND VPWR sky130_fd_sc_hd__tapvpwrvgnd_1
Xfill_39_2 VGND VGND VPWR VPWR sky130_fd_sc_hd__decap_12
XSLICE_16\[0\].RAM16.SLICE\[1\].RAM8.DEC0.AND3 SLICE_16\[0\].RAM16.SLICE\[1\].RAM8.DEC0.A_buf\[2\]
+ SLICE_16\[0\].RAM16.SLICE\[1\].RAM8.DEC0.A_buf\[1\] SLICE_16\[0\].RAM16.SLICE\[1\].RAM8.DEC0.A_buf\[0\]
+ SLICE_16\[0\].RAM16.SLICE\[1\].RAM8.DEC0.EN_buf VGND VGND VPWR VPWR SLICE_16\[0\].RAM16.SLICE\[1\].RAM8.DEC0.SEL\[3\]
+ sky130_fd_sc_hd__and4b_2
Xfill_1_3 VGND VGND VPWR VPWR sky130_fd_sc_hd__decap_6
XSLICE_16\[0\].RAM16.SLICE\[0\].RAM8.WORD\[4\].W.BYTE\[0\].B.BIT\[0\].OBUF0 SLICE_16\[0\].RAM16.SLICE\[0\].RAM8.WORD\[4\].W.BYTE\[0\].B.Q_WIRE\[0\]
+ SLICE_16\[0\].RAM16.SLICE\[0\].RAM8.WORD\[4\].W.BYTE\[0\].B.SEL0_B VGND VGND VPWR
+ VPWR SLICE_16\[0\].RAM16.BYTE\[0\].FLOATBUF0\[0\].Z sky130_fd_sc_hd__ebufn_2
Xtap_11_16 VGND VPWR sky130_fd_sc_hd__tapvpwrvgnd_1
XSLICE_16\[1\].RAM16.SLICE\[0\].RAM8.WORD\[3\].W.BYTE\[1\].B.BIT\[7\].OBUF0 SLICE_16\[1\].RAM16.SLICE\[0\].RAM8.WORD\[3\].W.BYTE\[1\].B.Q_WIRE\[7\]
+ SLICE_16\[1\].RAM16.SLICE\[0\].RAM8.WORD\[3\].W.BYTE\[1\].B.SEL0_B VGND VGND VPWR
+ VPWR SLICE_16\[1\].RAM16.BYTE\[1\].FLOATBUF0\[15\].Z sky130_fd_sc_hd__ebufn_2
XSLICE_16\[0\].RAM16.SLICE\[1\].RAM8.WORD\[0\].W.BYTE\[3\].B.BIT\[6\].OBUF0 SLICE_16\[0\].RAM16.SLICE\[1\].RAM8.WORD\[0\].W.BYTE\[3\].B.Q_WIRE\[6\]
+ SLICE_16\[0\].RAM16.SLICE\[1\].RAM8.WORD\[0\].W.BYTE\[3\].B.SEL0_B VGND VGND VPWR
+ VPWR SLICE_16\[0\].RAM16.BYTE\[3\].FLOATBUF0\[30\].Z sky130_fd_sc_hd__ebufn_2
Xtap_11_27 VGND VPWR sky130_fd_sc_hd__tapvpwrvgnd_1
Xtap_36_35 VGND VPWR sky130_fd_sc_hd__tapvpwrvgnd_1
Xtap_36_24 VGND VPWR sky130_fd_sc_hd__tapvpwrvgnd_1
Xtap_36_13 VGND VPWR sky130_fd_sc_hd__tapvpwrvgnd_1
XSLICE_16\[1\].RAM16.SLICE\[1\].RAM8.WORD\[3\].W.BYTE\[3\].B.BIT\[4\].genblk1.STORAGE
+ DIBUF\[28\].X SLICE_16\[1\].RAM16.SLICE\[1\].RAM8.WORD\[3\].W.BYTE\[3\].B.GCLK VGND
+ VGND VPWR VPWR SLICE_16\[1\].RAM16.SLICE\[1\].RAM8.WORD\[3\].W.BYTE\[3\].B.Q_WIRE\[4\]
+ sky130_fd_sc_hd__dlxtp_1
XSLICE_16\[1\].RAM16.SLICE\[0\].RAM8.WORD\[5\].W.BYTE\[1\].B.DIODE_CLK SLICE_16\[1\].RAM16.SLICE\[0\].RAM8.WORD\[5\].W.BYTE\[0\].B.CLK
+ VGND VGND VPWR VPWR sky130_fd_sc_hd__diode_2
XSLICE_16\[1\].RAM16.SLICE\[0\].RAM8.WORD\[3\].W.BYTE\[1\].B.CGAND SLICE_16\[1\].RAM16.SLICE\[0\].RAM8.WORD\[3\].W.BYTE\[0\].B.SEL0
+ SLICE_16\[1\].RAM16.SLICE\[0\].RAM8.WE0_buf\[1\] VGND VGND VPWR VPWR SLICE_16\[1\].RAM16.SLICE\[0\].RAM8.WORD\[3\].W.BYTE\[1\].B.WE0_WIRE
+ sky130_fd_sc_hd__and2_1
Xtap_11_6 VGND VPWR sky130_fd_sc_hd__tapvpwrvgnd_1
XSLICE_16\[1\].RAM16.SLICE\[1\].RAM8.WORD\[7\].W.BYTE\[0\].B.BIT\[2\].genblk1.STORAGE
+ DIBUF\[2\].X SLICE_16\[1\].RAM16.SLICE\[1\].RAM8.WORD\[7\].W.BYTE\[0\].B.GCLK VGND
+ VGND VPWR VPWR SLICE_16\[1\].RAM16.SLICE\[1\].RAM8.WORD\[7\].W.BYTE\[0\].B.Q_WIRE\[2\]
+ sky130_fd_sc_hd__dlxtp_1
XSLICE_16\[1\].RAM16.SLICE\[1\].RAM8.WORD\[1\].W.BYTE\[1\].B.BIT\[3\].genblk1.STORAGE
+ DIBUF\[11\].X SLICE_16\[1\].RAM16.SLICE\[1\].RAM8.WORD\[1\].W.BYTE\[1\].B.GCLK VGND
+ VGND VPWR VPWR SLICE_16\[1\].RAM16.SLICE\[1\].RAM8.WORD\[1\].W.BYTE\[1\].B.Q_WIRE\[3\]
+ sky130_fd_sc_hd__dlxtp_1
Xtap_4_5 VGND VPWR sky130_fd_sc_hd__tapvpwrvgnd_1
Xfill_40_11 VGND VGND VPWR VPWR sky130_fd_sc_hd__decap_12
XSLICE_16\[1\].RAM16.SLICE\[1\].RAM8.WORD\[7\].W.BYTE\[0\].B.BIT\[5\].OBUF0 SLICE_16\[1\].RAM16.SLICE\[1\].RAM8.WORD\[7\].W.BYTE\[0\].B.Q_WIRE\[5\]
+ SLICE_16\[1\].RAM16.SLICE\[1\].RAM8.WORD\[7\].W.BYTE\[0\].B.SEL0_B VGND VGND VPWR
+ VPWR SLICE_16\[1\].RAM16.BYTE\[0\].FLOATBUF0\[5\].Z sky130_fd_sc_hd__ebufn_2
XSLICE_16\[0\].RAM16.SLICE\[1\].RAM8.WORD\[4\].W.BYTE\[3\].B.BIT\[0\].genblk1.STORAGE
+ DIBUF\[24\].X SLICE_16\[0\].RAM16.SLICE\[1\].RAM8.WORD\[4\].W.BYTE\[3\].B.GCLK VGND
+ VGND VPWR VPWR SLICE_16\[0\].RAM16.SLICE\[1\].RAM8.WORD\[4\].W.BYTE\[3\].B.Q_WIRE\[0\]
+ sky130_fd_sc_hd__dlxtp_1
Xfill_40_22 VGND VGND VPWR VPWR sky130_fd_sc_hd__decap_12
XSLICE_16\[1\].RAM16.SLICE\[1\].RAM8.WORD\[7\].W.BYTE\[0\].B.genblk1.CG SLICE_16\[1\].RAM16.SLICE\[1\].RAM8.WORD\[7\].W.BYTE\[0\].B.CLK_B
+ SLICE_16\[1\].RAM16.SLICE\[1\].RAM8.WORD\[7\].W.BYTE\[0\].B.WE0_WIRE VGND VGND VPWR
+ VPWR SLICE_16\[1\].RAM16.SLICE\[1\].RAM8.WORD\[7\].W.BYTE\[0\].B.GCLK sky130_fd_sc_hd__dlclkp_1
XSLICE_16\[0\].RAM16.SLICE\[1\].RAM8.WORD\[2\].W.BYTE\[1\].B.DIODE_CLK SLICE_16\[0\].RAM16.SLICE\[1\].RAM8.WORD\[2\].W.BYTE\[0\].B.CLK
+ VGND VGND VPWR VPWR sky130_fd_sc_hd__diode_2
Xfill_18_7 VGND VGND VPWR VPWR sky130_fd_sc_hd__decap_12
XSLICE_16\[0\].RAM16.SLICE\[0\].RAM8.WORD\[7\].W.BYTE\[1\].B.BIT\[0\].OBUF0 SLICE_16\[0\].RAM16.SLICE\[0\].RAM8.WORD\[7\].W.BYTE\[1\].B.Q_WIRE\[0\]
+ SLICE_16\[0\].RAM16.SLICE\[0\].RAM8.WORD\[7\].W.BYTE\[1\].B.SEL0_B VGND VGND VPWR
+ VPWR SLICE_16\[0\].RAM16.BYTE\[1\].FLOATBUF0\[8\].Z sky130_fd_sc_hd__ebufn_2
XSLICE_16\[1\].RAM16.SLICE\[0\].RAM8.WORD\[6\].W.BYTE\[2\].B.BIT\[7\].OBUF0 SLICE_16\[1\].RAM16.SLICE\[0\].RAM8.WORD\[6\].W.BYTE\[2\].B.Q_WIRE\[7\]
+ SLICE_16\[1\].RAM16.SLICE\[0\].RAM8.WORD\[6\].W.BYTE\[2\].B.SEL0_B VGND VGND VPWR
+ VPWR SLICE_16\[1\].RAM16.BYTE\[2\].FLOATBUF0\[23\].Z sky130_fd_sc_hd__ebufn_2
Xtap_3_19 VGND VPWR sky130_fd_sc_hd__tapvpwrvgnd_1
XSLICE_16\[0\].RAM16.SLICE\[0\].RAM8.WORD\[7\].W.BYTE\[2\].B.BIT\[5\].genblk1.STORAGE
+ DIBUF\[21\].X SLICE_16\[0\].RAM16.SLICE\[0\].RAM8.WORD\[7\].W.BYTE\[2\].B.GCLK VGND
+ VGND VPWR VPWR SLICE_16\[0\].RAM16.SLICE\[0\].RAM8.WORD\[7\].W.BYTE\[2\].B.Q_WIRE\[5\]
+ sky130_fd_sc_hd__dlxtp_1
XSLICE_16\[0\].RAM16.SLICE\[0\].RAM8.WORD\[1\].W.BYTE\[3\].B.BIT\[6\].genblk1.STORAGE
+ DIBUF\[30\].X SLICE_16\[0\].RAM16.SLICE\[0\].RAM8.WORD\[1\].W.BYTE\[3\].B.GCLK VGND
+ VGND VPWR VPWR SLICE_16\[0\].RAM16.SLICE\[0\].RAM8.WORD\[1\].W.BYTE\[3\].B.Q_WIRE\[6\]
+ sky130_fd_sc_hd__dlxtp_1
XSLICE_16\[0\].RAM16.SLICE\[0\].RAM8.WORD\[5\].W.BYTE\[0\].B.BIT\[4\].genblk1.STORAGE
+ DIBUF\[4\].X SLICE_16\[0\].RAM16.SLICE\[0\].RAM8.WORD\[5\].W.BYTE\[0\].B.GCLK VGND
+ VGND VPWR VPWR SLICE_16\[0\].RAM16.SLICE\[0\].RAM8.WORD\[5\].W.BYTE\[0\].B.Q_WIRE\[4\]
+ sky130_fd_sc_hd__dlxtp_1
XSLICE_16\[0\].RAM16.SLICE\[0\].RAM8.WORD\[5\].W.BYTE\[3\].B.CGAND SLICE_16\[0\].RAM16.SLICE\[0\].RAM8.WORD\[5\].W.BYTE\[0\].B.SEL0
+ SLICE_16\[0\].RAM16.SLICE\[0\].RAM8.WE0_buf\[3\] VGND VGND VPWR VPWR SLICE_16\[0\].RAM16.SLICE\[0\].RAM8.WORD\[5\].W.BYTE\[3\].B.WE0_WIRE
+ sky130_fd_sc_hd__and2_1
Xfill_44_0 VGND VPWR sky130_fd_sc_hd__tapvpwrvgnd_1
XSLICE_16\[1\].RAM16.SLICE\[1\].RAM8.WORD\[0\].W.BYTE\[3\].B.BIT\[2\].OBUF0 SLICE_16\[1\].RAM16.SLICE\[1\].RAM8.WORD\[0\].W.BYTE\[3\].B.Q_WIRE\[2\]
+ SLICE_16\[1\].RAM16.SLICE\[1\].RAM8.WORD\[0\].W.BYTE\[3\].B.SEL0_B VGND VGND VPWR
+ VPWR SLICE_16\[1\].RAM16.BYTE\[3\].FLOATBUF0\[26\].Z sky130_fd_sc_hd__ebufn_2
XSLICE_16\[0\].RAM16.SLICE\[1\].RAM8.WORD\[2\].W.BYTE\[0\].B.SEL0INV SLICE_16\[0\].RAM16.SLICE\[1\].RAM8.WORD\[2\].W.BYTE\[0\].B.SEL0
+ VGND VGND VPWR VPWR SLICE_16\[0\].RAM16.SLICE\[1\].RAM8.WORD\[2\].W.BYTE\[0\].B.SEL0_B
+ sky130_fd_sc_hd__inv_1
XSLICE_16\[1\].RAM16.SLICE\[1\].RAM8.WORD\[4\].W.BYTE\[0\].B.CGAND SLICE_16\[1\].RAM16.SLICE\[1\].RAM8.WORD\[4\].W.BYTE\[0\].B.SEL0
+ SLICE_16\[1\].RAM16.SLICE\[1\].RAM8.WE0_buf\[0\] VGND VGND VPWR VPWR SLICE_16\[1\].RAM16.SLICE\[1\].RAM8.WORD\[4\].W.BYTE\[0\].B.WE0_WIRE
+ sky130_fd_sc_hd__and2_1
XSLICE_16\[1\].RAM16.SLICE\[0\].RAM8.WORD\[5\].W.BYTE\[0\].B.BIT\[4\].OBUF0 SLICE_16\[1\].RAM16.SLICE\[0\].RAM8.WORD\[5\].W.BYTE\[0\].B.Q_WIRE\[4\]
+ SLICE_16\[1\].RAM16.SLICE\[0\].RAM8.WORD\[5\].W.BYTE\[0\].B.SEL0_B VGND VGND VPWR
+ VPWR SLICE_16\[1\].RAM16.BYTE\[0\].FLOATBUF0\[4\].Z sky130_fd_sc_hd__ebufn_2
Xfill_19_89 VGND VGND VPWR VPWR sky130_fd_sc_hd__decap_12
Xfill_19_78 VGND VPWR sky130_fd_sc_hd__tapvpwrvgnd_1
Xfill_19_67 VGND VGND VPWR VPWR sky130_fd_sc_hd__decap_12
Xfill_19_56 VGND VGND VPWR VPWR sky130_fd_sc_hd__decap_12
Xfill_19_45 VGND VPWR sky130_fd_sc_hd__tapvpwrvgnd_1
Xfill_19_34 VGND VGND VPWR VPWR sky130_fd_sc_hd__decap_12
Xfill_19_23 VGND VGND VPWR VPWR sky130_fd_sc_hd__decap_12
Xfill_19_12 VGND VPWR sky130_fd_sc_hd__tapvpwrvgnd_1
Xtap_2_2 VGND VPWR sky130_fd_sc_hd__tapvpwrvgnd_1
XSLICE_16\[0\].RAM16.SLICE\[1\].RAM8.WORD\[2\].W.BYTE\[2\].B.BIT\[3\].OBUF0 SLICE_16\[0\].RAM16.SLICE\[1\].RAM8.WORD\[2\].W.BYTE\[2\].B.Q_WIRE\[3\]
+ SLICE_16\[0\].RAM16.SLICE\[1\].RAM8.WORD\[2\].W.BYTE\[2\].B.SEL0_B VGND VGND VPWR
+ VPWR SLICE_16\[0\].RAM16.BYTE\[2\].FLOATBUF0\[19\].Z sky130_fd_sc_hd__ebufn_2
XSLICE_16\[1\].RAM16.SLICE\[1\].RAM8.WORD\[4\].W.BYTE\[2\].B.BIT\[3\].genblk1.STORAGE
+ DIBUF\[19\].X SLICE_16\[1\].RAM16.SLICE\[1\].RAM8.WORD\[4\].W.BYTE\[2\].B.GCLK VGND
+ VGND VPWR VPWR SLICE_16\[1\].RAM16.SLICE\[1\].RAM8.WORD\[4\].W.BYTE\[2\].B.Q_WIRE\[3\]
+ sky130_fd_sc_hd__dlxtp_1
XSLICE_16\[1\].RAM16.SLICE\[1\].RAM8.WORD\[2\].W.BYTE\[0\].B.BIT\[2\].genblk1.STORAGE
+ DIBUF\[2\].X SLICE_16\[1\].RAM16.SLICE\[1\].RAM8.WORD\[2\].W.BYTE\[0\].B.GCLK VGND
+ VGND VPWR VPWR SLICE_16\[1\].RAM16.SLICE\[1\].RAM8.WORD\[2\].W.BYTE\[0\].B.Q_WIRE\[2\]
+ sky130_fd_sc_hd__dlxtp_1
Xfill_30_6 VGND VPWR sky130_fd_sc_hd__tapvpwrvgnd_1
Xfill_16_4 VGND VGND VPWR VPWR sky130_fd_sc_hd__decap_6
XSLICE_16\[1\].RAM16.SLICE\[1\].RAM8.WORD\[7\].W.BYTE\[1\].B.DIODE_CLK SLICE_16\[1\].RAM16.SLICE\[1\].RAM8.WORD\[7\].W.BYTE\[0\].B.CLK
+ VGND VGND VPWR VPWR sky130_fd_sc_hd__diode_2
XSLICE_16\[0\].RAM16.SLICE\[1\].RAM8.WORD\[1\].W.BYTE\[0\].B.BIT\[0\].OBUF0 SLICE_16\[0\].RAM16.SLICE\[1\].RAM8.WORD\[1\].W.BYTE\[0\].B.Q_WIRE\[0\]
+ SLICE_16\[0\].RAM16.SLICE\[1\].RAM8.WORD\[1\].W.BYTE\[0\].B.SEL0_B VGND VGND VPWR
+ VPWR SLICE_16\[0\].RAM16.BYTE\[0\].FLOATBUF0\[0\].Z sky130_fd_sc_hd__ebufn_2
XSLICE_16\[1\].RAM16.SLICE\[1\].RAM8.WORD\[0\].W.BYTE\[1\].B.BIT\[7\].OBUF0 SLICE_16\[1\].RAM16.SLICE\[1\].RAM8.WORD\[0\].W.BYTE\[1\].B.Q_WIRE\[7\]
+ SLICE_16\[1\].RAM16.SLICE\[1\].RAM8.WORD\[0\].W.BYTE\[1\].B.SEL0_B VGND VGND VPWR
+ VPWR SLICE_16\[1\].RAM16.BYTE\[1\].FLOATBUF0\[15\].Z sky130_fd_sc_hd__ebufn_2
XSLICE_16\[0\].RAM16.SLICE\[1\].RAM8.WORD\[6\].W.BYTE\[2\].B.CGAND SLICE_16\[0\].RAM16.SLICE\[1\].RAM8.WORD\[6\].W.BYTE\[0\].B.SEL0
+ SLICE_16\[0\].RAM16.SLICE\[1\].RAM8.WE0_buf\[2\] VGND VGND VPWR VPWR SLICE_16\[0\].RAM16.SLICE\[1\].RAM8.WORD\[6\].W.BYTE\[2\].B.WE0_WIRE
+ sky130_fd_sc_hd__and2_1
XSLICE_16\[0\].RAM16.SLICE\[1\].RAM8.WORD\[6\].W.BYTE\[0\].B.genblk1.CLKINV SLICE_16\[0\].RAM16.SLICE\[1\].RAM8.WORD\[6\].W.BYTE\[0\].B.CLK
+ VGND VGND VPWR VPWR SLICE_16\[0\].RAM16.SLICE\[1\].RAM8.WORD\[6\].W.BYTE\[0\].B.CLK_B
+ sky130_fd_sc_hd__inv_1
XSLICE_16\[0\].RAM16.SLICE\[1\].RAM8.WORD\[5\].W.BYTE\[3\].B.BIT\[3\].OBUF0 SLICE_16\[0\].RAM16.SLICE\[1\].RAM8.WORD\[5\].W.BYTE\[3\].B.Q_WIRE\[3\]
+ SLICE_16\[0\].RAM16.SLICE\[1\].RAM8.WORD\[5\].W.BYTE\[3\].B.SEL0_B VGND VGND VPWR
+ VPWR SLICE_16\[0\].RAM16.BYTE\[3\].FLOATBUF0\[27\].Z sky130_fd_sc_hd__ebufn_2
Xtap_33_36 VGND VPWR sky130_fd_sc_hd__tapvpwrvgnd_1
Xtap_33_25 VGND VPWR sky130_fd_sc_hd__tapvpwrvgnd_1
Xtap_33_14 VGND VPWR sky130_fd_sc_hd__tapvpwrvgnd_1
Xfill_21_46 VGND VGND VPWR VPWR sky130_fd_sc_hd__decap_12
Xfill_21_35 VGND VGND VPWR VPWR sky130_fd_sc_hd__decap_12
Xfill_21_24 VGND VPWR sky130_fd_sc_hd__tapvpwrvgnd_1
Xfill_21_13 VGND VGND VPWR VPWR sky130_fd_sc_hd__decap_12
XSLICE_16\[0\].RAM16.SLICE\[0\].RAM8.WORD\[1\].W.BYTE\[0\].B.genblk1.CG SLICE_16\[0\].RAM16.SLICE\[0\].RAM8.WORD\[1\].W.BYTE\[0\].B.CLK_B
+ SLICE_16\[0\].RAM16.SLICE\[0\].RAM8.WORD\[1\].W.BYTE\[0\].B.WE0_WIRE VGND VGND VPWR
+ VPWR SLICE_16\[0\].RAM16.SLICE\[0\].RAM8.WORD\[1\].W.BYTE\[0\].B.GCLK sky130_fd_sc_hd__dlclkp_1
XSLICE_16\[0\].RAM16.SLICE\[0\].RAM8.WORD\[2\].W.BYTE\[2\].B.BIT\[5\].genblk1.STORAGE
+ DIBUF\[21\].X SLICE_16\[0\].RAM16.SLICE\[0\].RAM8.WORD\[2\].W.BYTE\[2\].B.GCLK VGND
+ VGND VPWR VPWR SLICE_16\[0\].RAM16.SLICE\[0\].RAM8.WORD\[2\].W.BYTE\[2\].B.Q_WIRE\[5\]
+ sky130_fd_sc_hd__dlxtp_1
Xfill_21_79 VGND VGND VPWR VPWR sky130_fd_sc_hd__decap_12
Xfill_21_68 VGND VGND VPWR VPWR sky130_fd_sc_hd__decap_12
Xfill_21_57 VGND VPWR sky130_fd_sc_hd__tapvpwrvgnd_1
XSLICE_16\[0\].RAM16.SLICE\[0\].RAM8.WORD\[0\].W.BYTE\[2\].B.BIT\[2\].OBUF0 SLICE_16\[0\].RAM16.SLICE\[0\].RAM8.WORD\[0\].W.BYTE\[2\].B.Q_WIRE\[2\]
+ SLICE_16\[0\].RAM16.SLICE\[0\].RAM8.WORD\[0\].W.BYTE\[2\].B.SEL0_B VGND VGND VPWR
+ VPWR SLICE_16\[0\].RAM16.BYTE\[2\].FLOATBUF0\[18\].Z sky130_fd_sc_hd__ebufn_2
XSLICE_16\[0\].RAM16.SLICE\[0\].RAM8.WORD\[0\].W.BYTE\[0\].B.BIT\[4\].genblk1.STORAGE
+ DIBUF\[4\].X SLICE_16\[0\].RAM16.SLICE\[0\].RAM8.WORD\[0\].W.BYTE\[0\].B.GCLK VGND
+ VGND VPWR VPWR SLICE_16\[0\].RAM16.SLICE\[0\].RAM8.WORD\[0\].W.BYTE\[0\].B.Q_WIRE\[4\]
+ sky130_fd_sc_hd__dlxtp_1
Xfill_46_87 VGND VPWR sky130_fd_sc_hd__tapvpwrvgnd_1
Xfill_46_76 VGND VGND VPWR VPWR sky130_fd_sc_hd__decap_4
Xfill_46_65 VGND VGND VPWR VPWR sky130_fd_sc_hd__decap_4
Xfill_46_54 VGND VPWR sky130_fd_sc_hd__tapvpwrvgnd_1
Xfill_46_43 VGND VPWR sky130_fd_sc_hd__tapvpwrvgnd_1
Xfill_46_32 VGND VGND VPWR VPWR sky130_fd_sc_hd__decap_4
Xfill_46_21 VGND VPWR sky130_fd_sc_hd__tapvpwrvgnd_1
Xfill_46_10 VGND VPWR sky130_fd_sc_hd__tapvpwrvgnd_1
XSLICE_16\[1\].RAM16.SLICE\[0\].RAM8.WORD\[3\].W.BYTE\[3\].B.genblk1.CG SLICE_16\[1\].RAM16.SLICE\[0\].RAM8.WORD\[3\].W.BYTE\[3\].B.CLK_B
+ SLICE_16\[1\].RAM16.SLICE\[0\].RAM8.WORD\[3\].W.BYTE\[3\].B.WE0_WIRE VGND VGND VPWR
+ VPWR SLICE_16\[1\].RAM16.SLICE\[0\].RAM8.WORD\[3\].W.BYTE\[3\].B.GCLK sky130_fd_sc_hd__dlclkp_1
Xfill_46_98 VGND VGND VPWR VPWR sky130_fd_sc_hd__decap_12
XSLICE_16\[0\].RAM16.SLICE\[1\].RAM8.WORD\[4\].W.BYTE\[1\].B.BIT\[0\].OBUF0 SLICE_16\[0\].RAM16.SLICE\[1\].RAM8.WORD\[4\].W.BYTE\[1\].B.Q_WIRE\[0\]
+ SLICE_16\[0\].RAM16.SLICE\[1\].RAM8.WORD\[4\].W.BYTE\[1\].B.SEL0_B VGND VGND VPWR
+ VPWR SLICE_16\[0\].RAM16.BYTE\[1\].FLOATBUF0\[8\].Z sky130_fd_sc_hd__ebufn_2
XSLICE_16\[1\].RAM16.SLICE\[1\].RAM8.WORD\[3\].W.BYTE\[2\].B.BIT\[7\].OBUF0 SLICE_16\[1\].RAM16.SLICE\[1\].RAM8.WORD\[3\].W.BYTE\[2\].B.Q_WIRE\[7\]
+ SLICE_16\[1\].RAM16.SLICE\[1\].RAM8.WORD\[3\].W.BYTE\[2\].B.SEL0_B VGND VGND VPWR
+ VPWR SLICE_16\[1\].RAM16.BYTE\[2\].FLOATBUF0\[23\].Z sky130_fd_sc_hd__ebufn_2
XSLICE_16\[1\].RAM16.SLICE\[1\].RAM8.WORD\[7\].W.BYTE\[3\].B.BIT\[3\].genblk1.STORAGE
+ DIBUF\[27\].X SLICE_16\[1\].RAM16.SLICE\[1\].RAM8.WORD\[7\].W.BYTE\[3\].B.GCLK VGND
+ VGND VPWR VPWR SLICE_16\[1\].RAM16.SLICE\[1\].RAM8.WORD\[7\].W.BYTE\[3\].B.Q_WIRE\[3\]
+ sky130_fd_sc_hd__dlxtp_1
Xfill_21_2 VGND VGND VPWR VPWR sky130_fd_sc_hd__decap_12
Xfill_14_1 VGND VPWR sky130_fd_sc_hd__tapvpwrvgnd_1
Xtap_9_18 VGND VPWR sky130_fd_sc_hd__tapvpwrvgnd_1
Xtap_9_29 VGND VPWR sky130_fd_sc_hd__tapvpwrvgnd_1
XSLICE_16\[1\].RAM16.SLICE\[1\].RAM8.WORD\[5\].W.BYTE\[1\].B.BIT\[2\].genblk1.STORAGE
+ DIBUF\[10\].X SLICE_16\[1\].RAM16.SLICE\[1\].RAM8.WORD\[5\].W.BYTE\[1\].B.GCLK VGND
+ VGND VPWR VPWR SLICE_16\[1\].RAM16.SLICE\[1\].RAM8.WORD\[5\].W.BYTE\[1\].B.Q_WIRE\[2\]
+ sky130_fd_sc_hd__dlxtp_1
XSLICE_16\[0\].RAM16.SLICE\[0\].RAM8.WORD\[3\].W.BYTE\[3\].B.BIT\[2\].OBUF0 SLICE_16\[0\].RAM16.SLICE\[0\].RAM8.WORD\[3\].W.BYTE\[3\].B.Q_WIRE\[2\]
+ SLICE_16\[0\].RAM16.SLICE\[0\].RAM8.WORD\[3\].W.BYTE\[3\].B.SEL0_B VGND VGND VPWR
+ VPWR SLICE_16\[0\].RAM16.BYTE\[3\].FLOATBUF0\[26\].Z sky130_fd_sc_hd__ebufn_2
XSLICE_16\[1\].RAM16.WEBUF\[0\].__cell__ SLICE_16\[0\].RAM16.WE0\[0\] VGND VGND VPWR
+ VPWR SLICE_16\[1\].RAM16.SLICE\[0\].RAM8.WE0\[0\] sky130_fd_sc_hd__clkbuf_2
Xtap_36_8 VGND VPWR sky130_fd_sc_hd__tapvpwrvgnd_1
Xtap_29_7 VGND VPWR sky130_fd_sc_hd__tapvpwrvgnd_1
Xtap_28_25 VGND VPWR sky130_fd_sc_hd__tapvpwrvgnd_1
Xtap_28_14 VGND VPWR sky130_fd_sc_hd__tapvpwrvgnd_1
XSLICE_16\[1\].RAM16.SLICE\[1\].RAM8.WORD\[0\].W.BYTE\[0\].B.SEL0INV SLICE_16\[1\].RAM16.SLICE\[1\].RAM8.WORD\[0\].W.BYTE\[0\].B.SEL0
+ VGND VGND VPWR VPWR SLICE_16\[1\].RAM16.SLICE\[1\].RAM8.WORD\[0\].W.BYTE\[0\].B.SEL0_B
+ sky130_fd_sc_hd__inv_1
XSLICE_16\[1\].RAM16.Do0_REG.OUTREG_BYTE\[3\].Do_FF\[2\] SLICE_16\[1\].RAM16.Do0_REG.CLKBUF\[3\]
+ SLICE_16\[1\].RAM16.BYTE\[3\].FLOATBUF0\[26\].Z VGND VGND VPWR VPWR Do0MUX.A1\[26\]
+ sky130_fd_sc_hd__dfxtp_1
XA0BUF\[2\].__cell__ A0[2] VGND VGND VPWR VPWR A0BUF\[2\].X sky130_fd_sc_hd__clkbuf_2
XDIBUF\[30\].__cell__ Di0[30] VGND VGND VPWR VPWR DIBUF\[30\].X sky130_fd_sc_hd__clkbuf_16
XSLICE_16\[0\].RAM16.SLICE\[0\].RAM8.WORD\[0\].W.BYTE\[0\].B.BIT\[7\].OBUF0 SLICE_16\[0\].RAM16.SLICE\[0\].RAM8.WORD\[0\].W.BYTE\[0\].B.Q_WIRE\[7\]
+ SLICE_16\[0\].RAM16.SLICE\[0\].RAM8.WORD\[0\].W.BYTE\[0\].B.SEL0_B VGND VGND VPWR
+ VPWR SLICE_16\[0\].RAM16.BYTE\[0\].FLOATBUF0\[7\].Z sky130_fd_sc_hd__ebufn_2
XSLICE_16\[1\].RAM16.SLICE\[1\].RAM8.WORD\[2\].W.BYTE\[0\].B.BIT\[4\].OBUF0 SLICE_16\[1\].RAM16.SLICE\[1\].RAM8.WORD\[2\].W.BYTE\[0\].B.Q_WIRE\[4\]
+ SLICE_16\[1\].RAM16.SLICE\[1\].RAM8.WORD\[2\].W.BYTE\[0\].B.SEL0_B VGND VGND VPWR
+ VPWR SLICE_16\[1\].RAM16.BYTE\[0\].FLOATBUF0\[4\].Z sky130_fd_sc_hd__ebufn_2
XSLICE_16\[0\].RAM16.SLICE\[1\].RAM8.WORD\[7\].W.BYTE\[2\].B.BIT\[0\].OBUF0 SLICE_16\[0\].RAM16.SLICE\[1\].RAM8.WORD\[7\].W.BYTE\[2\].B.Q_WIRE\[0\]
+ SLICE_16\[0\].RAM16.SLICE\[1\].RAM8.WORD\[7\].W.BYTE\[2\].B.SEL0_B VGND VGND VPWR
+ VPWR SLICE_16\[0\].RAM16.BYTE\[2\].FLOATBUF0\[16\].Z sky130_fd_sc_hd__ebufn_2
XSLICE_16\[1\].RAM16.SLICE\[1\].RAM8.WORD\[6\].W.BYTE\[3\].B.BIT\[7\].OBUF0 SLICE_16\[1\].RAM16.SLICE\[1\].RAM8.WORD\[6\].W.BYTE\[3\].B.Q_WIRE\[7\]
+ SLICE_16\[1\].RAM16.SLICE\[1\].RAM8.WORD\[6\].W.BYTE\[3\].B.SEL0_B VGND VGND VPWR
+ VPWR SLICE_16\[1\].RAM16.BYTE\[3\].FLOATBUF0\[31\].Z sky130_fd_sc_hd__ebufn_2
XSLICE_16\[0\].RAM16.SLICE\[1\].RAM8.WORD\[6\].W.BYTE\[0\].B.genblk1.CG SLICE_16\[0\].RAM16.SLICE\[1\].RAM8.WORD\[6\].W.BYTE\[0\].B.CLK_B
+ SLICE_16\[0\].RAM16.SLICE\[1\].RAM8.WORD\[6\].W.BYTE\[0\].B.WE0_WIRE VGND VGND VPWR
+ VPWR SLICE_16\[0\].RAM16.SLICE\[1\].RAM8.WORD\[6\].W.BYTE\[0\].B.GCLK sky130_fd_sc_hd__dlclkp_1
XSLICE_16\[0\].RAM16.SLICE\[0\].RAM8.WORD\[1\].W.BYTE\[2\].B.CGAND SLICE_16\[0\].RAM16.SLICE\[0\].RAM8.WORD\[1\].W.BYTE\[0\].B.SEL0
+ SLICE_16\[0\].RAM16.SLICE\[0\].RAM8.WE0_buf\[2\] VGND VGND VPWR VPWR SLICE_16\[0\].RAM16.SLICE\[0\].RAM8.WORD\[1\].W.BYTE\[2\].B.WE0_WIRE
+ sky130_fd_sc_hd__and2_1
XSLICE_16\[0\].RAM16.SLICE\[0\].RAM8.WORD\[5\].W.BYTE\[3\].B.BIT\[5\].genblk1.STORAGE
+ DIBUF\[29\].X SLICE_16\[0\].RAM16.SLICE\[0\].RAM8.WORD\[5\].W.BYTE\[3\].B.GCLK VGND
+ VGND VPWR VPWR SLICE_16\[0\].RAM16.SLICE\[0\].RAM8.WORD\[5\].W.BYTE\[3\].B.Q_WIRE\[5\]
+ sky130_fd_sc_hd__dlxtp_1
XSLICE_16\[1\].RAM16.SLICE\[1\].RAM8.DEC0.AND0 SLICE_16\[1\].RAM16.SLICE\[1\].RAM8.DEC0.A_buf\[0\]
+ SLICE_16\[1\].RAM16.SLICE\[1\].RAM8.DEC0.A_buf\[1\] SLICE_16\[1\].RAM16.SLICE\[1\].RAM8.DEC0.A_buf\[2\]
+ SLICE_16\[1\].RAM16.SLICE\[1\].RAM8.DEC0.EN_buf VGND VGND VPWR VPWR SLICE_16\[1\].RAM16.SLICE\[1\].RAM8.DEC0.SEL\[0\]
+ sky130_fd_sc_hd__nor4b_2
XSLICE_16\[1\].RAM16.SLICE\[0\].RAM8.WORD\[1\].W.BYTE\[2\].B.BIT\[6\].OBUF0 SLICE_16\[1\].RAM16.SLICE\[0\].RAM8.WORD\[1\].W.BYTE\[2\].B.Q_WIRE\[6\]
+ SLICE_16\[1\].RAM16.SLICE\[0\].RAM8.WORD\[1\].W.BYTE\[2\].B.SEL0_B VGND VGND VPWR
+ VPWR SLICE_16\[1\].RAM16.BYTE\[2\].FLOATBUF0\[22\].Z sky130_fd_sc_hd__ebufn_2
XSLICE_16\[0\].RAM16.SLICE\[0\].RAM8.WORD\[3\].W.BYTE\[1\].B.BIT\[4\].genblk1.STORAGE
+ DIBUF\[12\].X SLICE_16\[0\].RAM16.SLICE\[0\].RAM8.WORD\[3\].W.BYTE\[1\].B.GCLK VGND
+ VGND VPWR VPWR SLICE_16\[0\].RAM16.SLICE\[0\].RAM8.WORD\[3\].W.BYTE\[1\].B.Q_WIRE\[4\]
+ sky130_fd_sc_hd__dlxtp_1
XSLICE_16\[0\].RAM16.SLICE\[0\].RAM8.WORD\[3\].W.BYTE\[1\].B.BIT\[7\].OBUF0 SLICE_16\[0\].RAM16.SLICE\[0\].RAM8.WORD\[3\].W.BYTE\[1\].B.Q_WIRE\[7\]
+ SLICE_16\[0\].RAM16.SLICE\[0\].RAM8.WORD\[3\].W.BYTE\[1\].B.SEL0_B VGND VGND VPWR
+ VPWR SLICE_16\[0\].RAM16.BYTE\[1\].FLOATBUF0\[15\].Z sky130_fd_sc_hd__ebufn_2
Xtap_30_15 VGND VPWR sky130_fd_sc_hd__tapvpwrvgnd_1
Xtap_14_27 VGND VPWR sky130_fd_sc_hd__tapvpwrvgnd_1
Xtap_14_16 VGND VPWR sky130_fd_sc_hd__tapvpwrvgnd_1
XSLICE_16\[1\].RAM16.SLICE\[1\].RAM8.WORD\[5\].W.BYTE\[1\].B.BIT\[4\].OBUF0 SLICE_16\[1\].RAM16.SLICE\[1\].RAM8.WORD\[5\].W.BYTE\[1\].B.Q_WIRE\[4\]
+ SLICE_16\[1\].RAM16.SLICE\[1\].RAM8.WORD\[5\].W.BYTE\[1\].B.SEL0_B VGND VGND VPWR
+ VPWR SLICE_16\[1\].RAM16.BYTE\[1\].FLOATBUF0\[12\].Z sky130_fd_sc_hd__ebufn_2
Xtap_30_26 VGND VPWR sky130_fd_sc_hd__tapvpwrvgnd_1
XSLICE_16\[1\].RAM16.Do0_REG.OUTREG_BYTE\[0\].DIODE\[5\] SLICE_16\[1\].RAM16.BYTE\[0\].FLOATBUF0\[5\].Z
+ VGND VGND VPWR VPWR sky130_fd_sc_hd__diode_2
Xtap_34_5 VGND VPWR sky130_fd_sc_hd__tapvpwrvgnd_1
Xtap_27_4 VGND VPWR sky130_fd_sc_hd__tapvpwrvgnd_1
Xtap_1_30 VGND VPWR sky130_fd_sc_hd__tapvpwrvgnd_1
XSLICE_16\[1\].RAM16.BYTE\[0\].FLOATBUF0\[1\].__cell__ SLICE_16\[1\].RAM16.BYTE\[0\].FLOATBUF0\[0\].A
+ SLICE_16\[1\].RAM16.BYTE\[0\].FLOATBUF0\[0\].TE_B VGND VGND VPWR VPWR SLICE_16\[1\].RAM16.BYTE\[0\].FLOATBUF0\[1\].Z
+ sky130_fd_sc_hd__ebufn_2
XSLICE_16\[1\].RAM16.SLICE\[1\].RAM8.WORD\[2\].W.BYTE\[3\].B.BIT\[3\].genblk1.STORAGE
+ DIBUF\[27\].X SLICE_16\[1\].RAM16.SLICE\[1\].RAM8.WORD\[2\].W.BYTE\[3\].B.GCLK VGND
+ VGND VPWR VPWR SLICE_16\[1\].RAM16.SLICE\[1\].RAM8.WORD\[2\].W.BYTE\[3\].B.Q_WIRE\[3\]
+ sky130_fd_sc_hd__dlxtp_1
XSLICE_16\[1\].RAM16.SLICE\[0\].RAM8.WORD\[0\].W.BYTE\[0\].B.BIT\[3\].OBUF0 SLICE_16\[1\].RAM16.SLICE\[0\].RAM8.WORD\[0\].W.BYTE\[0\].B.Q_WIRE\[3\]
+ SLICE_16\[1\].RAM16.SLICE\[0\].RAM8.WORD\[0\].W.BYTE\[0\].B.SEL0_B VGND VGND VPWR
+ VPWR SLICE_16\[1\].RAM16.BYTE\[0\].FLOATBUF0\[3\].Z sky130_fd_sc_hd__ebufn_2
XSLICE_16\[0\].RAM16.SLICE\[1\].RAM8.WORD\[7\].W.BYTE\[0\].B.BIT\[5\].OBUF0 SLICE_16\[0\].RAM16.SLICE\[1\].RAM8.WORD\[7\].W.BYTE\[0\].B.Q_WIRE\[5\]
+ SLICE_16\[0\].RAM16.SLICE\[1\].RAM8.WORD\[7\].W.BYTE\[0\].B.SEL0_B VGND VGND VPWR
+ VPWR SLICE_16\[0\].RAM16.BYTE\[0\].FLOATBUF0\[5\].Z sky130_fd_sc_hd__ebufn_2
Xfill_43_99 VGND VPWR sky130_fd_sc_hd__tapvpwrvgnd_1
Xfill_43_88 VGND VGND VPWR VPWR sky130_fd_sc_hd__decap_12
Xfill_43_77 VGND VGND VPWR VPWR sky130_fd_sc_hd__decap_12
Xfill_43_66 VGND VPWR sky130_fd_sc_hd__tapvpwrvgnd_1
Xfill_43_55 VGND VGND VPWR VPWR sky130_fd_sc_hd__decap_12
Xfill_43_44 VGND VGND VPWR VPWR sky130_fd_sc_hd__decap_12
Xfill_43_33 VGND VPWR sky130_fd_sc_hd__tapvpwrvgnd_1
Xfill_43_22 VGND VGND VPWR VPWR sky130_fd_sc_hd__decap_12
Xfill_43_11 VGND VGND VPWR VPWR sky130_fd_sc_hd__decap_12
XSLICE_16\[1\].RAM16.SLICE\[1\].RAM8.WORD\[6\].W.BYTE\[0\].B.BIT\[1\].genblk1.STORAGE
+ DIBUF\[1\].X SLICE_16\[1\].RAM16.SLICE\[1\].RAM8.WORD\[6\].W.BYTE\[0\].B.GCLK VGND
+ VGND VPWR VPWR SLICE_16\[1\].RAM16.SLICE\[1\].RAM8.WORD\[6\].W.BYTE\[0\].B.Q_WIRE\[1\]
+ sky130_fd_sc_hd__dlxtp_1
XSLICE_16\[1\].RAM16.SLICE\[1\].RAM8.WORD\[0\].W.BYTE\[1\].B.BIT\[2\].genblk1.STORAGE
+ DIBUF\[10\].X SLICE_16\[1\].RAM16.SLICE\[1\].RAM8.WORD\[0\].W.BYTE\[1\].B.GCLK VGND
+ VGND VPWR VPWR SLICE_16\[1\].RAM16.SLICE\[1\].RAM8.WORD\[0\].W.BYTE\[1\].B.Q_WIRE\[2\]
+ sky130_fd_sc_hd__dlxtp_1
XSLICE_16\[1\].RAM16.SLICE\[0\].RAM8.WORD\[4\].W.BYTE\[3\].B.BIT\[6\].OBUF0 SLICE_16\[1\].RAM16.SLICE\[0\].RAM8.WORD\[4\].W.BYTE\[3\].B.Q_WIRE\[6\]
+ SLICE_16\[1\].RAM16.SLICE\[0\].RAM8.WORD\[4\].W.BYTE\[3\].B.SEL0_B VGND VGND VPWR
+ VPWR SLICE_16\[1\].RAM16.BYTE\[3\].FLOATBUF0\[30\].Z sky130_fd_sc_hd__ebufn_2
XDo0MUX.M\[0\].MUX\[0\] Do0MUX.A0\[0\] Do0MUX.A1\[0\] Do0MUX.SEL\[0\] VGND VGND VPWR
+ VPWR Do0[0] sky130_fd_sc_hd__mux2_1
XSLICE_16\[0\].RAM16.Do0_REG.OUTREG_BYTE\[2\].DIODE\[2\] SLICE_16\[0\].RAM16.BYTE\[2\].FLOATBUF0\[18\].Z
+ VGND VGND VPWR VPWR sky130_fd_sc_hd__diode_2
XSLICE_16\[0\].RAM16.SLICE\[0\].RAM8.WORD\[6\].W.BYTE\[2\].B.BIT\[7\].OBUF0 SLICE_16\[0\].RAM16.SLICE\[0\].RAM8.WORD\[6\].W.BYTE\[2\].B.Q_WIRE\[7\]
+ SLICE_16\[0\].RAM16.SLICE\[0\].RAM8.WORD\[6\].W.BYTE\[2\].B.SEL0_B VGND VGND VPWR
+ VPWR SLICE_16\[0\].RAM16.BYTE\[2\].FLOATBUF0\[23\].Z sky130_fd_sc_hd__ebufn_2
Xfill_45_102 VGND VPWR sky130_fd_sc_hd__tapvpwrvgnd_1
XSLICE_16\[0\].RAM16.SLICE\[1\].RAM8.WORD\[2\].W.BYTE\[1\].B.CGAND SLICE_16\[0\].RAM16.SLICE\[1\].RAM8.WORD\[2\].W.BYTE\[0\].B.SEL0
+ SLICE_16\[0\].RAM16.SLICE\[1\].RAM8.WE0_buf\[1\] VGND VGND VPWR VPWR SLICE_16\[0\].RAM16.SLICE\[1\].RAM8.WORD\[2\].W.BYTE\[1\].B.WE0_WIRE
+ sky130_fd_sc_hd__and2_1
XSLICE_16\[1\].RAM16.SLICE\[0\].RAM8.WORD\[3\].W.BYTE\[0\].B.BIT\[7\].genblk1.STORAGE
+ DIBUF\[7\].X SLICE_16\[1\].RAM16.SLICE\[0\].RAM8.WORD\[3\].W.BYTE\[0\].B.GCLK VGND
+ VGND VPWR VPWR SLICE_16\[1\].RAM16.SLICE\[0\].RAM8.WORD\[3\].W.BYTE\[0\].B.Q_WIRE\[7\]
+ sky130_fd_sc_hd__dlxtp_1
Xtap_6_19 VGND VPWR sky130_fd_sc_hd__tapvpwrvgnd_1
XSLICE_16\[1\].RAM16.SLICE\[0\].RAM8.WORD\[3\].W.BYTE\[1\].B.BIT\[3\].OBUF0 SLICE_16\[1\].RAM16.SLICE\[0\].RAM8.WORD\[3\].W.BYTE\[1\].B.Q_WIRE\[3\]
+ SLICE_16\[1\].RAM16.SLICE\[0\].RAM8.WORD\[3\].W.BYTE\[1\].B.SEL0_B VGND VGND VPWR
+ VPWR SLICE_16\[1\].RAM16.BYTE\[1\].FLOATBUF0\[11\].Z sky130_fd_sc_hd__ebufn_2
Xtap_25_26 VGND VPWR sky130_fd_sc_hd__tapvpwrvgnd_1
Xtap_25_15 VGND VPWR sky130_fd_sc_hd__tapvpwrvgnd_1
XSLICE_16\[0\].RAM16.BYTE\[2\].FLOATBUF0\[18\].__cell__ SLICE_16\[0\].RAM16.BYTE\[2\].FLOATBUF0\[16\].A
+ SLICE_16\[0\].RAM16.BYTE\[2\].FLOATBUF0\[16\].TE_B VGND VGND VPWR VPWR SLICE_16\[0\].RAM16.BYTE\[2\].FLOATBUF0\[18\].Z
+ sky130_fd_sc_hd__ebufn_2
XSLICE_16\[0\].RAM16.SLICE\[0\].RAM8.WORD\[0\].W.BYTE\[3\].B.BIT\[5\].genblk1.STORAGE
+ DIBUF\[29\].X SLICE_16\[0\].RAM16.SLICE\[0\].RAM8.WORD\[0\].W.BYTE\[3\].B.GCLK VGND
+ VGND VPWR VPWR SLICE_16\[0\].RAM16.SLICE\[0\].RAM8.WORD\[0\].W.BYTE\[3\].B.Q_WIRE\[5\]
+ sky130_fd_sc_hd__dlxtp_1
XSLICE_16\[0\].RAM16.SLICE\[0\].RAM8.WORD\[4\].W.BYTE\[0\].B.BIT\[3\].genblk1.STORAGE
+ DIBUF\[3\].X SLICE_16\[0\].RAM16.SLICE\[0\].RAM8.WORD\[4\].W.BYTE\[0\].B.GCLK VGND
+ VGND VPWR VPWR SLICE_16\[0\].RAM16.SLICE\[0\].RAM8.WORD\[4\].W.BYTE\[0\].B.Q_WIRE\[3\]
+ sky130_fd_sc_hd__dlxtp_1
Xtap_6_9 VGND VPWR sky130_fd_sc_hd__tapvpwrvgnd_1
XSLICE_16\[0\].RAM16.SLICE\[0\].RAM8.WORD\[6\].W.BYTE\[2\].B.BIT\[4\].genblk1.STORAGE
+ DIBUF\[20\].X SLICE_16\[0\].RAM16.SLICE\[0\].RAM8.WORD\[6\].W.BYTE\[2\].B.GCLK VGND
+ VGND VPWR VPWR SLICE_16\[0\].RAM16.SLICE\[0\].RAM8.WORD\[6\].W.BYTE\[2\].B.Q_WIRE\[4\]
+ sky130_fd_sc_hd__dlxtp_1
XSLICE_16\[0\].RAM16.SLICE\[1\].RAM8.WORD\[0\].W.BYTE\[3\].B.BIT\[2\].OBUF0 SLICE_16\[0\].RAM16.SLICE\[1\].RAM8.WORD\[0\].W.BYTE\[3\].B.Q_WIRE\[2\]
+ SLICE_16\[0\].RAM16.SLICE\[1\].RAM8.WORD\[0\].W.BYTE\[3\].B.SEL0_B VGND VGND VPWR
+ VPWR SLICE_16\[0\].RAM16.BYTE\[3\].FLOATBUF0\[26\].Z sky130_fd_sc_hd__ebufn_2
Xtap_32_2 VGND VPWR sky130_fd_sc_hd__tapvpwrvgnd_1
XSLICE_16\[0\].RAM16.SLICE\[0\].RAM8.WORD\[5\].W.BYTE\[0\].B.BIT\[4\].OBUF0 SLICE_16\[0\].RAM16.SLICE\[0\].RAM8.WORD\[5\].W.BYTE\[0\].B.Q_WIRE\[4\]
+ SLICE_16\[0\].RAM16.SLICE\[0\].RAM8.WORD\[5\].W.BYTE\[0\].B.SEL0_B VGND VGND VPWR
+ VPWR SLICE_16\[0\].RAM16.BYTE\[0\].FLOATBUF0\[4\].Z sky130_fd_sc_hd__ebufn_2
XSLICE_16\[1\].RAM16.SLICE\[1\].RAM8.WORD\[7\].W.BYTE\[0\].B.BIT\[1\].OBUF0 SLICE_16\[1\].RAM16.SLICE\[1\].RAM8.WORD\[7\].W.BYTE\[0\].B.Q_WIRE\[1\]
+ SLICE_16\[1\].RAM16.SLICE\[1\].RAM8.WORD\[7\].W.BYTE\[0\].B.SEL0_B VGND VGND VPWR
+ VPWR SLICE_16\[1\].RAM16.BYTE\[0\].FLOATBUF0\[1\].Z sky130_fd_sc_hd__ebufn_2
Xtap_25_1 VGND VPWR sky130_fd_sc_hd__tapvpwrvgnd_1
Xtap_18_0 VGND VPWR sky130_fd_sc_hd__tapvpwrvgnd_1
XSLICE_16\[0\].RAM16.FBUFENBUF0\[0\].__cell__ DEC0.SEL\[0\] VGND VGND VPWR VPWR SLICE_16\[0\].RAM16.BYTE\[0\].FLOATBUF0\[0\].TE_B
+ sky130_fd_sc_hd__clkbuf_2
XSLICE_16\[0\].RAM16.SLICE\[0\].RAM8.WORD\[2\].W.BYTE\[3\].B.genblk1.CG SLICE_16\[0\].RAM16.SLICE\[0\].RAM8.WORD\[2\].W.BYTE\[3\].B.CLK_B
+ SLICE_16\[0\].RAM16.SLICE\[0\].RAM8.WORD\[2\].W.BYTE\[3\].B.WE0_WIRE VGND VGND VPWR
+ VPWR SLICE_16\[0\].RAM16.SLICE\[0\].RAM8.WORD\[2\].W.BYTE\[3\].B.GCLK sky130_fd_sc_hd__dlclkp_1
XSLICE_16\[0\].RAM16.Do0_REG.OUTREG_BYTE\[1\].Do_FF\[3\] SLICE_16\[0\].RAM16.Do0_REG.CLKBUF\[1\]
+ SLICE_16\[0\].RAM16.BYTE\[1\].FLOATBUF0\[11\].Z VGND VGND VPWR VPWR Do0MUX.A0\[11\]
+ sky130_fd_sc_hd__dfxtp_1
Xfill_46_4 VGND VGND VPWR VPWR sky130_fd_sc_hd__decap_4
Xfill_39_3 VGND VPWR sky130_fd_sc_hd__tapvpwrvgnd_1
XSLICE_16\[1\].RAM16.SLICE\[1\].RAM8.WORD\[3\].W.BYTE\[2\].B.BIT\[2\].genblk1.STORAGE
+ DIBUF\[18\].X SLICE_16\[1\].RAM16.SLICE\[1\].RAM8.WORD\[3\].W.BYTE\[2\].B.GCLK VGND
+ VGND VPWR VPWR SLICE_16\[1\].RAM16.SLICE\[1\].RAM8.WORD\[3\].W.BYTE\[2\].B.Q_WIRE\[2\]
+ sky130_fd_sc_hd__dlxtp_1
XSLICE_16\[1\].RAM16.SLICE\[0\].RAM8.WORD\[6\].W.BYTE\[2\].B.BIT\[3\].OBUF0 SLICE_16\[1\].RAM16.SLICE\[0\].RAM8.WORD\[6\].W.BYTE\[2\].B.Q_WIRE\[3\]
+ SLICE_16\[1\].RAM16.SLICE\[0\].RAM8.WORD\[6\].W.BYTE\[2\].B.SEL0_B VGND VGND VPWR
+ VPWR SLICE_16\[1\].RAM16.BYTE\[2\].FLOATBUF0\[19\].Z sky130_fd_sc_hd__ebufn_2
XSLICE_16\[0\].RAM16.SLICE\[1\].RAM8.DEC0.AND4 SLICE_16\[0\].RAM16.SLICE\[1\].RAM8.DEC0.A_buf\[0\]
+ SLICE_16\[0\].RAM16.SLICE\[1\].RAM8.DEC0.A_buf\[1\] SLICE_16\[0\].RAM16.SLICE\[1\].RAM8.DEC0.A_buf\[2\]
+ SLICE_16\[0\].RAM16.SLICE\[1\].RAM8.DEC0.EN_buf VGND VGND VPWR VPWR SLICE_16\[0\].RAM16.SLICE\[1\].RAM8.DEC0.SEL\[4\]
+ sky130_fd_sc_hd__and4bb_2
XDo0MUX.M\[3\].MUX\[5\] Do0MUX.A0\[29\] Do0MUX.A1\[29\] Do0MUX.SEL\[3\] VGND VGND
+ VPWR VPWR Do0[29] sky130_fd_sc_hd__mux2_1
XSLICE_16\[1\].RAM16.SLICE\[1\].RAM8.WORD\[1\].W.BYTE\[0\].B.BIT\[1\].genblk1.STORAGE
+ DIBUF\[1\].X SLICE_16\[1\].RAM16.SLICE\[1\].RAM8.WORD\[1\].W.BYTE\[0\].B.GCLK VGND
+ VGND VPWR VPWR SLICE_16\[1\].RAM16.SLICE\[1\].RAM8.WORD\[1\].W.BYTE\[0\].B.Q_WIRE\[1\]
+ sky130_fd_sc_hd__dlxtp_1
Xtap_11_17 VGND VPWR sky130_fd_sc_hd__tapvpwrvgnd_1
Xtap_11_28 VGND VPWR sky130_fd_sc_hd__tapvpwrvgnd_1
XSLICE_16\[0\].RAM16.SLICE\[1\].RAM8.WORD\[0\].W.BYTE\[1\].B.BIT\[7\].OBUF0 SLICE_16\[0\].RAM16.SLICE\[1\].RAM8.WORD\[0\].W.BYTE\[1\].B.Q_WIRE\[7\]
+ SLICE_16\[0\].RAM16.SLICE\[1\].RAM8.WORD\[0\].W.BYTE\[1\].B.SEL0_B VGND VGND VPWR
+ VPWR SLICE_16\[0\].RAM16.BYTE\[1\].FLOATBUF0\[15\].Z sky130_fd_sc_hd__ebufn_2
Xtap_36_25 VGND VPWR sky130_fd_sc_hd__tapvpwrvgnd_1
Xtap_36_14 VGND VPWR sky130_fd_sc_hd__tapvpwrvgnd_1
Xtap_11_7 VGND VPWR sky130_fd_sc_hd__tapvpwrvgnd_1
XSLICE_16\[1\].RAM16.SLICE\[0\].RAM8.WORD\[6\].W.BYTE\[1\].B.BIT\[7\].genblk1.STORAGE
+ DIBUF\[15\].X SLICE_16\[1\].RAM16.SLICE\[0\].RAM8.WORD\[6\].W.BYTE\[1\].B.GCLK VGND
+ VGND VPWR VPWR SLICE_16\[1\].RAM16.SLICE\[0\].RAM8.WORD\[6\].W.BYTE\[1\].B.Q_WIRE\[7\]
+ sky130_fd_sc_hd__dlxtp_1
Xtap_4_6 VGND VPWR sky130_fd_sc_hd__tapvpwrvgnd_1
XTIE_ZERO_zero_ VGND VGND VPWR VPWR TIE_ZERO_zero_/HI zero_ sky130_fd_sc_hd__conb_1
Xfill_40_23 VGND VGND VPWR VPWR sky130_fd_sc_hd__decap_12
Xfill_40_12 VGND VPWR sky130_fd_sc_hd__tapvpwrvgnd_1
XSLICE_16\[1\].RAM16.SLICE\[0\].RAM8.WORD\[5\].W.BYTE\[0\].B.BIT\[0\].OBUF0 SLICE_16\[1\].RAM16.SLICE\[0\].RAM8.WORD\[5\].W.BYTE\[0\].B.Q_WIRE\[0\]
+ SLICE_16\[1\].RAM16.SLICE\[0\].RAM8.WORD\[5\].W.BYTE\[0\].B.SEL0_B VGND VGND VPWR
+ VPWR SLICE_16\[1\].RAM16.BYTE\[0\].FLOATBUF0\[0\].Z sky130_fd_sc_hd__ebufn_2
XDo0MUX.M\[2\].MUX\[7\] Do0MUX.A0\[23\] Do0MUX.A1\[23\] Do0MUX.SEL\[2\] VGND VGND
+ VPWR VPWR Do0[23] sky130_fd_sc_hd__mux2_1
XSLICE_16\[1\].RAM16.SLICE\[1\].RAM8.WORD\[1\].W.BYTE\[3\].B.BIT\[6\].OBUF0 SLICE_16\[1\].RAM16.SLICE\[1\].RAM8.WORD\[1\].W.BYTE\[3\].B.Q_WIRE\[6\]
+ SLICE_16\[1\].RAM16.SLICE\[1\].RAM8.WORD\[1\].W.BYTE\[3\].B.SEL0_B VGND VGND VPWR
+ VPWR SLICE_16\[1\].RAM16.BYTE\[3\].FLOATBUF0\[30\].Z sky130_fd_sc_hd__ebufn_2
XSLICE_16\[0\].RAM16.SLICE\[0\].RAM8.WORD\[1\].W.BYTE\[2\].B.BIT\[4\].genblk1.STORAGE
+ DIBUF\[20\].X SLICE_16\[0\].RAM16.SLICE\[0\].RAM8.WORD\[1\].W.BYTE\[2\].B.GCLK VGND
+ VGND VPWR VPWR SLICE_16\[0\].RAM16.SLICE\[0\].RAM8.WORD\[1\].W.BYTE\[2\].B.Q_WIRE\[4\]
+ sky130_fd_sc_hd__dlxtp_1
XSLICE_16\[0\].RAM16.SLICE\[0\].RAM8.WORD\[7\].W.BYTE\[1\].B.BIT\[3\].genblk1.STORAGE
+ DIBUF\[11\].X SLICE_16\[0\].RAM16.SLICE\[0\].RAM8.WORD\[7\].W.BYTE\[1\].B.GCLK VGND
+ VGND VPWR VPWR SLICE_16\[0\].RAM16.SLICE\[0\].RAM8.WORD\[7\].W.BYTE\[1\].B.Q_WIRE\[3\]
+ sky130_fd_sc_hd__dlxtp_1
Xfill_18_8 VGND VGND VPWR VPWR sky130_fd_sc_hd__decap_12
XSLICE_16\[0\].RAM16.SLICE\[1\].RAM8.WORD\[3\].W.BYTE\[2\].B.BIT\[7\].OBUF0 SLICE_16\[0\].RAM16.SLICE\[1\].RAM8.WORD\[3\].W.BYTE\[2\].B.Q_WIRE\[7\]
+ SLICE_16\[0\].RAM16.SLICE\[1\].RAM8.WORD\[3\].W.BYTE\[2\].B.SEL0_B VGND VGND VPWR
+ VPWR SLICE_16\[0\].RAM16.BYTE\[2\].FLOATBUF0\[23\].Z sky130_fd_sc_hd__ebufn_2
Xfill_44_1 VGND VGND VPWR VPWR sky130_fd_sc_hd__decap_12
Xfill_37_0 VGND VPWR sky130_fd_sc_hd__tapvpwrvgnd_1
XSLICE_16\[0\].RAM16.SLICE\[1\].RAM8.WORD\[7\].W.BYTE\[3\].B.genblk1.CG SLICE_16\[0\].RAM16.SLICE\[1\].RAM8.WORD\[7\].W.BYTE\[3\].B.CLK_B
+ SLICE_16\[0\].RAM16.SLICE\[1\].RAM8.WORD\[7\].W.BYTE\[3\].B.WE0_WIRE VGND VGND VPWR
+ VPWR SLICE_16\[0\].RAM16.SLICE\[1\].RAM8.WORD\[7\].W.BYTE\[3\].B.GCLK sky130_fd_sc_hd__dlclkp_1
XSLICE_16\[1\].RAM16.SLICE\[1\].RAM8.WORD\[0\].W.BYTE\[1\].B.BIT\[3\].OBUF0 SLICE_16\[1\].RAM16.SLICE\[1\].RAM8.WORD\[0\].W.BYTE\[1\].B.Q_WIRE\[3\]
+ SLICE_16\[1\].RAM16.SLICE\[1\].RAM8.WORD\[0\].W.BYTE\[1\].B.SEL0_B VGND VGND VPWR
+ VPWR SLICE_16\[1\].RAM16.BYTE\[1\].FLOATBUF0\[11\].Z sky130_fd_sc_hd__ebufn_2
XSLICE_16\[1\].RAM16.SLICE\[1\].RAM8.WORD\[6\].W.BYTE\[3\].B.BIT\[2\].genblk1.STORAGE
+ DIBUF\[26\].X SLICE_16\[1\].RAM16.SLICE\[1\].RAM8.WORD\[6\].W.BYTE\[3\].B.GCLK VGND
+ VGND VPWR VPWR SLICE_16\[1\].RAM16.SLICE\[1\].RAM8.WORD\[6\].W.BYTE\[3\].B.Q_WIRE\[2\]
+ sky130_fd_sc_hd__dlxtp_1
XSLICE_16\[1\].RAM16.SLICE\[1\].RAM8.WORD\[4\].W.BYTE\[1\].B.BIT\[1\].genblk1.STORAGE
+ DIBUF\[9\].X SLICE_16\[1\].RAM16.SLICE\[1\].RAM8.WORD\[4\].W.BYTE\[1\].B.GCLK VGND
+ VGND VPWR VPWR SLICE_16\[1\].RAM16.SLICE\[1\].RAM8.WORD\[4\].W.BYTE\[1\].B.Q_WIRE\[1\]
+ sky130_fd_sc_hd__dlxtp_1
Xfill_19_79 VGND VGND VPWR VPWR sky130_fd_sc_hd__decap_12
Xfill_19_68 VGND VGND VPWR VPWR sky130_fd_sc_hd__decap_12
Xfill_19_57 VGND VPWR sky130_fd_sc_hd__tapvpwrvgnd_1
Xfill_19_46 VGND VGND VPWR VPWR sky130_fd_sc_hd__decap_12
Xfill_19_35 VGND VGND VPWR VPWR sky130_fd_sc_hd__decap_12
Xfill_19_24 VGND VPWR sky130_fd_sc_hd__tapvpwrvgnd_1
Xfill_19_13 VGND VGND VPWR VPWR sky130_fd_sc_hd__decap_12
Xtap_2_3 VGND VPWR sky130_fd_sc_hd__tapvpwrvgnd_1
XSLICE_16\[0\].RAM16.SLICE\[0\].RAM8.WORD\[2\].W.BYTE\[2\].B.DIODE_CLK SLICE_16\[0\].RAM16.SLICE\[0\].RAM8.WORD\[2\].W.BYTE\[0\].B.CLK
+ VGND VGND VPWR VPWR sky130_fd_sc_hd__diode_2
XSLICE_16\[0\].RAM16.SLICE\[1\].RAM8.WORD\[2\].W.BYTE\[0\].B.BIT\[4\].OBUF0 SLICE_16\[0\].RAM16.SLICE\[1\].RAM8.WORD\[2\].W.BYTE\[0\].B.Q_WIRE\[4\]
+ SLICE_16\[0\].RAM16.SLICE\[1\].RAM8.WORD\[2\].W.BYTE\[0\].B.SEL0_B VGND VGND VPWR
+ VPWR SLICE_16\[0\].RAM16.BYTE\[0\].FLOATBUF0\[4\].Z sky130_fd_sc_hd__ebufn_2
XSLICE_16\[0\].RAM16.SLICE\[1\].RAM8.WORD\[6\].W.BYTE\[3\].B.BIT\[7\].OBUF0 SLICE_16\[0\].RAM16.SLICE\[1\].RAM8.WORD\[6\].W.BYTE\[3\].B.Q_WIRE\[7\]
+ SLICE_16\[0\].RAM16.SLICE\[1\].RAM8.WORD\[6\].W.BYTE\[3\].B.SEL0_B VGND VGND VPWR
+ VPWR SLICE_16\[0\].RAM16.BYTE\[3\].FLOATBUF0\[31\].Z sky130_fd_sc_hd__ebufn_2
XSLICE_16\[1\].RAM16.SLICE\[1\].RAM8.WORD\[4\].W.BYTE\[2\].B.genblk1.CG SLICE_16\[1\].RAM16.SLICE\[1\].RAM8.WORD\[4\].W.BYTE\[2\].B.CLK_B
+ SLICE_16\[1\].RAM16.SLICE\[1\].RAM8.WORD\[4\].W.BYTE\[2\].B.WE0_WIRE VGND VGND VPWR
+ VPWR SLICE_16\[1\].RAM16.SLICE\[1\].RAM8.WORD\[4\].W.BYTE\[2\].B.GCLK sky130_fd_sc_hd__dlclkp_1
Xfill_30_7 VGND VPWR sky130_fd_sc_hd__tapvpwrvgnd_1
XSLICE_16\[1\].RAM16.SLICE\[0\].RAM8.WORD\[7\].W.BYTE\[0\].B.BIT\[6\].genblk1.STORAGE
+ DIBUF\[6\].X SLICE_16\[1\].RAM16.SLICE\[0\].RAM8.WORD\[7\].W.BYTE\[0\].B.GCLK VGND
+ VGND VPWR VPWR SLICE_16\[1\].RAM16.SLICE\[0\].RAM8.WORD\[7\].W.BYTE\[0\].B.Q_WIRE\[6\]
+ sky130_fd_sc_hd__dlxtp_1
XSLICE_16\[1\].RAM16.SLICE\[0\].RAM8.WORD\[1\].W.BYTE\[1\].B.BIT\[7\].genblk1.STORAGE
+ DIBUF\[15\].X SLICE_16\[1\].RAM16.SLICE\[0\].RAM8.WORD\[1\].W.BYTE\[1\].B.GCLK VGND
+ VGND VPWR VPWR SLICE_16\[1\].RAM16.SLICE\[0\].RAM8.WORD\[1\].W.BYTE\[1\].B.Q_WIRE\[7\]
+ sky130_fd_sc_hd__dlxtp_1
Xfill_16_5 VGND VPWR sky130_fd_sc_hd__tapvpwrvgnd_1
XSLICE_16\[0\].RAM16.SLICE\[0\].RAM8.WORD\[1\].W.BYTE\[2\].B.BIT\[6\].OBUF0 SLICE_16\[0\].RAM16.SLICE\[0\].RAM8.WORD\[1\].W.BYTE\[2\].B.Q_WIRE\[6\]
+ SLICE_16\[0\].RAM16.SLICE\[0\].RAM8.WORD\[1\].W.BYTE\[2\].B.SEL0_B VGND VGND VPWR
+ VPWR SLICE_16\[0\].RAM16.BYTE\[2\].FLOATBUF0\[22\].Z sky130_fd_sc_hd__ebufn_2
XSLICE_16\[1\].RAM16.SLICE\[1\].RAM8.WORD\[3\].W.BYTE\[2\].B.BIT\[3\].OBUF0 SLICE_16\[1\].RAM16.SLICE\[1\].RAM8.WORD\[3\].W.BYTE\[2\].B.Q_WIRE\[3\]
+ SLICE_16\[1\].RAM16.SLICE\[1\].RAM8.WORD\[3\].W.BYTE\[2\].B.SEL0_B VGND VGND VPWR
+ VPWR SLICE_16\[1\].RAM16.BYTE\[2\].FLOATBUF0\[19\].Z sky130_fd_sc_hd__ebufn_2
XSLICE_16\[0\].RAM16.SLICE\[0\].RAM8.WORD\[4\].W.BYTE\[3\].B.BIT\[4\].genblk1.STORAGE
+ DIBUF\[28\].X SLICE_16\[0\].RAM16.SLICE\[0\].RAM8.WORD\[4\].W.BYTE\[3\].B.GCLK VGND
+ VGND VPWR VPWR SLICE_16\[0\].RAM16.SLICE\[0\].RAM8.WORD\[4\].W.BYTE\[3\].B.Q_WIRE\[4\]
+ sky130_fd_sc_hd__dlxtp_1
XSLICE_16\[0\].RAM16.SLICE\[0\].RAM8.WORD\[2\].W.BYTE\[1\].B.BIT\[3\].genblk1.STORAGE
+ DIBUF\[11\].X SLICE_16\[0\].RAM16.SLICE\[0\].RAM8.WORD\[2\].W.BYTE\[1\].B.GCLK VGND
+ VGND VPWR VPWR SLICE_16\[0\].RAM16.SLICE\[0\].RAM8.WORD\[2\].W.BYTE\[1\].B.Q_WIRE\[3\]
+ sky130_fd_sc_hd__dlxtp_1
XSLICE_16\[1\].RAM16.SLICE\[0\].RAM8.WORD\[2\].W.CLKBUF SLICE_16\[1\].RAM16.SLICE\[0\].RAM8.CLKBUF.X
+ VGND VGND VPWR VPWR SLICE_16\[1\].RAM16.SLICE\[0\].RAM8.WORD\[2\].W.BYTE\[0\].B.CLK
+ sky130_fd_sc_hd__clkbuf_4
XSLICE_16\[0\].RAM16.SLICE\[1\].RAM8.WORD\[5\].W.BYTE\[1\].B.BIT\[4\].OBUF0 SLICE_16\[0\].RAM16.SLICE\[1\].RAM8.WORD\[5\].W.BYTE\[1\].B.Q_WIRE\[4\]
+ SLICE_16\[0\].RAM16.SLICE\[1\].RAM8.WORD\[5\].W.BYTE\[1\].B.SEL0_B VGND VGND VPWR
+ VPWR SLICE_16\[0\].RAM16.BYTE\[1\].FLOATBUF0\[12\].Z sky130_fd_sc_hd__ebufn_2
Xtap_33_26 VGND VPWR sky130_fd_sc_hd__tapvpwrvgnd_1
Xtap_33_15 VGND VPWR sky130_fd_sc_hd__tapvpwrvgnd_1
XDIBUF\[20\].__cell__ Di0[20] VGND VGND VPWR VPWR DIBUF\[20\].X sky130_fd_sc_hd__clkbuf_16
Xfill_21_69 VGND VPWR sky130_fd_sc_hd__tapvpwrvgnd_1
Xfill_21_58 VGND VGND VPWR VPWR sky130_fd_sc_hd__decap_12
Xfill_21_47 VGND VGND VPWR VPWR sky130_fd_sc_hd__decap_12
Xfill_21_36 VGND VPWR sky130_fd_sc_hd__tapvpwrvgnd_1
Xfill_21_25 VGND VGND VPWR VPWR sky130_fd_sc_hd__decap_12
Xfill_21_14 VGND VGND VPWR VPWR sky130_fd_sc_hd__decap_12
Xtap_4_30 VGND VPWR sky130_fd_sc_hd__tapvpwrvgnd_1
XSLICE_16\[0\].RAM16.SLICE\[0\].RAM8.WORD\[0\].W.BYTE\[0\].B.BIT\[3\].OBUF0 SLICE_16\[0\].RAM16.SLICE\[0\].RAM8.WORD\[0\].W.BYTE\[0\].B.Q_WIRE\[3\]
+ SLICE_16\[0\].RAM16.SLICE\[0\].RAM8.WORD\[0\].W.BYTE\[0\].B.SEL0_B VGND VGND VPWR
+ VPWR SLICE_16\[0\].RAM16.BYTE\[0\].FLOATBUF0\[3\].Z sky130_fd_sc_hd__ebufn_2
Xfill_46_99 VGND VPWR sky130_fd_sc_hd__tapvpwrvgnd_1
Xfill_46_88 VGND VGND VPWR VPWR sky130_fd_sc_hd__decap_12
Xfill_46_77 VGND VPWR sky130_fd_sc_hd__tapvpwrvgnd_1
Xfill_46_66 VGND VPWR sky130_fd_sc_hd__tapvpwrvgnd_1
Xfill_46_55 VGND VGND VPWR VPWR sky130_fd_sc_hd__decap_4
Xfill_46_44 VGND VGND VPWR VPWR sky130_fd_sc_hd__decap_4
Xfill_46_33 VGND VPWR sky130_fd_sc_hd__tapvpwrvgnd_1
Xfill_46_22 VGND VPWR sky130_fd_sc_hd__tapvpwrvgnd_1
Xfill_46_11 VGND VGND VPWR VPWR sky130_fd_sc_hd__decap_4
XSLICE_16\[1\].RAM16.SLICE\[1\].RAM8.WORD\[7\].W.BYTE\[0\].B.genblk1.CLKINV SLICE_16\[1\].RAM16.SLICE\[1\].RAM8.WORD\[7\].W.BYTE\[0\].B.CLK
+ VGND VGND VPWR VPWR SLICE_16\[1\].RAM16.SLICE\[1\].RAM8.WORD\[7\].W.BYTE\[0\].B.CLK_B
+ sky130_fd_sc_hd__inv_1
XSLICE_16\[1\].RAM16.SLICE\[1\].RAM8.WORD\[2\].W.BYTE\[0\].B.BIT\[0\].OBUF0 SLICE_16\[1\].RAM16.SLICE\[1\].RAM8.WORD\[2\].W.BYTE\[0\].B.Q_WIRE\[0\]
+ SLICE_16\[1\].RAM16.SLICE\[1\].RAM8.WORD\[2\].W.BYTE\[0\].B.SEL0_B VGND VGND VPWR
+ VPWR SLICE_16\[1\].RAM16.BYTE\[0\].FLOATBUF0\[0\].Z sky130_fd_sc_hd__ebufn_2
Xtap_0_0 VGND VPWR sky130_fd_sc_hd__tapvpwrvgnd_1
XSLICE_16\[0\].RAM16.SLICE\[0\].RAM8.WORD\[4\].W.BYTE\[3\].B.BIT\[6\].OBUF0 SLICE_16\[0\].RAM16.SLICE\[0\].RAM8.WORD\[4\].W.BYTE\[3\].B.Q_WIRE\[6\]
+ SLICE_16\[0\].RAM16.SLICE\[0\].RAM8.WORD\[4\].W.BYTE\[3\].B.SEL0_B VGND VGND VPWR
+ VPWR SLICE_16\[0\].RAM16.BYTE\[3\].FLOATBUF0\[30\].Z sky130_fd_sc_hd__ebufn_2
XSLICE_16\[1\].RAM16.SLICE\[1\].RAM8.WORD\[7\].W.BYTE\[2\].B.BIT\[1\].genblk1.STORAGE
+ DIBUF\[17\].X SLICE_16\[1\].RAM16.SLICE\[1\].RAM8.WORD\[7\].W.BYTE\[2\].B.GCLK VGND
+ VGND VPWR VPWR SLICE_16\[1\].RAM16.SLICE\[1\].RAM8.WORD\[7\].W.BYTE\[2\].B.Q_WIRE\[1\]
+ sky130_fd_sc_hd__dlxtp_1
XSLICE_16\[1\].RAM16.SLICE\[1\].RAM8.WORD\[6\].W.BYTE\[3\].B.BIT\[3\].OBUF0 SLICE_16\[1\].RAM16.SLICE\[1\].RAM8.WORD\[6\].W.BYTE\[3\].B.Q_WIRE\[3\]
+ SLICE_16\[1\].RAM16.SLICE\[1\].RAM8.WORD\[6\].W.BYTE\[3\].B.SEL0_B VGND VGND VPWR
+ VPWR SLICE_16\[1\].RAM16.BYTE\[3\].FLOATBUF0\[27\].Z sky130_fd_sc_hd__ebufn_2
XSLICE_16\[1\].RAM16.SLICE\[1\].RAM8.WORD\[1\].W.BYTE\[3\].B.BIT\[2\].genblk1.STORAGE
+ DIBUF\[26\].X SLICE_16\[1\].RAM16.SLICE\[1\].RAM8.WORD\[1\].W.BYTE\[3\].B.GCLK VGND
+ VGND VPWR VPWR SLICE_16\[1\].RAM16.SLICE\[1\].RAM8.WORD\[1\].W.BYTE\[3\].B.Q_WIRE\[2\]
+ sky130_fd_sc_hd__dlxtp_1
XSLICE_16\[1\].RAM16.SLICE\[1\].RAM8.WORD\[5\].W.BYTE\[0\].B.BIT\[0\].genblk1.STORAGE
+ DIBUF\[0\].X SLICE_16\[1\].RAM16.SLICE\[1\].RAM8.WORD\[5\].W.BYTE\[0\].B.GCLK VGND
+ VGND VPWR VPWR SLICE_16\[1\].RAM16.SLICE\[1\].RAM8.WORD\[5\].W.BYTE\[0\].B.Q_WIRE\[0\]
+ sky130_fd_sc_hd__dlxtp_1
XSLICE_16\[1\].RAM16.SLICE\[1\].RAM8.WORD\[1\].W.BYTE\[3\].B.DIODE_CLK SLICE_16\[1\].RAM16.SLICE\[1\].RAM8.WORD\[1\].W.BYTE\[0\].B.CLK
+ VGND VGND VPWR VPWR sky130_fd_sc_hd__diode_2
XSLICE_16\[1\].RAM16.SLICE\[0\].RAM8.WORD\[7\].W.BYTE\[2\].B.DIODE_CLK SLICE_16\[1\].RAM16.SLICE\[0\].RAM8.WORD\[7\].W.BYTE\[0\].B.CLK
+ VGND VGND VPWR VPWR sky130_fd_sc_hd__diode_2
XSLICE_16\[1\].RAM16.SLICE\[0\].RAM8.WORD\[1\].W.BYTE\[2\].B.BIT\[2\].OBUF0 SLICE_16\[1\].RAM16.SLICE\[0\].RAM8.WORD\[1\].W.BYTE\[2\].B.Q_WIRE\[2\]
+ SLICE_16\[1\].RAM16.SLICE\[0\].RAM8.WORD\[1\].W.BYTE\[2\].B.SEL0_B VGND VGND VPWR
+ VPWR SLICE_16\[1\].RAM16.BYTE\[2\].FLOATBUF0\[18\].Z sky130_fd_sc_hd__ebufn_2
Xfill_21_3 VGND VPWR sky130_fd_sc_hd__tapvpwrvgnd_1
Xfill_14_2 VGND VGND VPWR VPWR sky130_fd_sc_hd__decap_3
Xtap_9_19 VGND VPWR sky130_fd_sc_hd__tapvpwrvgnd_1
XSLICE_16\[0\].RAM16.SLICE\[0\].RAM8.WORD\[3\].W.BYTE\[1\].B.BIT\[3\].OBUF0 SLICE_16\[0\].RAM16.SLICE\[0\].RAM8.WORD\[3\].W.BYTE\[1\].B.Q_WIRE\[3\]
+ SLICE_16\[0\].RAM16.SLICE\[0\].RAM8.WORD\[3\].W.BYTE\[1\].B.SEL0_B VGND VGND VPWR
+ VPWR SLICE_16\[0\].RAM16.BYTE\[1\].FLOATBUF0\[11\].Z sky130_fd_sc_hd__ebufn_2
Xtap_36_9 VGND VPWR sky130_fd_sc_hd__tapvpwrvgnd_1
Xtap_29_8 VGND VPWR sky130_fd_sc_hd__tapvpwrvgnd_1
Xtap_28_26 VGND VPWR sky130_fd_sc_hd__tapvpwrvgnd_1
Xtap_28_15 VGND VPWR sky130_fd_sc_hd__tapvpwrvgnd_1
XSLICE_16\[1\].RAM16.SLICE\[0\].RAM8.WORD\[4\].W.BYTE\[2\].B.BIT\[7\].genblk1.STORAGE
+ DIBUF\[23\].X SLICE_16\[1\].RAM16.SLICE\[0\].RAM8.WORD\[4\].W.BYTE\[2\].B.GCLK VGND
+ VGND VPWR VPWR SLICE_16\[1\].RAM16.SLICE\[0\].RAM8.WORD\[4\].W.BYTE\[2\].B.Q_WIRE\[7\]
+ sky130_fd_sc_hd__dlxtp_1
XSLICE_16\[1\].RAM16.SLICE\[0\].RAM8.WORD\[2\].W.BYTE\[0\].B.BIT\[6\].genblk1.STORAGE
+ DIBUF\[6\].X SLICE_16\[1\].RAM16.SLICE\[0\].RAM8.WORD\[2\].W.BYTE\[0\].B.GCLK VGND
+ VGND VPWR VPWR SLICE_16\[1\].RAM16.SLICE\[0\].RAM8.WORD\[2\].W.BYTE\[0\].B.Q_WIRE\[6\]
+ sky130_fd_sc_hd__dlxtp_1
XSLICE_16\[0\].RAM16.SLICE\[1\].RAM8.WORD\[4\].W.BYTE\[2\].B.DIODE_CLK SLICE_16\[0\].RAM16.SLICE\[1\].RAM8.WORD\[4\].W.BYTE\[0\].B.CLK
+ VGND VGND VPWR VPWR sky130_fd_sc_hd__diode_2
XSLICE_16\[1\].RAM16.SLICE\[1\].RAM8.WORD\[5\].W.BYTE\[1\].B.BIT\[0\].OBUF0 SLICE_16\[1\].RAM16.SLICE\[1\].RAM8.WORD\[5\].W.BYTE\[1\].B.Q_WIRE\[0\]
+ SLICE_16\[1\].RAM16.SLICE\[1\].RAM8.WORD\[5\].W.BYTE\[1\].B.SEL0_B VGND VGND VPWR
+ VPWR SLICE_16\[1\].RAM16.BYTE\[1\].FLOATBUF0\[8\].Z sky130_fd_sc_hd__ebufn_2
XSLICE_16\[0\].RAM16.SLICE\[1\].RAM8.WORD\[4\].W.BYTE\[0\].B.BIT\[7\].genblk1.STORAGE
+ DIBUF\[7\].X SLICE_16\[0\].RAM16.SLICE\[1\].RAM8.WORD\[4\].W.BYTE\[0\].B.GCLK VGND
+ VGND VPWR VPWR SLICE_16\[0\].RAM16.SLICE\[1\].RAM8.WORD\[4\].W.BYTE\[0\].B.Q_WIRE\[7\]
+ sky130_fd_sc_hd__dlxtp_1
XSLICE_16\[0\].RAM16.SLICE\[0\].RAM8.WORD\[5\].W.BYTE\[2\].B.BIT\[3\].genblk1.STORAGE
+ DIBUF\[19\].X SLICE_16\[0\].RAM16.SLICE\[0\].RAM8.WORD\[5\].W.BYTE\[2\].B.GCLK VGND
+ VGND VPWR VPWR SLICE_16\[0\].RAM16.SLICE\[0\].RAM8.WORD\[5\].W.BYTE\[2\].B.Q_WIRE\[3\]
+ sky130_fd_sc_hd__dlxtp_1
XSLICE_16\[0\].RAM16.SLICE\[1\].RAM8.WORD\[7\].W.BYTE\[0\].B.BIT\[1\].OBUF0 SLICE_16\[0\].RAM16.SLICE\[1\].RAM8.WORD\[7\].W.BYTE\[0\].B.Q_WIRE\[1\]
+ SLICE_16\[0\].RAM16.SLICE\[1\].RAM8.WORD\[7\].W.BYTE\[0\].B.SEL0_B VGND VGND VPWR
+ VPWR SLICE_16\[0\].RAM16.BYTE\[0\].FLOATBUF0\[1\].Z sky130_fd_sc_hd__ebufn_2
XSLICE_16\[0\].RAM16.SLICE\[0\].RAM8.WORD\[3\].W.BYTE\[0\].B.BIT\[2\].genblk1.STORAGE
+ DIBUF\[2\].X SLICE_16\[0\].RAM16.SLICE\[0\].RAM8.WORD\[3\].W.BYTE\[0\].B.GCLK VGND
+ VGND VPWR VPWR SLICE_16\[0\].RAM16.SLICE\[0\].RAM8.WORD\[3\].W.BYTE\[0\].B.Q_WIRE\[2\]
+ sky130_fd_sc_hd__dlxtp_1
XSLICE_16\[1\].RAM16.SLICE\[0\].RAM8.WORD\[4\].W.BYTE\[3\].B.BIT\[2\].OBUF0 SLICE_16\[1\].RAM16.SLICE\[0\].RAM8.WORD\[4\].W.BYTE\[3\].B.Q_WIRE\[2\]
+ SLICE_16\[1\].RAM16.SLICE\[0\].RAM8.WORD\[4\].W.BYTE\[3\].B.SEL0_B VGND VGND VPWR
+ VPWR SLICE_16\[1\].RAM16.BYTE\[3\].FLOATBUF0\[26\].Z sky130_fd_sc_hd__ebufn_2
XSLICE_16\[1\].RAM16.SLICE\[1\].RAM8.DEC0.AND1 SLICE_16\[1\].RAM16.SLICE\[1\].RAM8.DEC0.A_buf\[2\]
+ SLICE_16\[1\].RAM16.SLICE\[1\].RAM8.DEC0.A_buf\[1\] SLICE_16\[1\].RAM16.SLICE\[1\].RAM8.DEC0.A_buf\[0\]
+ SLICE_16\[1\].RAM16.SLICE\[1\].RAM8.DEC0.EN_buf VGND VGND VPWR VPWR SLICE_16\[1\].RAM16.SLICE\[1\].RAM8.DEC0.SEL\[1\]
+ sky130_fd_sc_hd__and4bb_2
XSLICE_16\[1\].RAM16.SLICE\[0\].RAM8.WORD\[1\].W.BYTE\[0\].B.BIT\[7\].OBUF0 SLICE_16\[1\].RAM16.SLICE\[0\].RAM8.WORD\[1\].W.BYTE\[0\].B.Q_WIRE\[7\]
+ SLICE_16\[1\].RAM16.SLICE\[0\].RAM8.WORD\[1\].W.BYTE\[0\].B.SEL0_B VGND VGND VPWR
+ VPWR SLICE_16\[1\].RAM16.BYTE\[0\].FLOATBUF0\[7\].Z sky130_fd_sc_hd__ebufn_2
XDIBUF\[4\].__cell__ Di0[4] VGND VGND VPWR VPWR DIBUF\[4\].X sky130_fd_sc_hd__clkbuf_16
XSLICE_16\[0\].RAM16.SLICE\[0\].RAM8.WORD\[6\].W.BYTE\[2\].B.BIT\[3\].OBUF0 SLICE_16\[0\].RAM16.SLICE\[0\].RAM8.WORD\[6\].W.BYTE\[2\].B.Q_WIRE\[3\]
+ SLICE_16\[0\].RAM16.SLICE\[0\].RAM8.WORD\[6\].W.BYTE\[2\].B.SEL0_B VGND VGND VPWR
+ VPWR SLICE_16\[0\].RAM16.BYTE\[2\].FLOATBUF0\[19\].Z sky130_fd_sc_hd__ebufn_2
Xfill_22_90 VGND VPWR sky130_fd_sc_hd__tapvpwrvgnd_1
XDo0MUX.M\[1\].DIODE_A1MUX\[8\] Do0MUX.A1\[8\] VGND VGND VPWR VPWR sky130_fd_sc_hd__diode_2
Xtap_14_28 VGND VPWR sky130_fd_sc_hd__tapvpwrvgnd_1
Xtap_14_17 VGND VPWR sky130_fd_sc_hd__tapvpwrvgnd_1
XSLICE_16\[1\].RAM16.BYTE\[3\].FLOATBUF0\[28\].__cell__ SLICE_16\[1\].RAM16.BYTE\[3\].FLOATBUF0\[24\].A
+ SLICE_16\[1\].RAM16.BYTE\[3\].FLOATBUF0\[24\].TE_B VGND VGND VPWR VPWR SLICE_16\[1\].RAM16.BYTE\[3\].FLOATBUF0\[28\].Z
+ sky130_fd_sc_hd__ebufn_2
XSLICE_16\[1\].RAM16.SLICE\[1\].RAM8.WORD\[2\].W.BYTE\[2\].B.BIT\[1\].genblk1.STORAGE
+ DIBUF\[17\].X SLICE_16\[1\].RAM16.SLICE\[1\].RAM8.WORD\[2\].W.BYTE\[2\].B.GCLK VGND
+ VGND VPWR VPWR SLICE_16\[1\].RAM16.SLICE\[1\].RAM8.WORD\[2\].W.BYTE\[2\].B.Q_WIRE\[1\]
+ sky130_fd_sc_hd__dlxtp_1
Xtap_30_27 VGND VPWR sky130_fd_sc_hd__tapvpwrvgnd_1
Xtap_30_16 VGND VPWR sky130_fd_sc_hd__tapvpwrvgnd_1
Xtap_34_6 VGND VPWR sky130_fd_sc_hd__tapvpwrvgnd_1
XSLICE_16\[1\].RAM16.SLICE\[1\].RAM8.WORD\[0\].W.BYTE\[3\].B.CGAND SLICE_16\[1\].RAM16.SLICE\[1\].RAM8.WORD\[0\].W.BYTE\[0\].B.SEL0
+ SLICE_16\[1\].RAM16.SLICE\[1\].RAM8.WE0_buf\[3\] VGND VGND VPWR VPWR SLICE_16\[1\].RAM16.SLICE\[1\].RAM8.WORD\[0\].W.BYTE\[3\].B.WE0_WIRE
+ sky130_fd_sc_hd__and2_1
XSLICE_16\[1\].RAM16.SLICE\[1\].RAM8.WORD\[0\].W.BYTE\[0\].B.BIT\[0\].genblk1.STORAGE
+ DIBUF\[0\].X SLICE_16\[1\].RAM16.SLICE\[1\].RAM8.WORD\[0\].W.BYTE\[0\].B.GCLK VGND
+ VGND VPWR VPWR SLICE_16\[1\].RAM16.SLICE\[1\].RAM8.WORD\[0\].W.BYTE\[0\].B.Q_WIRE\[0\]
+ sky130_fd_sc_hd__dlxtp_1
Xtap_27_5 VGND VPWR sky130_fd_sc_hd__tapvpwrvgnd_1
Xtap_1_31 VGND VPWR sky130_fd_sc_hd__tapvpwrvgnd_1
Xtap_1_20 VGND VPWR sky130_fd_sc_hd__tapvpwrvgnd_1
Xfill_43_23 VGND VGND VPWR VPWR sky130_fd_sc_hd__decap_12
Xfill_43_12 VGND VPWR sky130_fd_sc_hd__tapvpwrvgnd_1
XSLICE_16\[1\].RAM16.SLICE\[0\].RAM8.WORD\[7\].W.BYTE\[3\].B.BIT\[7\].genblk1.STORAGE
+ DIBUF\[31\].X SLICE_16\[1\].RAM16.SLICE\[0\].RAM8.WORD\[7\].W.BYTE\[3\].B.GCLK VGND
+ VGND VPWR VPWR SLICE_16\[1\].RAM16.SLICE\[0\].RAM8.WORD\[7\].W.BYTE\[3\].B.Q_WIRE\[7\]
+ sky130_fd_sc_hd__dlxtp_1
XSLICE_16\[0\].RAM16.SLICE\[0\].RAM8.WORD\[5\].W.BYTE\[0\].B.BIT\[0\].OBUF0 SLICE_16\[0\].RAM16.SLICE\[0\].RAM8.WORD\[5\].W.BYTE\[0\].B.Q_WIRE\[0\]
+ SLICE_16\[0\].RAM16.SLICE\[0\].RAM8.WORD\[5\].W.BYTE\[0\].B.SEL0_B VGND VGND VPWR
+ VPWR SLICE_16\[0\].RAM16.BYTE\[0\].FLOATBUF0\[0\].Z sky130_fd_sc_hd__ebufn_2
Xfill_43_89 VGND VGND VPWR VPWR sky130_fd_sc_hd__decap_12
Xfill_43_78 VGND VPWR sky130_fd_sc_hd__tapvpwrvgnd_1
Xfill_43_67 VGND VGND VPWR VPWR sky130_fd_sc_hd__decap_12
Xfill_43_56 VGND VGND VPWR VPWR sky130_fd_sc_hd__decap_12
Xfill_43_45 VGND VPWR sky130_fd_sc_hd__tapvpwrvgnd_1
Xfill_43_34 VGND VGND VPWR VPWR sky130_fd_sc_hd__decap_12
XSLICE_16\[1\].RAM16.SLICE\[0\].RAM8.WORD\[5\].W.BYTE\[1\].B.BIT\[6\].genblk1.STORAGE
+ DIBUF\[14\].X SLICE_16\[1\].RAM16.SLICE\[0\].RAM8.WORD\[5\].W.BYTE\[1\].B.GCLK VGND
+ VGND VPWR VPWR SLICE_16\[1\].RAM16.SLICE\[0\].RAM8.WORD\[5\].W.BYTE\[1\].B.Q_WIRE\[6\]
+ sky130_fd_sc_hd__dlxtp_1
XSLICE_16\[1\].RAM16.SLICE\[0\].RAM8.WORD\[4\].W.BYTE\[1\].B.BIT\[7\].OBUF0 SLICE_16\[1\].RAM16.SLICE\[0\].RAM8.WORD\[4\].W.BYTE\[1\].B.Q_WIRE\[7\]
+ SLICE_16\[1\].RAM16.SLICE\[0\].RAM8.WORD\[4\].W.BYTE\[1\].B.SEL0_B VGND VGND VPWR
+ VPWR SLICE_16\[1\].RAM16.BYTE\[1\].FLOATBUF0\[15\].Z sky130_fd_sc_hd__ebufn_2
XSLICE_16\[0\].RAM16.Do0_REG.OUTREG_BYTE\[3\].DIODE\[6\] SLICE_16\[0\].RAM16.BYTE\[3\].FLOATBUF0\[30\].Z
+ VGND VGND VPWR VPWR sky130_fd_sc_hd__diode_2
XSLICE_16\[0\].RAM16.SLICE\[1\].RAM8.WORD\[1\].W.BYTE\[3\].B.BIT\[6\].OBUF0 SLICE_16\[0\].RAM16.SLICE\[1\].RAM8.WORD\[1\].W.BYTE\[3\].B.Q_WIRE\[6\]
+ SLICE_16\[0\].RAM16.SLICE\[1\].RAM8.WORD\[1\].W.BYTE\[3\].B.SEL0_B VGND VGND VPWR
+ VPWR SLICE_16\[0\].RAM16.BYTE\[3\].FLOATBUF0\[30\].Z sky130_fd_sc_hd__ebufn_2
XSLICE_16\[0\].RAM16.SLICE\[1\].RAM8.WORD\[7\].W.BYTE\[1\].B.BIT\[7\].genblk1.STORAGE
+ DIBUF\[15\].X SLICE_16\[0\].RAM16.SLICE\[1\].RAM8.WORD\[7\].W.BYTE\[1\].B.GCLK VGND
+ VGND VPWR VPWR SLICE_16\[0\].RAM16.SLICE\[1\].RAM8.WORD\[7\].W.BYTE\[1\].B.Q_WIRE\[7\]
+ sky130_fd_sc_hd__dlxtp_1
Xfill_45_103 VGND VGND VPWR VPWR sky130_fd_sc_hd__decap_6
XSLICE_16\[0\].RAM16.SLICE\[1\].RAM8.WORD\[3\].W.BYTE\[2\].B.genblk1.CG SLICE_16\[0\].RAM16.SLICE\[1\].RAM8.WORD\[3\].W.BYTE\[2\].B.CLK_B
+ SLICE_16\[0\].RAM16.SLICE\[1\].RAM8.WORD\[3\].W.BYTE\[2\].B.WE0_WIRE VGND VGND VPWR
+ VPWR SLICE_16\[0\].RAM16.SLICE\[1\].RAM8.WORD\[3\].W.BYTE\[2\].B.GCLK sky130_fd_sc_hd__dlclkp_1
XSLICE_16\[0\].RAM16.SLICE\[0\].RAM8.WORD\[0\].W.BYTE\[2\].B.BIT\[3\].genblk1.STORAGE
+ DIBUF\[19\].X SLICE_16\[0\].RAM16.SLICE\[0\].RAM8.WORD\[0\].W.BYTE\[2\].B.GCLK VGND
+ VGND VPWR VPWR SLICE_16\[0\].RAM16.SLICE\[0\].RAM8.WORD\[0\].W.BYTE\[2\].B.Q_WIRE\[3\]
+ sky130_fd_sc_hd__dlxtp_1
XSLICE_16\[0\].RAM16.SLICE\[0\].RAM8.WORD\[6\].W.BYTE\[1\].B.BIT\[2\].genblk1.STORAGE
+ DIBUF\[10\].X SLICE_16\[0\].RAM16.SLICE\[0\].RAM8.WORD\[6\].W.BYTE\[1\].B.GCLK VGND
+ VGND VPWR VPWR SLICE_16\[0\].RAM16.SLICE\[0\].RAM8.WORD\[6\].W.BYTE\[1\].B.Q_WIRE\[2\]
+ sky130_fd_sc_hd__dlxtp_1
XSLICE_16\[1\].RAM16.Do0_REG.Root_CLKBUF SLICE_16\[1\].RAM16.CLKBUF.X VGND VGND VPWR
+ VPWR SLICE_16\[1\].RAM16.Do0_REG.CLK_buf sky130_fd_sc_hd__clkbuf_4
XWEBUF\[0\].__cell__ WE0[0] VGND VGND VPWR VPWR SLICE_16\[0\].RAM16.WE0\[0\] sky130_fd_sc_hd__clkbuf_2
XSLICE_16\[0\].RAM16.BYTE\[1\].FLOATBUF0\[9\].__cell__ SLICE_16\[0\].RAM16.BYTE\[1\].FLOATBUF0\[10\].A
+ SLICE_16\[0\].RAM16.BYTE\[1\].FLOATBUF0\[10\].TE_B VGND VGND VPWR VPWR SLICE_16\[0\].RAM16.BYTE\[1\].FLOATBUF0\[9\].Z
+ sky130_fd_sc_hd__ebufn_2
XSLICE_16\[1\].RAM16.SLICE\[0\].RAM8.WORD\[4\].W.BYTE\[0\].B.CGAND SLICE_16\[1\].RAM16.SLICE\[0\].RAM8.WORD\[4\].W.BYTE\[0\].B.SEL0
+ SLICE_16\[1\].RAM16.SLICE\[0\].RAM8.WE0_buf\[0\] VGND VGND VPWR VPWR SLICE_16\[1\].RAM16.SLICE\[0\].RAM8.WORD\[4\].W.BYTE\[0\].B.WE0_WIRE
+ sky130_fd_sc_hd__and2_1
Xtap_25_27 VGND VPWR sky130_fd_sc_hd__tapvpwrvgnd_1
Xtap_25_16 VGND VPWR sky130_fd_sc_hd__tapvpwrvgnd_1
XSLICE_16\[0\].RAM16.SLICE\[1\].RAM8.WORD\[0\].W.BYTE\[1\].B.BIT\[3\].OBUF0 SLICE_16\[0\].RAM16.SLICE\[1\].RAM8.WORD\[0\].W.BYTE\[1\].B.Q_WIRE\[3\]
+ SLICE_16\[0\].RAM16.SLICE\[1\].RAM8.WORD\[0\].W.BYTE\[1\].B.SEL0_B VGND VGND VPWR
+ VPWR SLICE_16\[0\].RAM16.BYTE\[1\].FLOATBUF0\[11\].Z sky130_fd_sc_hd__ebufn_2
XSLICE_16\[1\].RAM16.SLICE\[0\].RAM8.WORD\[7\].W.BYTE\[2\].B.BIT\[7\].OBUF0 SLICE_16\[1\].RAM16.SLICE\[0\].RAM8.WORD\[7\].W.BYTE\[2\].B.Q_WIRE\[7\]
+ SLICE_16\[1\].RAM16.SLICE\[0\].RAM8.WORD\[7\].W.BYTE\[2\].B.SEL0_B VGND VGND VPWR
+ VPWR SLICE_16\[1\].RAM16.BYTE\[2\].FLOATBUF0\[23\].Z sky130_fd_sc_hd__ebufn_2
Xtap_32_3 VGND VPWR sky130_fd_sc_hd__tapvpwrvgnd_1
Xtap_25_2 VGND VPWR sky130_fd_sc_hd__tapvpwrvgnd_1
XSLICE_16\[1\].RAM16.SLICE\[1\].RAM8.WORD\[5\].W.BYTE\[3\].B.BIT\[1\].genblk1.STORAGE
+ DIBUF\[25\].X SLICE_16\[1\].RAM16.SLICE\[1\].RAM8.WORD\[5\].W.BYTE\[3\].B.GCLK VGND
+ VGND VPWR VPWR SLICE_16\[1\].RAM16.SLICE\[1\].RAM8.WORD\[5\].W.BYTE\[3\].B.Q_WIRE\[1\]
+ sky130_fd_sc_hd__dlxtp_1
XSLICE_16\[1\].RAM16.SLICE\[1\].RAM8.WORD\[0\].W.BYTE\[1\].B.genblk1.CG SLICE_16\[1\].RAM16.SLICE\[1\].RAM8.WORD\[0\].W.BYTE\[1\].B.CLK_B
+ SLICE_16\[1\].RAM16.SLICE\[1\].RAM8.WORD\[0\].W.BYTE\[1\].B.WE0_WIRE VGND VGND VPWR
+ VPWR SLICE_16\[1\].RAM16.SLICE\[1\].RAM8.WORD\[0\].W.BYTE\[1\].B.GCLK sky130_fd_sc_hd__dlclkp_1
Xtap_18_1 VGND VPWR sky130_fd_sc_hd__tapvpwrvgnd_1
XSLICE_16\[1\].RAM16.SLICE\[1\].RAM8.WORD\[3\].W.BYTE\[1\].B.BIT\[0\].genblk1.STORAGE
+ DIBUF\[8\].X SLICE_16\[1\].RAM16.SLICE\[1\].RAM8.WORD\[3\].W.BYTE\[1\].B.GCLK VGND
+ VGND VPWR VPWR SLICE_16\[1\].RAM16.SLICE\[1\].RAM8.WORD\[3\].W.BYTE\[1\].B.Q_WIRE\[0\]
+ sky130_fd_sc_hd__dlxtp_1
XSLICE_16\[1\].RAM16.SLICE\[1\].RAM8.WORD\[1\].W.BYTE\[3\].B.BIT\[2\].OBUF0 SLICE_16\[1\].RAM16.SLICE\[1\].RAM8.WORD\[1\].W.BYTE\[3\].B.Q_WIRE\[2\]
+ SLICE_16\[1\].RAM16.SLICE\[1\].RAM8.WORD\[1\].W.BYTE\[3\].B.SEL0_B VGND VGND VPWR
+ VPWR SLICE_16\[1\].RAM16.BYTE\[3\].FLOATBUF0\[26\].Z sky130_fd_sc_hd__ebufn_2
XSLICE_16\[0\].RAM16.Do0_REG.OUTREG_BYTE\[2\].Do_FF\[7\] SLICE_16\[0\].RAM16.Do0_REG.CLKBUF\[2\]
+ SLICE_16\[0\].RAM16.BYTE\[2\].FLOATBUF0\[23\].Z VGND VGND VPWR VPWR Do0MUX.A0\[23\]
+ sky130_fd_sc_hd__dfxtp_1
Xfill_46_5 VGND VPWR sky130_fd_sc_hd__tapvpwrvgnd_1
XSLICE_16\[1\].RAM16.SLICE\[0\].RAM8.WORD\[6\].W.BYTE\[0\].B.BIT\[4\].OBUF0 SLICE_16\[1\].RAM16.SLICE\[0\].RAM8.WORD\[6\].W.BYTE\[0\].B.Q_WIRE\[4\]
+ SLICE_16\[1\].RAM16.SLICE\[0\].RAM8.WORD\[6\].W.BYTE\[0\].B.SEL0_B VGND VGND VPWR
+ VPWR SLICE_16\[1\].RAM16.BYTE\[0\].FLOATBUF0\[4\].Z sky130_fd_sc_hd__ebufn_2
XSLICE_16\[0\].RAM16.SLICE\[1\].RAM8.WORD\[7\].W.CLKBUF SLICE_16\[0\].RAM16.SLICE\[1\].RAM8.CLKBUF.X
+ VGND VGND VPWR VPWR SLICE_16\[0\].RAM16.SLICE\[1\].RAM8.WORD\[7\].W.BYTE\[0\].B.CLK
+ sky130_fd_sc_hd__clkbuf_4
XSLICE_16\[0\].RAM16.SLICE\[1\].RAM8.DEC0.AND5 SLICE_16\[0\].RAM16.SLICE\[1\].RAM8.DEC0.A_buf\[1\]
+ SLICE_16\[0\].RAM16.SLICE\[1\].RAM8.DEC0.A_buf\[0\] SLICE_16\[0\].RAM16.SLICE\[1\].RAM8.DEC0.A_buf\[2\]
+ SLICE_16\[0\].RAM16.SLICE\[1\].RAM8.DEC0.EN_buf VGND VGND VPWR VPWR SLICE_16\[0\].RAM16.SLICE\[1\].RAM8.DEC0.SEL\[5\]
+ sky130_fd_sc_hd__and4b_2
XSLICE_16\[0\].RAM16.SLICE\[0\].RAM8.WORD\[6\].W.BYTE\[2\].B.CGAND SLICE_16\[0\].RAM16.SLICE\[0\].RAM8.WORD\[6\].W.BYTE\[0\].B.SEL0
+ SLICE_16\[0\].RAM16.SLICE\[0\].RAM8.WE0_buf\[2\] VGND VGND VPWR VPWR SLICE_16\[0\].RAM16.SLICE\[0\].RAM8.WORD\[6\].W.BYTE\[2\].B.WE0_WIRE
+ sky130_fd_sc_hd__and2_1
Xfill_39_4 VGND VGND VPWR VPWR sky130_fd_sc_hd__decap_12
XSLICE_16\[1\].RAM16.SLICE\[0\].RAM8.WORD\[2\].W.BYTE\[3\].B.BIT\[7\].genblk1.STORAGE
+ DIBUF\[31\].X SLICE_16\[1\].RAM16.SLICE\[0\].RAM8.WORD\[2\].W.BYTE\[3\].B.GCLK VGND
+ VGND VPWR VPWR SLICE_16\[1\].RAM16.SLICE\[0\].RAM8.WORD\[2\].W.BYTE\[3\].B.Q_WIRE\[7\]
+ sky130_fd_sc_hd__dlxtp_1
XSLICE_16\[0\].RAM16.SLICE\[1\].RAM8.WORD\[3\].W.BYTE\[2\].B.BIT\[3\].OBUF0 SLICE_16\[0\].RAM16.SLICE\[1\].RAM8.WORD\[3\].W.BYTE\[2\].B.Q_WIRE\[3\]
+ SLICE_16\[0\].RAM16.SLICE\[1\].RAM8.WORD\[3\].W.BYTE\[2\].B.SEL0_B VGND VGND VPWR
+ VPWR SLICE_16\[0\].RAM16.BYTE\[2\].FLOATBUF0\[19\].Z sky130_fd_sc_hd__ebufn_2
XSLICE_16\[1\].RAM16.SLICE\[0\].RAM8.WORD\[7\].W.BYTE\[0\].B.genblk1.CG SLICE_16\[1\].RAM16.SLICE\[0\].RAM8.WORD\[7\].W.BYTE\[0\].B.CLK_B
+ SLICE_16\[1\].RAM16.SLICE\[0\].RAM8.WORD\[7\].W.BYTE\[0\].B.WE0_WIRE VGND VGND VPWR
+ VPWR SLICE_16\[1\].RAM16.SLICE\[0\].RAM8.WORD\[7\].W.BYTE\[0\].B.GCLK sky130_fd_sc_hd__dlclkp_1
XSLICE_16\[1\].RAM16.SLICE\[0\].RAM8.WORD\[6\].W.BYTE\[0\].B.BIT\[5\].genblk1.STORAGE
+ DIBUF\[5\].X SLICE_16\[1\].RAM16.SLICE\[0\].RAM8.WORD\[6\].W.BYTE\[0\].B.GCLK VGND
+ VGND VPWR VPWR SLICE_16\[1\].RAM16.SLICE\[0\].RAM8.WORD\[6\].W.BYTE\[0\].B.Q_WIRE\[5\]
+ sky130_fd_sc_hd__dlxtp_1
XSLICE_16\[1\].RAM16.SLICE\[0\].RAM8.WORD\[0\].W.BYTE\[1\].B.BIT\[6\].genblk1.STORAGE
+ DIBUF\[14\].X SLICE_16\[1\].RAM16.SLICE\[0\].RAM8.WORD\[0\].W.BYTE\[1\].B.GCLK VGND
+ VGND VPWR VPWR SLICE_16\[1\].RAM16.SLICE\[0\].RAM8.WORD\[0\].W.BYTE\[1\].B.Q_WIRE\[6\]
+ sky130_fd_sc_hd__dlxtp_1
Xtap_11_18 VGND VPWR sky130_fd_sc_hd__tapvpwrvgnd_1
Xtap_11_29 VGND VPWR sky130_fd_sc_hd__tapvpwrvgnd_1
XSLICE_16\[0\].RAM16.SLICE\[0\].RAM8.WORD\[3\].W.BYTE\[3\].B.BIT\[3\].genblk1.STORAGE
+ DIBUF\[27\].X SLICE_16\[0\].RAM16.SLICE\[0\].RAM8.WORD\[3\].W.BYTE\[3\].B.GCLK VGND
+ VGND VPWR VPWR SLICE_16\[0\].RAM16.SLICE\[0\].RAM8.WORD\[3\].W.BYTE\[3\].B.Q_WIRE\[3\]
+ sky130_fd_sc_hd__dlxtp_1
XSLICE_16\[0\].RAM16.SLICE\[1\].RAM8.WORD\[2\].W.BYTE\[1\].B.BIT\[7\].genblk1.STORAGE
+ DIBUF\[15\].X SLICE_16\[0\].RAM16.SLICE\[1\].RAM8.WORD\[2\].W.BYTE\[1\].B.GCLK VGND
+ VGND VPWR VPWR SLICE_16\[0\].RAM16.SLICE\[1\].RAM8.WORD\[2\].W.BYTE\[1\].B.Q_WIRE\[7\]
+ sky130_fd_sc_hd__dlxtp_1
Xtap_36_26 VGND VPWR sky130_fd_sc_hd__tapvpwrvgnd_1
Xtap_36_15 VGND VPWR sky130_fd_sc_hd__tapvpwrvgnd_1
XSLICE_16\[0\].RAM16.SLICE\[0\].RAM8.WORD\[1\].W.BYTE\[1\].B.BIT\[2\].genblk1.STORAGE
+ DIBUF\[10\].X SLICE_16\[0\].RAM16.SLICE\[0\].RAM8.WORD\[1\].W.BYTE\[1\].B.GCLK VGND
+ VGND VPWR VPWR SLICE_16\[0\].RAM16.SLICE\[0\].RAM8.WORD\[1\].W.BYTE\[1\].B.Q_WIRE\[2\]
+ sky130_fd_sc_hd__dlxtp_1
Xtap_4_7 VGND VPWR sky130_fd_sc_hd__tapvpwrvgnd_1
XSLICE_16\[0\].RAM16.SLICE\[0\].RAM8.WORD\[7\].W.BYTE\[0\].B.BIT\[1\].genblk1.STORAGE
+ DIBUF\[1\].X SLICE_16\[0\].RAM16.SLICE\[0\].RAM8.WORD\[7\].W.BYTE\[0\].B.GCLK VGND
+ VGND VPWR VPWR SLICE_16\[0\].RAM16.SLICE\[0\].RAM8.WORD\[7\].W.BYTE\[0\].B.Q_WIRE\[1\]
+ sky130_fd_sc_hd__dlxtp_1
Xtap_11_8 VGND VPWR sky130_fd_sc_hd__tapvpwrvgnd_1
XDo0MUX.M\[2\].DIODE_A0MUX\[23\] Do0MUX.A0\[23\] VGND VGND VPWR VPWR sky130_fd_sc_hd__diode_2
Xfill_40_24 VGND VGND VPWR VPWR sky130_fd_sc_hd__decap_8
Xfill_40_13 VGND VGND VPWR VPWR sky130_fd_sc_hd__decap_12
Xtap_7_30 VGND VPWR sky130_fd_sc_hd__tapvpwrvgnd_1
XSLICE_16\[0\].RAM16.SLICE\[1\].RAM8.WORD\[2\].W.BYTE\[0\].B.BIT\[0\].OBUF0 SLICE_16\[0\].RAM16.SLICE\[1\].RAM8.WORD\[2\].W.BYTE\[0\].B.Q_WIRE\[0\]
+ SLICE_16\[0\].RAM16.SLICE\[1\].RAM8.WORD\[2\].W.BYTE\[0\].B.SEL0_B VGND VGND VPWR
+ VPWR SLICE_16\[0\].RAM16.BYTE\[0\].FLOATBUF0\[0\].Z sky130_fd_sc_hd__ebufn_2
XSLICE_16\[1\].RAM16.SLICE\[1\].RAM8.WORD\[1\].W.BYTE\[1\].B.BIT\[7\].OBUF0 SLICE_16\[1\].RAM16.SLICE\[1\].RAM8.WORD\[1\].W.BYTE\[1\].B.Q_WIRE\[7\]
+ SLICE_16\[1\].RAM16.SLICE\[1\].RAM8.WORD\[1\].W.BYTE\[1\].B.SEL0_B VGND VGND VPWR
+ VPWR SLICE_16\[1\].RAM16.BYTE\[1\].FLOATBUF0\[15\].Z sky130_fd_sc_hd__ebufn_2
Xtap_30_0 VGND VPWR sky130_fd_sc_hd__tapvpwrvgnd_1
XSLICE_16\[0\].RAM16.SLICE\[1\].RAM8.WORD\[7\].W.BYTE\[0\].B.genblk1.CLKINV SLICE_16\[0\].RAM16.SLICE\[1\].RAM8.WORD\[7\].W.BYTE\[0\].B.CLK
+ VGND VGND VPWR VPWR SLICE_16\[0\].RAM16.SLICE\[1\].RAM8.WORD\[7\].W.BYTE\[0\].B.CLK_B
+ sky130_fd_sc_hd__inv_1
XSLICE_16\[0\].RAM16.SLICE\[1\].RAM8.WORD\[6\].W.BYTE\[3\].B.BIT\[3\].OBUF0 SLICE_16\[0\].RAM16.SLICE\[1\].RAM8.WORD\[6\].W.BYTE\[3\].B.Q_WIRE\[3\]
+ SLICE_16\[0\].RAM16.SLICE\[1\].RAM8.WORD\[6\].W.BYTE\[3\].B.SEL0_B VGND VGND VPWR
+ VPWR SLICE_16\[0\].RAM16.BYTE\[3\].FLOATBUF0\[27\].Z sky130_fd_sc_hd__ebufn_2
Xfill_18_9 VGND VPWR sky130_fd_sc_hd__tapvpwrvgnd_1
XDo0MUX.M\[3\].DIODE_A0MUX\[27\] Do0MUX.A0\[27\] VGND VGND VPWR VPWR sky130_fd_sc_hd__diode_2
XSLICE_16\[1\].RAM16.Do0_REG.OUTREG_BYTE\[2\].DIODE\[2\] SLICE_16\[1\].RAM16.BYTE\[2\].FLOATBUF0\[18\].Z
+ VGND VGND VPWR VPWR sky130_fd_sc_hd__diode_2
XSLICE_16\[0\].RAM16.SLICE\[0\].RAM8.WORD\[1\].W.BYTE\[2\].B.BIT\[2\].OBUF0 SLICE_16\[0\].RAM16.SLICE\[0\].RAM8.WORD\[1\].W.BYTE\[2\].B.Q_WIRE\[2\]
+ SLICE_16\[0\].RAM16.SLICE\[0\].RAM8.WORD\[1\].W.BYTE\[2\].B.SEL0_B VGND VGND VPWR
+ VPWR SLICE_16\[0\].RAM16.BYTE\[2\].FLOATBUF0\[18\].Z sky130_fd_sc_hd__ebufn_2
Xfill_44_2 VGND VGND VPWR VPWR sky130_fd_sc_hd__decap_12
Xfill_37_1 VGND VGND VPWR VPWR sky130_fd_sc_hd__decap_3
XSLICE_16\[1\].RAM16.SLICE\[1\].RAM8.WORD\[6\].W.BYTE\[2\].B.BIT\[0\].genblk1.STORAGE
+ DIBUF\[16\].X SLICE_16\[1\].RAM16.SLICE\[1\].RAM8.WORD\[6\].W.BYTE\[2\].B.GCLK VGND
+ VGND VPWR VPWR SLICE_16\[1\].RAM16.SLICE\[1\].RAM8.WORD\[6\].W.BYTE\[2\].B.Q_WIRE\[0\]
+ sky130_fd_sc_hd__dlxtp_1
XSLICE_16\[1\].RAM16.SLICE\[1\].RAM8.WORD\[0\].W.BYTE\[3\].B.BIT\[1\].genblk1.STORAGE
+ DIBUF\[25\].X SLICE_16\[1\].RAM16.SLICE\[1\].RAM8.WORD\[0\].W.BYTE\[3\].B.GCLK VGND
+ VGND VPWR VPWR SLICE_16\[1\].RAM16.SLICE\[1\].RAM8.WORD\[0\].W.BYTE\[3\].B.Q_WIRE\[1\]
+ sky130_fd_sc_hd__dlxtp_1
XSLICE_16\[0\].RAM16.SLICE\[1\].RAM8.WORD\[7\].W.BYTE\[1\].B.CGAND SLICE_16\[0\].RAM16.SLICE\[1\].RAM8.WORD\[7\].W.BYTE\[0\].B.SEL0
+ SLICE_16\[0\].RAM16.SLICE\[1\].RAM8.WE0_buf\[1\] VGND VGND VPWR VPWR SLICE_16\[0\].RAM16.SLICE\[1\].RAM8.WORD\[7\].W.BYTE\[1\].B.WE0_WIRE
+ sky130_fd_sc_hd__and2_1
XDIBUF\[10\].__cell__ Di0[10] VGND VGND VPWR VPWR DIBUF\[10\].X sky130_fd_sc_hd__clkbuf_16
XSLICE_16\[0\].RAM16.SLICE\[1\].RAM8.WORD\[5\].W.BYTE\[1\].B.BIT\[0\].OBUF0 SLICE_16\[0\].RAM16.SLICE\[1\].RAM8.WORD\[5\].W.BYTE\[1\].B.Q_WIRE\[0\]
+ SLICE_16\[0\].RAM16.SLICE\[1\].RAM8.WORD\[5\].W.BYTE\[1\].B.SEL0_B VGND VGND VPWR
+ VPWR SLICE_16\[0\].RAM16.BYTE\[1\].FLOATBUF0\[8\].Z sky130_fd_sc_hd__ebufn_2
XSLICE_16\[1\].RAM16.SLICE\[1\].RAM8.WORD\[4\].W.BYTE\[2\].B.BIT\[7\].OBUF0 SLICE_16\[1\].RAM16.SLICE\[1\].RAM8.WORD\[4\].W.BYTE\[2\].B.Q_WIRE\[7\]
+ SLICE_16\[1\].RAM16.SLICE\[1\].RAM8.WORD\[4\].W.BYTE\[2\].B.SEL0_B VGND VGND VPWR
+ VPWR SLICE_16\[1\].RAM16.BYTE\[2\].FLOATBUF0\[23\].Z sky130_fd_sc_hd__ebufn_2
Xfill_19_14 VGND VGND VPWR VPWR sky130_fd_sc_hd__decap_12
XSLICE_16\[1\].RAM16.SLICE\[0\].RAM8.WORD\[3\].W.BYTE\[2\].B.BIT\[6\].genblk1.STORAGE
+ DIBUF\[22\].X SLICE_16\[1\].RAM16.SLICE\[0\].RAM8.WORD\[3\].W.BYTE\[2\].B.GCLK VGND
+ VGND VPWR VPWR SLICE_16\[1\].RAM16.SLICE\[0\].RAM8.WORD\[3\].W.BYTE\[2\].B.Q_WIRE\[6\]
+ sky130_fd_sc_hd__dlxtp_1
Xfill_19_69 VGND VPWR sky130_fd_sc_hd__tapvpwrvgnd_1
Xfill_19_58 VGND VGND VPWR VPWR sky130_fd_sc_hd__decap_12
Xfill_19_47 VGND VGND VPWR VPWR sky130_fd_sc_hd__decap_12
Xfill_19_36 VGND VPWR sky130_fd_sc_hd__tapvpwrvgnd_1
Xfill_19_25 VGND VGND VPWR VPWR sky130_fd_sc_hd__decap_12
Xtap_2_4 VGND VPWR sky130_fd_sc_hd__tapvpwrvgnd_1
XSLICE_16\[1\].RAM16.SLICE\[0\].RAM8.WORD\[1\].W.BYTE\[0\].B.BIT\[5\].genblk1.STORAGE
+ DIBUF\[5\].X SLICE_16\[1\].RAM16.SLICE\[0\].RAM8.WORD\[1\].W.BYTE\[0\].B.GCLK VGND
+ VGND VPWR VPWR SLICE_16\[1\].RAM16.SLICE\[0\].RAM8.WORD\[1\].W.BYTE\[0\].B.Q_WIRE\[5\]
+ sky130_fd_sc_hd__dlxtp_1
XSLICE_16\[0\].RAM16.SLICE\[1\].RAM8.WORD\[5\].W.BYTE\[2\].B.BIT\[7\].genblk1.STORAGE
+ DIBUF\[23\].X SLICE_16\[0\].RAM16.SLICE\[1\].RAM8.WORD\[5\].W.BYTE\[2\].B.GCLK VGND
+ VGND VPWR VPWR SLICE_16\[0\].RAM16.SLICE\[1\].RAM8.WORD\[5\].W.BYTE\[2\].B.Q_WIRE\[7\]
+ sky130_fd_sc_hd__dlxtp_1
XSLICE_16\[0\].RAM16.SLICE\[0\].RAM8.WORD\[4\].W.BYTE\[3\].B.BIT\[2\].OBUF0 SLICE_16\[0\].RAM16.SLICE\[0\].RAM8.WORD\[4\].W.BYTE\[3\].B.Q_WIRE\[2\]
+ SLICE_16\[0\].RAM16.SLICE\[0\].RAM8.WORD\[4\].W.BYTE\[3\].B.SEL0_B VGND VGND VPWR
+ VPWR SLICE_16\[0\].RAM16.BYTE\[3\].FLOATBUF0\[26\].Z sky130_fd_sc_hd__ebufn_2
XSLICE_16\[0\].RAM16.SLICE\[1\].RAM8.WORD\[3\].W.BYTE\[0\].B.BIT\[6\].genblk1.STORAGE
+ DIBUF\[6\].X SLICE_16\[0\].RAM16.SLICE\[1\].RAM8.WORD\[3\].W.BYTE\[0\].B.GCLK VGND
+ VGND VPWR VPWR SLICE_16\[0\].RAM16.SLICE\[1\].RAM8.WORD\[3\].W.BYTE\[0\].B.Q_WIRE\[6\]
+ sky130_fd_sc_hd__dlxtp_1
XSLICE_16\[0\].RAM16.SLICE\[0\].RAM8.WORD\[4\].W.BYTE\[2\].B.BIT\[2\].genblk1.STORAGE
+ DIBUF\[18\].X SLICE_16\[0\].RAM16.SLICE\[0\].RAM8.WORD\[4\].W.BYTE\[2\].B.GCLK VGND
+ VGND VPWR VPWR SLICE_16\[0\].RAM16.SLICE\[0\].RAM8.WORD\[4\].W.BYTE\[2\].B.Q_WIRE\[2\]
+ sky130_fd_sc_hd__dlxtp_1
XSLICE_16\[0\].RAM16.SLICE\[0\].RAM8.WORD\[2\].W.BYTE\[0\].B.BIT\[1\].genblk1.STORAGE
+ DIBUF\[1\].X SLICE_16\[0\].RAM16.SLICE\[0\].RAM8.WORD\[2\].W.BYTE\[0\].B.GCLK VGND
+ VGND VPWR VPWR SLICE_16\[0\].RAM16.SLICE\[0\].RAM8.WORD\[2\].W.BYTE\[0\].B.Q_WIRE\[1\]
+ sky130_fd_sc_hd__dlxtp_1
Xfill_30_8 VGND VGND VPWR VPWR sky130_fd_sc_hd__decap_6
Xfill_16_6 VGND VPWR sky130_fd_sc_hd__tapvpwrvgnd_1
XSLICE_16\[0\].RAM16.SLICE\[0\].RAM8.WORD\[1\].W.BYTE\[0\].B.BIT\[7\].OBUF0 SLICE_16\[0\].RAM16.SLICE\[0\].RAM8.WORD\[1\].W.BYTE\[0\].B.Q_WIRE\[7\]
+ SLICE_16\[0\].RAM16.SLICE\[0\].RAM8.WORD\[1\].W.BYTE\[0\].B.SEL0_B VGND VGND VPWR
+ VPWR SLICE_16\[0\].RAM16.BYTE\[0\].FLOATBUF0\[7\].Z sky130_fd_sc_hd__ebufn_2
XSLICE_16\[1\].RAM16.Do0_REG.OUTREG_BYTE\[1\].Do_FF\[3\] SLICE_16\[1\].RAM16.Do0_REG.CLKBUF\[1\]
+ SLICE_16\[1\].RAM16.BYTE\[1\].FLOATBUF0\[11\].Z VGND VGND VPWR VPWR Do0MUX.A1\[11\]
+ sky130_fd_sc_hd__dfxtp_1
XSLICE_16\[1\].RAM16.SLICE\[1\].RAM8.WORD\[3\].W.BYTE\[0\].B.BIT\[4\].OBUF0 SLICE_16\[1\].RAM16.SLICE\[1\].RAM8.WORD\[3\].W.BYTE\[0\].B.Q_WIRE\[4\]
+ SLICE_16\[1\].RAM16.SLICE\[1\].RAM8.WORD\[3\].W.BYTE\[0\].B.SEL0_B VGND VGND VPWR
+ VPWR SLICE_16\[1\].RAM16.BYTE\[0\].FLOATBUF0\[4\].Z sky130_fd_sc_hd__ebufn_2
XSLICE_16\[1\].RAM16.SLICE\[1\].RAM8.WORD\[7\].W.BYTE\[3\].B.BIT\[7\].OBUF0 SLICE_16\[1\].RAM16.SLICE\[1\].RAM8.WORD\[7\].W.BYTE\[3\].B.Q_WIRE\[7\]
+ SLICE_16\[1\].RAM16.SLICE\[1\].RAM8.WORD\[7\].W.BYTE\[3\].B.SEL0_B VGND VGND VPWR
+ VPWR SLICE_16\[1\].RAM16.BYTE\[3\].FLOATBUF0\[31\].Z sky130_fd_sc_hd__ebufn_2
Xtap_33_16 VGND VPWR sky130_fd_sc_hd__tapvpwrvgnd_1
Xtap_33_27 VGND VPWR sky130_fd_sc_hd__tapvpwrvgnd_1
XSLICE_16\[1\].RAM16.SLICE\[0\].RAM8.WORD\[2\].W.BYTE\[2\].B.BIT\[6\].OBUF0 SLICE_16\[1\].RAM16.SLICE\[0\].RAM8.WORD\[2\].W.BYTE\[2\].B.Q_WIRE\[6\]
+ SLICE_16\[1\].RAM16.SLICE\[0\].RAM8.WORD\[2\].W.BYTE\[2\].B.SEL0_B VGND VGND VPWR
+ VPWR SLICE_16\[1\].RAM16.BYTE\[2\].FLOATBUF0\[22\].Z sky130_fd_sc_hd__ebufn_2
XSLICE_16\[1\].RAM16.SLICE\[1\].RAM8.WORD\[1\].W.BYTE\[2\].B.BIT\[0\].genblk1.STORAGE
+ DIBUF\[16\].X SLICE_16\[1\].RAM16.SLICE\[1\].RAM8.WORD\[1\].W.BYTE\[2\].B.GCLK VGND
+ VGND VPWR VPWR SLICE_16\[1\].RAM16.SLICE\[1\].RAM8.WORD\[1\].W.BYTE\[2\].B.Q_WIRE\[0\]
+ sky130_fd_sc_hd__dlxtp_1
Xfill_21_59 VGND VGND VPWR VPWR sky130_fd_sc_hd__decap_12
Xfill_21_48 VGND VPWR sky130_fd_sc_hd__tapvpwrvgnd_1
Xfill_21_37 VGND VGND VPWR VPWR sky130_fd_sc_hd__decap_12
Xfill_21_26 VGND VGND VPWR VPWR sky130_fd_sc_hd__decap_12
Xfill_21_15 VGND VPWR sky130_fd_sc_hd__tapvpwrvgnd_1
XSLICE_16\[0\].RAM16.Do0_REG.OUTREG_BYTE\[3\].Do_FF\[0\] SLICE_16\[0\].RAM16.Do0_REG.CLKBUF\[3\]
+ SLICE_16\[0\].RAM16.BYTE\[3\].FLOATBUF0\[24\].Z VGND VGND VPWR VPWR Do0MUX.A0\[24\]
+ sky130_fd_sc_hd__dfxtp_1
Xtap_4_20 VGND VPWR sky130_fd_sc_hd__tapvpwrvgnd_1
Xtap_4_31 VGND VPWR sky130_fd_sc_hd__tapvpwrvgnd_1
Xfill_46_89 VGND VGND VPWR VPWR sky130_fd_sc_hd__decap_12
Xfill_46_78 VGND VPWR sky130_fd_sc_hd__tapvpwrvgnd_1
Xfill_46_67 VGND VGND VPWR VPWR sky130_fd_sc_hd__decap_4
Xfill_46_56 VGND VPWR sky130_fd_sc_hd__tapvpwrvgnd_1
Xfill_46_45 VGND VPWR sky130_fd_sc_hd__tapvpwrvgnd_1
Xfill_46_34 VGND VGND VPWR VPWR sky130_fd_sc_hd__decap_4
Xfill_46_23 VGND VGND VPWR VPWR sky130_fd_sc_hd__decap_4
Xfill_46_12 VGND VPWR sky130_fd_sc_hd__tapvpwrvgnd_1
Xtap_0_1 VGND VPWR sky130_fd_sc_hd__tapvpwrvgnd_1
XSLICE_16\[0\].RAM16.SLICE\[0\].RAM8.WORD\[2\].W.BYTE\[1\].B.CGAND SLICE_16\[0\].RAM16.SLICE\[0\].RAM8.WORD\[2\].W.BYTE\[0\].B.SEL0
+ SLICE_16\[0\].RAM16.SLICE\[0\].RAM8.WE0_buf\[1\] VGND VGND VPWR VPWR SLICE_16\[0\].RAM16.SLICE\[0\].RAM8.WORD\[2\].W.BYTE\[1\].B.WE0_WIRE
+ sky130_fd_sc_hd__and2_1
XSLICE_16\[0\].RAM16.SLICE\[0\].RAM8.WORD\[4\].W.BYTE\[1\].B.BIT\[7\].OBUF0 SLICE_16\[0\].RAM16.SLICE\[0\].RAM8.WORD\[4\].W.BYTE\[1\].B.Q_WIRE\[7\]
+ SLICE_16\[0\].RAM16.SLICE\[0\].RAM8.WORD\[4\].W.BYTE\[1\].B.SEL0_B VGND VGND VPWR
+ VPWR SLICE_16\[0\].RAM16.BYTE\[1\].FLOATBUF0\[15\].Z sky130_fd_sc_hd__ebufn_2
XSLICE_16\[1\].RAM16.SLICE\[1\].RAM8.WORD\[6\].W.BYTE\[1\].B.BIT\[4\].OBUF0 SLICE_16\[1\].RAM16.SLICE\[1\].RAM8.WORD\[6\].W.BYTE\[1\].B.Q_WIRE\[4\]
+ SLICE_16\[1\].RAM16.SLICE\[1\].RAM8.WORD\[6\].W.BYTE\[1\].B.SEL0_B VGND VGND VPWR
+ VPWR SLICE_16\[1\].RAM16.BYTE\[1\].FLOATBUF0\[12\].Z sky130_fd_sc_hd__ebufn_2
XSLICE_16\[1\].RAM16.SLICE\[0\].RAM8.WORD\[6\].W.BYTE\[3\].B.BIT\[6\].genblk1.STORAGE
+ DIBUF\[30\].X SLICE_16\[1\].RAM16.SLICE\[0\].RAM8.WORD\[6\].W.BYTE\[3\].B.GCLK VGND
+ VGND VPWR VPWR SLICE_16\[1\].RAM16.SLICE\[0\].RAM8.WORD\[6\].W.BYTE\[3\].B.Q_WIRE\[6\]
+ sky130_fd_sc_hd__dlxtp_1
XSLICE_16\[1\].RAM16.SLICE\[0\].RAM8.WORD\[4\].W.BYTE\[1\].B.BIT\[5\].genblk1.STORAGE
+ DIBUF\[13\].X SLICE_16\[1\].RAM16.SLICE\[0\].RAM8.WORD\[4\].W.BYTE\[1\].B.GCLK VGND
+ VGND VPWR VPWR SLICE_16\[1\].RAM16.SLICE\[0\].RAM8.WORD\[4\].W.BYTE\[1\].B.Q_WIRE\[5\]
+ sky130_fd_sc_hd__dlxtp_1
XSLICE_16\[0\].RAM16.WEBUF\[3\].__cell__ SLICE_16\[0\].RAM16.WE0\[3\] VGND VGND VPWR
+ VPWR SLICE_16\[0\].RAM16.SLICE\[0\].RAM8.WE0\[3\] sky130_fd_sc_hd__clkbuf_2
XSLICE_16\[0\].RAM16.SLICE\[0\].RAM8.WORD\[1\].W.BYTE\[0\].B.DIODE_CLK SLICE_16\[0\].RAM16.SLICE\[0\].RAM8.WORD\[1\].W.BYTE\[0\].B.CLK
+ VGND VGND VPWR VPWR sky130_fd_sc_hd__diode_2
XSLICE_16\[1\].RAM16.SLICE\[0\].RAM8.WORD\[1\].W.BYTE\[0\].B.BIT\[3\].OBUF0 SLICE_16\[1\].RAM16.SLICE\[0\].RAM8.WORD\[1\].W.BYTE\[0\].B.Q_WIRE\[3\]
+ SLICE_16\[1\].RAM16.SLICE\[0\].RAM8.WORD\[1\].W.BYTE\[0\].B.SEL0_B VGND VGND VPWR
+ VPWR SLICE_16\[1\].RAM16.BYTE\[0\].FLOATBUF0\[3\].Z sky130_fd_sc_hd__ebufn_2
Xfill_21_4 VGND VGND VPWR VPWR sky130_fd_sc_hd__decap_12
XSLICE_16\[0\].RAM16.SLICE\[1\].RAM8.WORD\[6\].W.BYTE\[1\].B.BIT\[6\].genblk1.STORAGE
+ DIBUF\[14\].X SLICE_16\[0\].RAM16.SLICE\[1\].RAM8.WORD\[6\].W.BYTE\[1\].B.GCLK VGND
+ VGND VPWR VPWR SLICE_16\[0\].RAM16.SLICE\[1\].RAM8.WORD\[6\].W.BYTE\[1\].B.Q_WIRE\[6\]
+ sky130_fd_sc_hd__dlxtp_1
XSLICE_16\[0\].RAM16.SLICE\[1\].RAM8.WORD\[0\].W.BYTE\[2\].B.BIT\[7\].genblk1.STORAGE
+ DIBUF\[23\].X SLICE_16\[0\].RAM16.SLICE\[1\].RAM8.WORD\[0\].W.BYTE\[2\].B.GCLK VGND
+ VGND VPWR VPWR SLICE_16\[0\].RAM16.SLICE\[1\].RAM8.WORD\[0\].W.BYTE\[2\].B.Q_WIRE\[7\]
+ sky130_fd_sc_hd__dlxtp_1
XSLICE_16\[1\].RAM16.SLICE\[0\].RAM8.WORD\[5\].W.BYTE\[3\].B.BIT\[6\].OBUF0 SLICE_16\[1\].RAM16.SLICE\[0\].RAM8.WORD\[5\].W.BYTE\[3\].B.Q_WIRE\[6\]
+ SLICE_16\[1\].RAM16.SLICE\[0\].RAM8.WORD\[5\].W.BYTE\[3\].B.SEL0_B VGND VGND VPWR
+ VPWR SLICE_16\[1\].RAM16.BYTE\[3\].FLOATBUF0\[30\].Z sky130_fd_sc_hd__ebufn_2
Xfill_14_3 VGND VPWR sky130_fd_sc_hd__tapvpwrvgnd_1
XSLICE_16\[0\].RAM16.SLICE\[0\].RAM8.WORD\[7\].W.BYTE\[3\].B.BIT\[2\].genblk1.STORAGE
+ DIBUF\[26\].X SLICE_16\[0\].RAM16.SLICE\[0\].RAM8.WORD\[7\].W.BYTE\[3\].B.GCLK VGND
+ VGND VPWR VPWR SLICE_16\[0\].RAM16.SLICE\[0\].RAM8.WORD\[7\].W.BYTE\[3\].B.Q_WIRE\[2\]
+ sky130_fd_sc_hd__dlxtp_1
XSLICE_16\[1\].RAM16.A0BUF\[1\].__cell__ A0BUF\[1\].X VGND VGND VPWR VPWR SLICE_16\[1\].RAM16.A0BUF\[1\].X
+ sky130_fd_sc_hd__clkbuf_2
XSLICE_16\[1\].RAM16.FBUFENBUF0\[2\].__cell__ DEC0.SEL\[1\] VGND VGND VPWR VPWR SLICE_16\[1\].RAM16.BYTE\[2\].FLOATBUF0\[16\].TE_B
+ sky130_fd_sc_hd__clkbuf_2
XSLICE_16\[0\].RAM16.SLICE\[0\].RAM8.WORD\[5\].W.BYTE\[1\].B.BIT\[1\].genblk1.STORAGE
+ DIBUF\[9\].X SLICE_16\[0\].RAM16.SLICE\[0\].RAM8.WORD\[5\].W.BYTE\[1\].B.GCLK VGND
+ VGND VPWR VPWR SLICE_16\[0\].RAM16.SLICE\[0\].RAM8.WORD\[5\].W.BYTE\[1\].B.Q_WIRE\[1\]
+ sky130_fd_sc_hd__dlxtp_1
Xtap_29_9 VGND VPWR sky130_fd_sc_hd__tapvpwrvgnd_1
Xtap_28_27 VGND VPWR sky130_fd_sc_hd__tapvpwrvgnd_1
Xtap_28_16 VGND VPWR sky130_fd_sc_hd__tapvpwrvgnd_1
XSLICE_16\[0\].RAM16.SLICE\[0\].RAM8.WORD\[6\].W.BYTE\[0\].B.genblk1.CG SLICE_16\[0\].RAM16.SLICE\[0\].RAM8.WORD\[6\].W.BYTE\[0\].B.CLK_B
+ SLICE_16\[0\].RAM16.SLICE\[0\].RAM8.WORD\[6\].W.BYTE\[0\].B.WE0_WIRE VGND VGND VPWR
+ VPWR SLICE_16\[0\].RAM16.SLICE\[0\].RAM8.WORD\[6\].W.BYTE\[0\].B.GCLK sky130_fd_sc_hd__dlclkp_1
XSLICE_16\[0\].RAM16.SLICE\[0\].RAM8.WORD\[7\].W.BYTE\[2\].B.BIT\[7\].OBUF0 SLICE_16\[0\].RAM16.SLICE\[0\].RAM8.WORD\[7\].W.BYTE\[2\].B.Q_WIRE\[7\]
+ SLICE_16\[0\].RAM16.SLICE\[0\].RAM8.WORD\[7\].W.BYTE\[2\].B.SEL0_B VGND VGND VPWR
+ VPWR SLICE_16\[0\].RAM16.BYTE\[2\].FLOATBUF0\[23\].Z sky130_fd_sc_hd__ebufn_2
XSLICE_16\[0\].RAM16.Do0_REG.OUTREG_BYTE\[0\].DIODE\[3\] SLICE_16\[0\].RAM16.BYTE\[0\].FLOATBUF0\[3\].Z
+ VGND VGND VPWR VPWR sky130_fd_sc_hd__diode_2
XSLICE_16\[1\].RAM16.SLICE\[0\].RAM8.WORD\[4\].W.BYTE\[1\].B.BIT\[3\].OBUF0 SLICE_16\[1\].RAM16.SLICE\[0\].RAM8.WORD\[4\].W.BYTE\[1\].B.Q_WIRE\[3\]
+ SLICE_16\[1\].RAM16.SLICE\[0\].RAM8.WORD\[4\].W.BYTE\[1\].B.SEL0_B VGND VGND VPWR
+ VPWR SLICE_16\[1\].RAM16.BYTE\[1\].FLOATBUF0\[11\].Z sky130_fd_sc_hd__ebufn_2
XSLICE_16\[0\].RAM16.SLICE\[1\].RAM8.WORD\[1\].W.BYTE\[3\].B.BIT\[2\].OBUF0 SLICE_16\[0\].RAM16.SLICE\[1\].RAM8.WORD\[1\].W.BYTE\[3\].B.Q_WIRE\[2\]
+ SLICE_16\[0\].RAM16.SLICE\[1\].RAM8.WORD\[1\].W.BYTE\[3\].B.SEL0_B VGND VGND VPWR
+ VPWR SLICE_16\[0\].RAM16.BYTE\[3\].FLOATBUF0\[26\].Z sky130_fd_sc_hd__ebufn_2
XSLICE_16\[1\].RAM16.SLICE\[1\].RAM8.WORD\[4\].W.BYTE\[3\].B.BIT\[0\].genblk1.STORAGE
+ DIBUF\[24\].X SLICE_16\[1\].RAM16.SLICE\[1\].RAM8.WORD\[4\].W.BYTE\[3\].B.GCLK VGND
+ VGND VPWR VPWR SLICE_16\[1\].RAM16.SLICE\[1\].RAM8.WORD\[4\].W.BYTE\[3\].B.Q_WIRE\[0\]
+ sky130_fd_sc_hd__dlxtp_1
XSLICE_16\[1\].RAM16.SLICE\[1\].RAM8.DEC0.AND2 SLICE_16\[1\].RAM16.SLICE\[1\].RAM8.DEC0.A_buf\[2\]
+ SLICE_16\[1\].RAM16.SLICE\[1\].RAM8.DEC0.A_buf\[0\] SLICE_16\[1\].RAM16.SLICE\[1\].RAM8.DEC0.A_buf\[1\]
+ SLICE_16\[1\].RAM16.SLICE\[1\].RAM8.DEC0.EN_buf VGND VGND VPWR VPWR SLICE_16\[1\].RAM16.SLICE\[1\].RAM8.DEC0.SEL\[2\]
+ sky130_fd_sc_hd__and4bb_2
Xfill_22_91 VGND VGND VPWR VPWR sky130_fd_sc_hd__decap_12
Xfill_22_80 VGND VGND VPWR VPWR sky130_fd_sc_hd__decap_12
XSLICE_16\[0\].RAM16.SLICE\[1\].RAM8.WORD\[3\].W.BYTE\[0\].B.CGAND SLICE_16\[0\].RAM16.SLICE\[1\].RAM8.WORD\[3\].W.BYTE\[0\].B.SEL0
+ SLICE_16\[0\].RAM16.SLICE\[1\].RAM8.WE0_buf\[0\] VGND VGND VPWR VPWR SLICE_16\[0\].RAM16.SLICE\[1\].RAM8.WORD\[3\].W.BYTE\[0\].B.WE0_WIRE
+ sky130_fd_sc_hd__and2_1
XSLICE_16\[0\].RAM16.SLICE\[0\].RAM8.WORD\[6\].W.BYTE\[0\].B.BIT\[4\].OBUF0 SLICE_16\[0\].RAM16.SLICE\[0\].RAM8.WORD\[6\].W.BYTE\[0\].B.Q_WIRE\[4\]
+ SLICE_16\[0\].RAM16.SLICE\[0\].RAM8.WORD\[6\].W.BYTE\[0\].B.SEL0_B VGND VGND VPWR
+ VPWR SLICE_16\[0\].RAM16.BYTE\[0\].FLOATBUF0\[4\].Z sky130_fd_sc_hd__ebufn_2
XSLICE_16\[0\].RAM16.BYTE\[0\].FLOATBUF0\[1\].__cell__ SLICE_16\[0\].RAM16.BYTE\[0\].FLOATBUF0\[0\].A
+ SLICE_16\[0\].RAM16.BYTE\[0\].FLOATBUF0\[0\].TE_B VGND VGND VPWR VPWR SLICE_16\[0\].RAM16.BYTE\[0\].FLOATBUF0\[1\].Z
+ sky130_fd_sc_hd__ebufn_2
Xtap_14_29 VGND VPWR sky130_fd_sc_hd__tapvpwrvgnd_1
Xtap_14_18 VGND VPWR sky130_fd_sc_hd__tapvpwrvgnd_1
Xfill_12_0 VGND VPWR sky130_fd_sc_hd__tapvpwrvgnd_1
Xtap_30_28 VGND VPWR sky130_fd_sc_hd__tapvpwrvgnd_1
XSLICE_16\[1\].RAM16.SLICE\[0\].RAM8.WORD\[7\].W.BYTE\[2\].B.BIT\[5\].genblk1.STORAGE
+ DIBUF\[21\].X SLICE_16\[1\].RAM16.SLICE\[0\].RAM8.WORD\[7\].W.BYTE\[2\].B.GCLK VGND
+ VGND VPWR VPWR SLICE_16\[1\].RAM16.SLICE\[0\].RAM8.WORD\[7\].W.BYTE\[2\].B.Q_WIRE\[5\]
+ sky130_fd_sc_hd__dlxtp_1
Xtap_30_17 VGND VPWR sky130_fd_sc_hd__tapvpwrvgnd_1
XSLICE_16\[1\].RAM16.SLICE\[0\].RAM8.WORD\[1\].W.BYTE\[3\].B.BIT\[6\].genblk1.STORAGE
+ DIBUF\[30\].X SLICE_16\[1\].RAM16.SLICE\[0\].RAM8.WORD\[1\].W.BYTE\[3\].B.GCLK VGND
+ VGND VPWR VPWR SLICE_16\[1\].RAM16.SLICE\[0\].RAM8.WORD\[1\].W.BYTE\[3\].B.Q_WIRE\[6\]
+ sky130_fd_sc_hd__dlxtp_1
XSLICE_16\[0\].RAM16.SLICE\[0\].RAM8.WORD\[4\].W.BYTE\[3\].B.DIODE_CLK SLICE_16\[0\].RAM16.SLICE\[0\].RAM8.WORD\[4\].W.BYTE\[0\].B.CLK
+ VGND VGND VPWR VPWR sky130_fd_sc_hd__diode_2
Xtap_34_7 VGND VPWR sky130_fd_sc_hd__tapvpwrvgnd_1
XSLICE_16\[1\].RAM16.SLICE\[1\].RAM8.WORD\[0\].W.BYTE\[1\].B.DIODE_CLK SLICE_16\[1\].RAM16.SLICE\[1\].RAM8.WORD\[0\].W.BYTE\[0\].B.CLK
+ VGND VGND VPWR VPWR sky130_fd_sc_hd__diode_2
XSLICE_16\[1\].RAM16.SLICE\[0\].RAM8.WORD\[6\].W.BYTE\[0\].B.DIODE_CLK SLICE_16\[1\].RAM16.SLICE\[0\].RAM8.WORD\[6\].W.BYTE\[0\].B.CLK
+ VGND VGND VPWR VPWR sky130_fd_sc_hd__diode_2
XSLICE_16\[1\].RAM16.SLICE\[0\].RAM8.WORD\[5\].W.BYTE\[0\].B.BIT\[4\].genblk1.STORAGE
+ DIBUF\[4\].X SLICE_16\[1\].RAM16.SLICE\[0\].RAM8.WORD\[5\].W.BYTE\[0\].B.GCLK VGND
+ VGND VPWR VPWR SLICE_16\[1\].RAM16.SLICE\[0\].RAM8.WORD\[5\].W.BYTE\[0\].B.Q_WIRE\[4\]
+ sky130_fd_sc_hd__dlxtp_1
Xtap_27_6 VGND VPWR sky130_fd_sc_hd__tapvpwrvgnd_1
XSLICE_16\[0\].RAM16.SLICE\[1\].RAM8.WORD\[3\].W.BYTE\[3\].B.BIT\[7\].genblk1.STORAGE
+ DIBUF\[31\].X SLICE_16\[0\].RAM16.SLICE\[1\].RAM8.WORD\[3\].W.BYTE\[3\].B.GCLK VGND
+ VGND VPWR VPWR SLICE_16\[0\].RAM16.SLICE\[1\].RAM8.WORD\[3\].W.BYTE\[3\].B.Q_WIRE\[7\]
+ sky130_fd_sc_hd__dlxtp_1
XSLICE_16\[1\].RAM16.SLICE\[0\].RAM8.WORD\[7\].W.BYTE\[2\].B.BIT\[3\].OBUF0 SLICE_16\[1\].RAM16.SLICE\[0\].RAM8.WORD\[7\].W.BYTE\[2\].B.Q_WIRE\[3\]
+ SLICE_16\[1\].RAM16.SLICE\[0\].RAM8.WORD\[7\].W.BYTE\[2\].B.SEL0_B VGND VGND VPWR
+ VPWR SLICE_16\[1\].RAM16.BYTE\[2\].FLOATBUF0\[19\].Z sky130_fd_sc_hd__ebufn_2
XSLICE_16\[0\].RAM16.SLICE\[1\].RAM8.WORD\[7\].W.BYTE\[0\].B.BIT\[5\].genblk1.STORAGE
+ DIBUF\[5\].X SLICE_16\[0\].RAM16.SLICE\[1\].RAM8.WORD\[7\].W.BYTE\[0\].B.GCLK VGND
+ VGND VPWR VPWR SLICE_16\[0\].RAM16.SLICE\[1\].RAM8.WORD\[7\].W.BYTE\[0\].B.Q_WIRE\[5\]
+ sky130_fd_sc_hd__dlxtp_1
Xtap_1_32 VGND VPWR sky130_fd_sc_hd__tapvpwrvgnd_1
Xtap_1_21 VGND VPWR sky130_fd_sc_hd__tapvpwrvgnd_1
Xtap_1_10 VGND VPWR sky130_fd_sc_hd__tapvpwrvgnd_1
XSLICE_16\[0\].RAM16.SLICE\[1\].RAM8.WORD\[1\].W.BYTE\[1\].B.BIT\[6\].genblk1.STORAGE
+ DIBUF\[14\].X SLICE_16\[0\].RAM16.SLICE\[1\].RAM8.WORD\[1\].W.BYTE\[1\].B.GCLK VGND
+ VGND VPWR VPWR SLICE_16\[0\].RAM16.SLICE\[1\].RAM8.WORD\[1\].W.BYTE\[1\].B.Q_WIRE\[6\]
+ sky130_fd_sc_hd__dlxtp_1
Xfill_43_57 VGND VPWR sky130_fd_sc_hd__tapvpwrvgnd_1
Xfill_43_46 VGND VGND VPWR VPWR sky130_fd_sc_hd__decap_12
Xfill_43_35 VGND VGND VPWR VPWR sky130_fd_sc_hd__decap_12
Xfill_43_24 VGND VPWR sky130_fd_sc_hd__tapvpwrvgnd_1
Xfill_43_13 VGND VGND VPWR VPWR sky130_fd_sc_hd__decap_12
XSLICE_16\[0\].RAM16.SLICE\[0\].RAM8.WORD\[2\].W.BYTE\[3\].B.BIT\[2\].genblk1.STORAGE
+ DIBUF\[26\].X SLICE_16\[0\].RAM16.SLICE\[0\].RAM8.WORD\[2\].W.BYTE\[3\].B.GCLK VGND
+ VGND VPWR VPWR SLICE_16\[0\].RAM16.SLICE\[0\].RAM8.WORD\[2\].W.BYTE\[3\].B.Q_WIRE\[2\]
+ sky130_fd_sc_hd__dlxtp_1
XSLICE_16\[0\].RAM16.SLICE\[0\].RAM8.WORD\[6\].W.BYTE\[0\].B.BIT\[0\].genblk1.STORAGE
+ DIBUF\[0\].X SLICE_16\[0\].RAM16.SLICE\[0\].RAM8.WORD\[6\].W.BYTE\[0\].B.GCLK VGND
+ VGND VPWR VPWR SLICE_16\[0\].RAM16.SLICE\[0\].RAM8.WORD\[6\].W.BYTE\[0\].B.Q_WIRE\[0\]
+ sky130_fd_sc_hd__dlxtp_1
XDo0MUX.M\[0\].DIODE_A0MUX\[5\] Do0MUX.A0\[5\] VGND VGND VPWR VPWR sky130_fd_sc_hd__diode_2
Xfill_43_79 VGND VGND VPWR VPWR sky130_fd_sc_hd__decap_12
Xfill_43_68 VGND VGND VPWR VPWR sky130_fd_sc_hd__decap_12
XSLICE_16\[0\].RAM16.SLICE\[1\].RAM8.WORD\[3\].W.BYTE\[0\].B.DIODE_CLK SLICE_16\[0\].RAM16.SLICE\[1\].RAM8.WORD\[3\].W.BYTE\[0\].B.CLK
+ VGND VGND VPWR VPWR sky130_fd_sc_hd__diode_2
XSLICE_16\[0\].RAM16.SLICE\[0\].RAM8.WORD\[0\].W.BYTE\[1\].B.BIT\[1\].genblk1.STORAGE
+ DIBUF\[9\].X SLICE_16\[0\].RAM16.SLICE\[0\].RAM8.WORD\[0\].W.BYTE\[1\].B.GCLK VGND
+ VGND VPWR VPWR SLICE_16\[0\].RAM16.SLICE\[0\].RAM8.WORD\[0\].W.BYTE\[1\].B.Q_WIRE\[1\]
+ sky130_fd_sc_hd__dlxtp_1
XSLICE_16\[0\].RAM16.SLICE\[1\].RAM8.WORD\[1\].W.BYTE\[1\].B.BIT\[7\].OBUF0 SLICE_16\[0\].RAM16.SLICE\[1\].RAM8.WORD\[1\].W.BYTE\[1\].B.Q_WIRE\[7\]
+ SLICE_16\[0\].RAM16.SLICE\[1\].RAM8.WORD\[1\].W.BYTE\[1\].B.SEL0_B VGND VGND VPWR
+ VPWR SLICE_16\[0\].RAM16.BYTE\[1\].FLOATBUF0\[15\].Z sky130_fd_sc_hd__ebufn_2
XSLICE_16\[1\].RAM16.SLICE\[0\].RAM8.WORD\[6\].W.BYTE\[0\].B.BIT\[0\].OBUF0 SLICE_16\[1\].RAM16.SLICE\[0\].RAM8.WORD\[6\].W.BYTE\[0\].B.Q_WIRE\[0\]
+ SLICE_16\[1\].RAM16.SLICE\[0\].RAM8.WORD\[6\].W.BYTE\[0\].B.SEL0_B VGND VGND VPWR
+ VPWR SLICE_16\[1\].RAM16.BYTE\[0\].FLOATBUF0\[0\].Z sky130_fd_sc_hd__ebufn_2
XSLICE_16\[1\].RAM16.SLICE\[1\].RAM8.WORD\[2\].W.BYTE\[3\].B.BIT\[6\].OBUF0 SLICE_16\[1\].RAM16.SLICE\[1\].RAM8.WORD\[2\].W.BYTE\[3\].B.Q_WIRE\[6\]
+ SLICE_16\[1\].RAM16.SLICE\[1\].RAM8.WORD\[2\].W.BYTE\[3\].B.SEL0_B VGND VGND VPWR
+ VPWR SLICE_16\[1\].RAM16.BYTE\[3\].FLOATBUF0\[30\].Z sky130_fd_sc_hd__ebufn_2
Xtap_25_28 VGND VPWR sky130_fd_sc_hd__tapvpwrvgnd_1
Xtap_25_17 VGND VPWR sky130_fd_sc_hd__tapvpwrvgnd_1
XSLICE_16\[0\].RAM16.SLICE\[1\].RAM8.WORD\[4\].W.BYTE\[2\].B.BIT\[7\].OBUF0 SLICE_16\[0\].RAM16.SLICE\[1\].RAM8.WORD\[4\].W.BYTE\[2\].B.Q_WIRE\[7\]
+ SLICE_16\[0\].RAM16.SLICE\[1\].RAM8.WORD\[4\].W.BYTE\[2\].B.SEL0_B VGND VGND VPWR
+ VPWR SLICE_16\[0\].RAM16.BYTE\[2\].FLOATBUF0\[23\].Z sky130_fd_sc_hd__ebufn_2
Xtap_32_4 VGND VPWR sky130_fd_sc_hd__tapvpwrvgnd_1
XSLICE_16\[1\].RAM16.SLICE\[0\].RAM8.WORD\[7\].W.BYTE\[3\].B.SEL0INV SLICE_16\[1\].RAM16.SLICE\[0\].RAM8.WORD\[7\].W.BYTE\[0\].B.SEL0
+ VGND VGND VPWR VPWR SLICE_16\[1\].RAM16.SLICE\[0\].RAM8.WORD\[7\].W.BYTE\[3\].B.SEL0_B
+ sky130_fd_sc_hd__inv_1
Xtap_25_3 VGND VPWR sky130_fd_sc_hd__tapvpwrvgnd_1
Xtap_18_2 VGND VPWR sky130_fd_sc_hd__tapvpwrvgnd_1
XSLICE_16\[1\].RAM16.TIE0\[3\].__cell__ VGND VGND VPWR VPWR SLICE_16\[1\].RAM16.TIE0\[3\].__cell__/HI
+ SLICE_16\[1\].RAM16.BYTE\[3\].FLOATBUF0\[24\].A sky130_fd_sc_hd__conb_1
XSLICE_16\[1\].RAM16.SLICE\[1\].RAM8.WORD\[1\].W.BYTE\[1\].B.BIT\[3\].OBUF0 SLICE_16\[1\].RAM16.SLICE\[1\].RAM8.WORD\[1\].W.BYTE\[1\].B.Q_WIRE\[3\]
+ SLICE_16\[1\].RAM16.SLICE\[1\].RAM8.WORD\[1\].W.BYTE\[1\].B.SEL0_B VGND VGND VPWR
+ VPWR SLICE_16\[1\].RAM16.BYTE\[1\].FLOATBUF0\[11\].Z sky130_fd_sc_hd__ebufn_2
XSLICE_16\[1\].RAM16.SLICE\[0\].RAM8.WORD\[2\].W.BYTE\[2\].B.BIT\[5\].genblk1.STORAGE
+ DIBUF\[21\].X SLICE_16\[1\].RAM16.SLICE\[0\].RAM8.WORD\[2\].W.BYTE\[2\].B.GCLK VGND
+ VGND VPWR VPWR SLICE_16\[1\].RAM16.SLICE\[0\].RAM8.WORD\[2\].W.BYTE\[2\].B.Q_WIRE\[5\]
+ sky130_fd_sc_hd__dlxtp_1
XSLICE_16\[1\].RAM16.BYTE\[1\].FLOATBUF0\[11\].__cell__ SLICE_16\[1\].RAM16.BYTE\[1\].FLOATBUF0\[10\].A
+ SLICE_16\[1\].RAM16.BYTE\[1\].FLOATBUF0\[10\].TE_B VGND VGND VPWR VPWR SLICE_16\[1\].RAM16.BYTE\[1\].FLOATBUF0\[11\].Z
+ sky130_fd_sc_hd__ebufn_2
XSLICE_16\[1\].RAM16.SLICE\[0\].RAM8.WORD\[0\].W.BYTE\[0\].B.BIT\[4\].genblk1.STORAGE
+ DIBUF\[4\].X SLICE_16\[1\].RAM16.SLICE\[0\].RAM8.WORD\[0\].W.BYTE\[0\].B.GCLK VGND
+ VGND VPWR VPWR SLICE_16\[1\].RAM16.SLICE\[0\].RAM8.WORD\[0\].W.BYTE\[0\].B.Q_WIRE\[4\]
+ sky130_fd_sc_hd__dlxtp_1
XSLICE_16\[0\].RAM16.SLICE\[1\].RAM8.WORD\[4\].W.BYTE\[2\].B.BIT\[6\].genblk1.STORAGE
+ DIBUF\[22\].X SLICE_16\[0\].RAM16.SLICE\[1\].RAM8.WORD\[4\].W.BYTE\[2\].B.GCLK VGND
+ VGND VPWR VPWR SLICE_16\[0\].RAM16.SLICE\[1\].RAM8.WORD\[4\].W.BYTE\[2\].B.Q_WIRE\[6\]
+ sky130_fd_sc_hd__dlxtp_1
XDo0MUX.M\[1\].DIODE_A0MUX\[12\] Do0MUX.A0\[12\] VGND VGND VPWR VPWR sky130_fd_sc_hd__diode_2
Xfill_46_6 VGND VGND VPWR VPWR sky130_fd_sc_hd__decap_4
XSLICE_16\[0\].RAM16.SLICE\[1\].RAM8.DEC0.AND6 SLICE_16\[0\].RAM16.SLICE\[1\].RAM8.DEC0.A_buf\[0\]
+ SLICE_16\[0\].RAM16.SLICE\[1\].RAM8.DEC0.A_buf\[1\] SLICE_16\[0\].RAM16.SLICE\[1\].RAM8.DEC0.A_buf\[2\]
+ SLICE_16\[0\].RAM16.SLICE\[1\].RAM8.DEC0.EN_buf VGND VGND VPWR VPWR SLICE_16\[0\].RAM16.SLICE\[1\].RAM8.DEC0.SEL\[6\]
+ sky130_fd_sc_hd__and4b_2
XSLICE_16\[0\].RAM16.SLICE\[0\].RAM8.WORD\[3\].W.BYTE\[2\].B.BIT\[1\].genblk1.STORAGE
+ DIBUF\[17\].X SLICE_16\[0\].RAM16.SLICE\[0\].RAM8.WORD\[3\].W.BYTE\[2\].B.GCLK VGND
+ VGND VPWR VPWR SLICE_16\[0\].RAM16.SLICE\[0\].RAM8.WORD\[3\].W.BYTE\[2\].B.Q_WIRE\[1\]
+ sky130_fd_sc_hd__dlxtp_1
XSLICE_16\[0\].RAM16.SLICE\[1\].RAM8.WORD\[2\].W.BYTE\[0\].B.BIT\[5\].genblk1.STORAGE
+ DIBUF\[5\].X SLICE_16\[0\].RAM16.SLICE\[1\].RAM8.WORD\[2\].W.BYTE\[0\].B.GCLK VGND
+ VGND VPWR VPWR SLICE_16\[0\].RAM16.SLICE\[1\].RAM8.WORD\[2\].W.BYTE\[0\].B.Q_WIRE\[5\]
+ sky130_fd_sc_hd__dlxtp_1
Xfill_39_5 VGND VGND VPWR VPWR sky130_fd_sc_hd__decap_12
XSLICE_16\[0\].RAM16.SLICE\[1\].RAM8.WORD\[6\].W.BYTE\[3\].B.DIODE_CLK SLICE_16\[0\].RAM16.SLICE\[1\].RAM8.WORD\[6\].W.BYTE\[0\].B.CLK
+ VGND VGND VPWR VPWR sky130_fd_sc_hd__diode_2
XSLICE_16\[0\].RAM16.SLICE\[1\].RAM8.WORD\[3\].W.BYTE\[0\].B.BIT\[4\].OBUF0 SLICE_16\[0\].RAM16.SLICE\[1\].RAM8.WORD\[3\].W.BYTE\[0\].B.Q_WIRE\[4\]
+ SLICE_16\[0\].RAM16.SLICE\[1\].RAM8.WORD\[3\].W.BYTE\[0\].B.SEL0_B VGND VGND VPWR
+ VPWR SLICE_16\[0\].RAM16.BYTE\[0\].FLOATBUF0\[4\].Z sky130_fd_sc_hd__ebufn_2
XSLICE_16\[0\].RAM16.SLICE\[0\].RAM8.WORD\[1\].W.BYTE\[0\].B.BIT\[0\].genblk1.STORAGE
+ DIBUF\[0\].X SLICE_16\[0\].RAM16.SLICE\[0\].RAM8.WORD\[1\].W.BYTE\[0\].B.GCLK VGND
+ VGND VPWR VPWR SLICE_16\[0\].RAM16.SLICE\[0\].RAM8.WORD\[1\].W.BYTE\[0\].B.Q_WIRE\[0\]
+ sky130_fd_sc_hd__dlxtp_1
XSLICE_16\[1\].RAM16.SLICE\[0\].RAM8.WORD\[0\].W.BYTE\[3\].B.BIT\[5\].OBUF0 SLICE_16\[1\].RAM16.SLICE\[0\].RAM8.WORD\[0\].W.BYTE\[3\].B.Q_WIRE\[5\]
+ SLICE_16\[1\].RAM16.SLICE\[0\].RAM8.WORD\[0\].W.BYTE\[3\].B.SEL0_B VGND VGND VPWR
+ VPWR SLICE_16\[1\].RAM16.BYTE\[3\].FLOATBUF0\[29\].Z sky130_fd_sc_hd__ebufn_2
XSLICE_16\[0\].RAM16.SLICE\[1\].RAM8.WORD\[7\].W.BYTE\[3\].B.BIT\[7\].OBUF0 SLICE_16\[0\].RAM16.SLICE\[1\].RAM8.WORD\[7\].W.BYTE\[3\].B.Q_WIRE\[7\]
+ SLICE_16\[0\].RAM16.SLICE\[1\].RAM8.WORD\[7\].W.BYTE\[3\].B.SEL0_B VGND VGND VPWR
+ VPWR SLICE_16\[0\].RAM16.BYTE\[3\].FLOATBUF0\[31\].Z sky130_fd_sc_hd__ebufn_2
Xtap_11_19 VGND VPWR sky130_fd_sc_hd__tapvpwrvgnd_1
Xtap_11_9 VGND VPWR sky130_fd_sc_hd__tapvpwrvgnd_1
Xtap_36_27 VGND VPWR sky130_fd_sc_hd__tapvpwrvgnd_1
Xtap_36_16 VGND VPWR sky130_fd_sc_hd__tapvpwrvgnd_1
XSLICE_16\[0\].RAM16.SLICE\[0\].RAM8.WORD\[2\].W.BYTE\[2\].B.BIT\[6\].OBUF0 SLICE_16\[0\].RAM16.SLICE\[0\].RAM8.WORD\[2\].W.BYTE\[2\].B.Q_WIRE\[6\]
+ SLICE_16\[0\].RAM16.SLICE\[0\].RAM8.WORD\[2\].W.BYTE\[2\].B.SEL0_B VGND VGND VPWR
+ VPWR SLICE_16\[0\].RAM16.BYTE\[2\].FLOATBUF0\[22\].Z sky130_fd_sc_hd__ebufn_2
Xtap_4_8 VGND VPWR sky130_fd_sc_hd__tapvpwrvgnd_1
XDo0MUX.M\[2\].DIODE_A0MUX\[16\] Do0MUX.A0\[16\] VGND VGND VPWR VPWR sky130_fd_sc_hd__diode_2
XSLICE_16\[1\].RAM16.SLICE\[1\].RAM8.WORD\[5\].W.BYTE\[3\].B.CGAND SLICE_16\[1\].RAM16.SLICE\[1\].RAM8.WORD\[5\].W.BYTE\[0\].B.SEL0
+ SLICE_16\[1\].RAM16.SLICE\[1\].RAM8.WE0_buf\[3\] VGND VGND VPWR VPWR SLICE_16\[1\].RAM16.SLICE\[1\].RAM8.WORD\[5\].W.BYTE\[3\].B.WE0_WIRE
+ sky130_fd_sc_hd__and2_1
XSLICE_16\[1\].RAM16.SLICE\[1\].RAM8.WORD\[4\].W.BYTE\[2\].B.BIT\[3\].OBUF0 SLICE_16\[1\].RAM16.SLICE\[1\].RAM8.WORD\[4\].W.BYTE\[2\].B.Q_WIRE\[3\]
+ SLICE_16\[1\].RAM16.SLICE\[1\].RAM8.WORD\[4\].W.BYTE\[2\].B.SEL0_B VGND VGND VPWR
+ VPWR SLICE_16\[1\].RAM16.BYTE\[2\].FLOATBUF0\[19\].Z sky130_fd_sc_hd__ebufn_2
Xtap_7_20 VGND VPWR sky130_fd_sc_hd__tapvpwrvgnd_1
Xtap_7_31 VGND VPWR sky130_fd_sc_hd__tapvpwrvgnd_1
Xfill_40_25 VGND VPWR sky130_fd_sc_hd__tapvpwrvgnd_1
Xfill_40_14 VGND VGND VPWR VPWR sky130_fd_sc_hd__decap_12
Xtap_30_1 VGND VPWR sky130_fd_sc_hd__tapvpwrvgnd_1
Xtap_23_0 VGND VPWR sky130_fd_sc_hd__tapvpwrvgnd_1
XSLICE_16\[0\].RAM16.SLICE\[1\].RAM8.WORD\[6\].W.BYTE\[1\].B.BIT\[4\].OBUF0 SLICE_16\[0\].RAM16.SLICE\[1\].RAM8.WORD\[6\].W.BYTE\[1\].B.Q_WIRE\[4\]
+ SLICE_16\[0\].RAM16.SLICE\[1\].RAM8.WORD\[6\].W.BYTE\[1\].B.SEL0_B VGND VGND VPWR
+ VPWR SLICE_16\[0\].RAM16.BYTE\[1\].FLOATBUF0\[12\].Z sky130_fd_sc_hd__ebufn_2
XSLICE_16\[0\].RAM16.SLICE\[0\].RAM8.WORD\[7\].W.BYTE\[3\].B.genblk1.CG SLICE_16\[0\].RAM16.SLICE\[0\].RAM8.WORD\[7\].W.BYTE\[3\].B.CLK_B
+ SLICE_16\[0\].RAM16.SLICE\[0\].RAM8.WORD\[7\].W.BYTE\[3\].B.WE0_WIRE VGND VGND VPWR
+ VPWR SLICE_16\[0\].RAM16.SLICE\[0\].RAM8.WORD\[7\].W.BYTE\[3\].B.GCLK sky130_fd_sc_hd__dlclkp_1
XSLICE_16\[1\].RAM16.Do0_REG.OUTREG_BYTE\[3\].DIODE\[6\] SLICE_16\[1\].RAM16.BYTE\[3\].FLOATBUF0\[30\].Z
+ VGND VGND VPWR VPWR sky130_fd_sc_hd__diode_2
XSLICE_16\[0\].RAM16.BYTE\[3\].FLOATBUF0\[25\].__cell__ SLICE_16\[0\].RAM16.BYTE\[3\].FLOATBUF0\[24\].A
+ SLICE_16\[0\].RAM16.BYTE\[3\].FLOATBUF0\[24\].TE_B VGND VGND VPWR VPWR SLICE_16\[0\].RAM16.BYTE\[3\].FLOATBUF0\[25\].Z
+ sky130_fd_sc_hd__ebufn_2
XSLICE_16\[0\].RAM16.SLICE\[0\].RAM8.WORD\[1\].W.BYTE\[0\].B.BIT\[3\].OBUF0 SLICE_16\[0\].RAM16.SLICE\[0\].RAM8.WORD\[1\].W.BYTE\[0\].B.Q_WIRE\[3\]
+ SLICE_16\[0\].RAM16.SLICE\[0\].RAM8.WORD\[1\].W.BYTE\[0\].B.SEL0_B VGND VGND VPWR
+ VPWR SLICE_16\[0\].RAM16.BYTE\[0\].FLOATBUF0\[3\].Z sky130_fd_sc_hd__ebufn_2
Xfill_44_3 VGND VPWR sky130_fd_sc_hd__tapvpwrvgnd_1
Xfill_37_2 VGND VPWR sky130_fd_sc_hd__tapvpwrvgnd_1
XSLICE_16\[1\].RAM16.SLICE\[1\].RAM8.WORD\[3\].W.BYTE\[0\].B.BIT\[0\].OBUF0 SLICE_16\[1\].RAM16.SLICE\[1\].RAM8.WORD\[3\].W.BYTE\[0\].B.Q_WIRE\[0\]
+ SLICE_16\[1\].RAM16.SLICE\[1\].RAM8.WORD\[3\].W.BYTE\[0\].B.SEL0_B VGND VGND VPWR
+ VPWR SLICE_16\[1\].RAM16.BYTE\[0\].FLOATBUF0\[0\].Z sky130_fd_sc_hd__ebufn_2
XSLICE_16\[1\].RAM16.SLICE\[0\].RAM8.WORD\[5\].W.BYTE\[3\].B.BIT\[5\].genblk1.STORAGE
+ DIBUF\[29\].X SLICE_16\[1\].RAM16.SLICE\[0\].RAM8.WORD\[5\].W.BYTE\[3\].B.GCLK VGND
+ VGND VPWR VPWR SLICE_16\[1\].RAM16.SLICE\[0\].RAM8.WORD\[5\].W.BYTE\[3\].B.Q_WIRE\[5\]
+ sky130_fd_sc_hd__dlxtp_1
XSLICE_16\[0\].RAM16.SLICE\[0\].RAM8.WORD\[5\].W.BYTE\[3\].B.BIT\[6\].OBUF0 SLICE_16\[0\].RAM16.SLICE\[0\].RAM8.WORD\[5\].W.BYTE\[3\].B.Q_WIRE\[6\]
+ SLICE_16\[0\].RAM16.SLICE\[0\].RAM8.WORD\[5\].W.BYTE\[3\].B.SEL0_B VGND VGND VPWR
+ VPWR SLICE_16\[0\].RAM16.BYTE\[3\].FLOATBUF0\[30\].Z sky130_fd_sc_hd__ebufn_2
XSLICE_16\[1\].RAM16.BYTE\[1\].FLOATBUF0\[8\].__cell__ SLICE_16\[1\].RAM16.BYTE\[1\].FLOATBUF0\[10\].A
+ SLICE_16\[1\].RAM16.BYTE\[1\].FLOATBUF0\[10\].TE_B VGND VGND VPWR VPWR SLICE_16\[1\].RAM16.BYTE\[1\].FLOATBUF0\[8\].Z
+ sky130_fd_sc_hd__ebufn_2
XSLICE_16\[1\].RAM16.SLICE\[1\].RAM8.WORD\[7\].W.BYTE\[3\].B.BIT\[3\].OBUF0 SLICE_16\[1\].RAM16.SLICE\[1\].RAM8.WORD\[7\].W.BYTE\[3\].B.Q_WIRE\[3\]
+ SLICE_16\[1\].RAM16.SLICE\[1\].RAM8.WORD\[7\].W.BYTE\[3\].B.SEL0_B VGND VGND VPWR
+ VPWR SLICE_16\[1\].RAM16.BYTE\[3\].FLOATBUF0\[27\].Z sky130_fd_sc_hd__ebufn_2
XSLICE_16\[1\].RAM16.SLICE\[0\].RAM8.WORD\[3\].W.BYTE\[1\].B.BIT\[4\].genblk1.STORAGE
+ DIBUF\[12\].X SLICE_16\[1\].RAM16.SLICE\[0\].RAM8.WORD\[3\].W.BYTE\[1\].B.GCLK VGND
+ VGND VPWR VPWR SLICE_16\[1\].RAM16.SLICE\[0\].RAM8.WORD\[3\].W.BYTE\[1\].B.Q_WIRE\[4\]
+ sky130_fd_sc_hd__dlxtp_1
XSLICE_16\[0\].RAM16.SLICE\[1\].RAM8.WORD\[7\].W.BYTE\[3\].B.BIT\[6\].genblk1.STORAGE
+ DIBUF\[30\].X SLICE_16\[0\].RAM16.SLICE\[1\].RAM8.WORD\[7\].W.BYTE\[3\].B.GCLK VGND
+ VGND VPWR VPWR SLICE_16\[0\].RAM16.SLICE\[1\].RAM8.WORD\[7\].W.BYTE\[3\].B.Q_WIRE\[6\]
+ sky130_fd_sc_hd__dlxtp_1
XSLICE_16\[1\].RAM16.SLICE\[0\].RAM8.WORD\[4\].W.BYTE\[2\].B.genblk1.CG SLICE_16\[1\].RAM16.SLICE\[0\].RAM8.WORD\[4\].W.BYTE\[2\].B.CLK_B
+ SLICE_16\[1\].RAM16.SLICE\[0\].RAM8.WORD\[4\].W.BYTE\[2\].B.WE0_WIRE VGND VGND VPWR
+ VPWR SLICE_16\[1\].RAM16.SLICE\[0\].RAM8.WORD\[4\].W.BYTE\[2\].B.GCLK sky130_fd_sc_hd__dlclkp_1
XSLICE_16\[0\].RAM16.SLICE\[1\].RAM8.WORD\[5\].W.BYTE\[1\].B.BIT\[5\].genblk1.STORAGE
+ DIBUF\[13\].X SLICE_16\[0\].RAM16.SLICE\[1\].RAM8.WORD\[5\].W.BYTE\[1\].B.GCLK VGND
+ VGND VPWR VPWR SLICE_16\[0\].RAM16.SLICE\[1\].RAM8.WORD\[5\].W.BYTE\[1\].B.Q_WIRE\[5\]
+ sky130_fd_sc_hd__dlxtp_1
XSLICE_16\[0\].RAM16.SLICE\[0\].RAM8.WORD\[6\].W.BYTE\[3\].B.BIT\[1\].genblk1.STORAGE
+ DIBUF\[25\].X SLICE_16\[0\].RAM16.SLICE\[0\].RAM8.WORD\[6\].W.BYTE\[3\].B.GCLK VGND
+ VGND VPWR VPWR SLICE_16\[0\].RAM16.SLICE\[0\].RAM8.WORD\[6\].W.BYTE\[3\].B.Q_WIRE\[1\]
+ sky130_fd_sc_hd__dlxtp_1
XSLICE_16\[1\].RAM16.SLICE\[0\].RAM8.WORD\[2\].W.BYTE\[2\].B.BIT\[2\].OBUF0 SLICE_16\[1\].RAM16.SLICE\[0\].RAM8.WORD\[2\].W.BYTE\[2\].B.Q_WIRE\[2\]
+ SLICE_16\[1\].RAM16.SLICE\[0\].RAM8.WORD\[2\].W.BYTE\[2\].B.SEL0_B VGND VGND VPWR
+ VPWR SLICE_16\[1\].RAM16.BYTE\[2\].FLOATBUF0\[18\].Z sky130_fd_sc_hd__ebufn_2
Xfill_19_48 VGND VPWR sky130_fd_sc_hd__tapvpwrvgnd_1
Xfill_19_37 VGND VGND VPWR VPWR sky130_fd_sc_hd__decap_12
Xfill_19_26 VGND VGND VPWR VPWR sky130_fd_sc_hd__decap_12
Xfill_19_15 VGND VPWR sky130_fd_sc_hd__tapvpwrvgnd_1
XSLICE_16\[0\].RAM16.SLICE\[0\].RAM8.WORD\[4\].W.BYTE\[1\].B.BIT\[0\].genblk1.STORAGE
+ DIBUF\[8\].X SLICE_16\[0\].RAM16.SLICE\[0\].RAM8.WORD\[4\].W.BYTE\[1\].B.GCLK VGND
+ VGND VPWR VPWR SLICE_16\[0\].RAM16.SLICE\[0\].RAM8.WORD\[4\].W.BYTE\[1\].B.Q_WIRE\[0\]
+ sky130_fd_sc_hd__dlxtp_1
Xfill_19_59 VGND VGND VPWR VPWR sky130_fd_sc_hd__decap_12
Xtap_2_5 VGND VPWR sky130_fd_sc_hd__tapvpwrvgnd_1
XSLICE_16\[0\].RAM16.SLICE\[0\].RAM8.WORD\[4\].W.BYTE\[1\].B.BIT\[3\].OBUF0 SLICE_16\[0\].RAM16.SLICE\[0\].RAM8.WORD\[4\].W.BYTE\[1\].B.Q_WIRE\[3\]
+ SLICE_16\[0\].RAM16.SLICE\[0\].RAM8.WORD\[4\].W.BYTE\[1\].B.SEL0_B VGND VGND VPWR
+ VPWR SLICE_16\[0\].RAM16.BYTE\[1\].FLOATBUF0\[11\].Z sky130_fd_sc_hd__ebufn_2
XSLICE_16\[1\].RAM16.Do0_REG.OUTREG_BYTE\[2\].Do_FF\[7\] SLICE_16\[1\].RAM16.Do0_REG.CLKBUF\[2\]
+ SLICE_16\[1\].RAM16.BYTE\[2\].FLOATBUF0\[23\].Z VGND VGND VPWR VPWR Do0MUX.A1\[23\]
+ sky130_fd_sc_hd__dfxtp_1
XSLICE_16\[1\].RAM16.SLICE\[1\].RAM8.WORD\[6\].W.BYTE\[1\].B.BIT\[0\].OBUF0 SLICE_16\[1\].RAM16.SLICE\[1\].RAM8.WORD\[6\].W.BYTE\[1\].B.Q_WIRE\[0\]
+ SLICE_16\[1\].RAM16.SLICE\[1\].RAM8.WORD\[6\].W.BYTE\[1\].B.SEL0_B VGND VGND VPWR
+ VPWR SLICE_16\[1\].RAM16.BYTE\[1\].FLOATBUF0\[8\].Z sky130_fd_sc_hd__ebufn_2
Xfill_16_7 VGND VGND VPWR VPWR sky130_fd_sc_hd__fill_2
Xfill_41_90 VGND VPWR sky130_fd_sc_hd__tapvpwrvgnd_1
XSLICE_16\[1\].RAM16.SLICE\[0\].RAM8.WORD\[0\].W.BYTE\[3\].B.CGAND SLICE_16\[1\].RAM16.SLICE\[0\].RAM8.WORD\[0\].W.BYTE\[0\].B.SEL0
+ SLICE_16\[1\].RAM16.SLICE\[0\].RAM8.WE0_buf\[3\] VGND VGND VPWR VPWR SLICE_16\[1\].RAM16.SLICE\[0\].RAM8.WORD\[0\].W.BYTE\[3\].B.WE0_WIRE
+ sky130_fd_sc_hd__and2_1
XSLICE_16\[1\].RAM16.SLICE\[0\].RAM8.WORD\[5\].W.BYTE\[3\].B.BIT\[2\].OBUF0 SLICE_16\[1\].RAM16.SLICE\[0\].RAM8.WORD\[5\].W.BYTE\[3\].B.Q_WIRE\[2\]
+ SLICE_16\[1\].RAM16.SLICE\[0\].RAM8.WORD\[5\].W.BYTE\[3\].B.SEL0_B VGND VGND VPWR
+ VPWR SLICE_16\[1\].RAM16.BYTE\[3\].FLOATBUF0\[26\].Z sky130_fd_sc_hd__ebufn_2
Xfill_42_0 VGND VPWR sky130_fd_sc_hd__tapvpwrvgnd_1
Xtap_33_28 VGND VPWR sky130_fd_sc_hd__tapvpwrvgnd_1
Xtap_33_17 VGND VPWR sky130_fd_sc_hd__tapvpwrvgnd_1
XSLICE_16\[1\].RAM16.SLICE\[0\].RAM8.WORD\[2\].W.BYTE\[0\].B.BIT\[7\].OBUF0 SLICE_16\[1\].RAM16.SLICE\[0\].RAM8.WORD\[2\].W.BYTE\[0\].B.Q_WIRE\[7\]
+ SLICE_16\[1\].RAM16.SLICE\[0\].RAM8.WORD\[2\].W.BYTE\[0\].B.SEL0_B VGND VGND VPWR
+ VPWR SLICE_16\[1\].RAM16.BYTE\[0\].FLOATBUF0\[7\].Z sky130_fd_sc_hd__ebufn_2
XSLICE_16\[0\].RAM16.SLICE\[0\].RAM8.WORD\[7\].W.BYTE\[2\].B.BIT\[3\].OBUF0 SLICE_16\[0\].RAM16.SLICE\[0\].RAM8.WORD\[7\].W.BYTE\[2\].B.Q_WIRE\[3\]
+ SLICE_16\[0\].RAM16.SLICE\[0\].RAM8.WORD\[7\].W.BYTE\[2\].B.SEL0_B VGND VGND VPWR
+ VPWR SLICE_16\[0\].RAM16.BYTE\[2\].FLOATBUF0\[19\].Z sky130_fd_sc_hd__ebufn_2
XSLICE_16\[1\].RAM16.SLICE\[0\].RAM8.WORD\[6\].W.BYTE\[2\].B.BIT\[4\].genblk1.STORAGE
+ DIBUF\[20\].X SLICE_16\[1\].RAM16.SLICE\[0\].RAM8.WORD\[6\].W.BYTE\[2\].B.GCLK VGND
+ VGND VPWR VPWR SLICE_16\[1\].RAM16.SLICE\[0\].RAM8.WORD\[6\].W.BYTE\[2\].B.Q_WIRE\[4\]
+ sky130_fd_sc_hd__dlxtp_1
Xfill_21_49 VGND VGND VPWR VPWR sky130_fd_sc_hd__decap_12
Xfill_21_38 VGND VGND VPWR VPWR sky130_fd_sc_hd__decap_12
Xfill_21_27 VGND VPWR sky130_fd_sc_hd__tapvpwrvgnd_1
Xfill_21_16 VGND VGND VPWR VPWR sky130_fd_sc_hd__decap_12
Xtap_4_10 VGND VPWR sky130_fd_sc_hd__tapvpwrvgnd_1
Xtap_4_21 VGND VPWR sky130_fd_sc_hd__tapvpwrvgnd_1
Xtap_4_32 VGND VPWR sky130_fd_sc_hd__tapvpwrvgnd_1
Xfill_46_35 VGND VPWR sky130_fd_sc_hd__tapvpwrvgnd_1
Xfill_46_24 VGND VPWR sky130_fd_sc_hd__tapvpwrvgnd_1
Xfill_46_13 VGND VGND VPWR VPWR sky130_fd_sc_hd__decap_4
XSLICE_16\[1\].RAM16.SLICE\[0\].RAM8.WORD\[4\].W.BYTE\[0\].B.BIT\[3\].genblk1.STORAGE
+ DIBUF\[3\].X SLICE_16\[1\].RAM16.SLICE\[0\].RAM8.WORD\[4\].W.BYTE\[0\].B.GCLK VGND
+ VGND VPWR VPWR SLICE_16\[1\].RAM16.SLICE\[0\].RAM8.WORD\[4\].W.BYTE\[0\].B.Q_WIRE\[3\]
+ sky130_fd_sc_hd__dlxtp_1
XSLICE_16\[1\].RAM16.SLICE\[0\].RAM8.WORD\[0\].W.BYTE\[3\].B.BIT\[5\].genblk1.STORAGE
+ DIBUF\[29\].X SLICE_16\[1\].RAM16.SLICE\[0\].RAM8.WORD\[0\].W.BYTE\[3\].B.GCLK VGND
+ VGND VPWR VPWR SLICE_16\[1\].RAM16.SLICE\[0\].RAM8.WORD\[0\].W.BYTE\[3\].B.Q_WIRE\[5\]
+ sky130_fd_sc_hd__dlxtp_1
XSLICE_16\[0\].RAM16.SLICE\[0\].RAM8.DEC0.ABUF\[1\] SLICE_16\[0\].RAM16.A0BUF\[1\].X
+ VGND VGND VPWR VPWR SLICE_16\[0\].RAM16.SLICE\[0\].RAM8.DEC0.A_buf\[1\] sky130_fd_sc_hd__clkbuf_2
Xtap_0_2 VGND VPWR sky130_fd_sc_hd__tapvpwrvgnd_1
Xfill_46_79 VGND VGND VPWR VPWR sky130_fd_sc_hd__decap_12
Xfill_46_68 VGND VPWR sky130_fd_sc_hd__tapvpwrvgnd_1
Xfill_46_57 VGND VPWR sky130_fd_sc_hd__tapvpwrvgnd_1
Xfill_46_46 VGND VGND VPWR VPWR sky130_fd_sc_hd__decap_4
XSLICE_16\[0\].RAM16.SLICE\[1\].RAM8.WORD\[6\].W.BYTE\[0\].B.BIT\[4\].genblk1.STORAGE
+ DIBUF\[4\].X SLICE_16\[0\].RAM16.SLICE\[1\].RAM8.WORD\[6\].W.BYTE\[0\].B.GCLK VGND
+ VGND VPWR VPWR SLICE_16\[0\].RAM16.SLICE\[1\].RAM8.WORD\[6\].W.BYTE\[0\].B.Q_WIRE\[4\]
+ sky130_fd_sc_hd__dlxtp_1
XSLICE_16\[0\].RAM16.SLICE\[1\].RAM8.WORD\[0\].W.BYTE\[1\].B.BIT\[5\].genblk1.STORAGE
+ DIBUF\[13\].X SLICE_16\[0\].RAM16.SLICE\[1\].RAM8.WORD\[0\].W.BYTE\[1\].B.GCLK VGND
+ VGND VPWR VPWR SLICE_16\[0\].RAM16.SLICE\[1\].RAM8.WORD\[0\].W.BYTE\[1\].B.Q_WIRE\[5\]
+ sky130_fd_sc_hd__dlxtp_1
XSLICE_16\[0\].RAM16.SLICE\[1\].RAM8.WORD\[2\].W.BYTE\[3\].B.BIT\[6\].genblk1.STORAGE
+ DIBUF\[30\].X SLICE_16\[0\].RAM16.SLICE\[1\].RAM8.WORD\[2\].W.BYTE\[3\].B.GCLK VGND
+ VGND VPWR VPWR SLICE_16\[0\].RAM16.SLICE\[1\].RAM8.WORD\[2\].W.BYTE\[3\].B.Q_WIRE\[6\]
+ sky130_fd_sc_hd__dlxtp_1
XSLICE_16\[0\].RAM16.SLICE\[0\].RAM8.WORD\[1\].W.BYTE\[3\].B.BIT\[1\].genblk1.STORAGE
+ DIBUF\[25\].X SLICE_16\[0\].RAM16.SLICE\[0\].RAM8.WORD\[1\].W.BYTE\[3\].B.GCLK VGND
+ VGND VPWR VPWR SLICE_16\[0\].RAM16.SLICE\[0\].RAM8.WORD\[1\].W.BYTE\[3\].B.Q_WIRE\[1\]
+ sky130_fd_sc_hd__dlxtp_1
XSLICE_16\[0\].RAM16.SLICE\[0\].RAM8.WORD\[7\].W.BYTE\[2\].B.BIT\[0\].genblk1.STORAGE
+ DIBUF\[16\].X SLICE_16\[0\].RAM16.SLICE\[0\].RAM8.WORD\[7\].W.BYTE\[2\].B.GCLK VGND
+ VGND VPWR VPWR SLICE_16\[0\].RAM16.SLICE\[0\].RAM8.WORD\[7\].W.BYTE\[2\].B.Q_WIRE\[0\]
+ sky130_fd_sc_hd__dlxtp_1
Xfill_21_5 VGND VGND VPWR VPWR sky130_fd_sc_hd__decap_12
XSLICE_16\[0\].RAM16.SLICE\[0\].RAM8.WORD\[6\].W.BYTE\[0\].B.BIT\[0\].OBUF0 SLICE_16\[0\].RAM16.SLICE\[0\].RAM8.WORD\[6\].W.BYTE\[0\].B.Q_WIRE\[0\]
+ SLICE_16\[0\].RAM16.SLICE\[0\].RAM8.WORD\[6\].W.BYTE\[0\].B.SEL0_B VGND VGND VPWR
+ VPWR SLICE_16\[0\].RAM16.BYTE\[0\].FLOATBUF0\[0\].Z sky130_fd_sc_hd__ebufn_2
XSLICE_16\[1\].RAM16.SLICE\[0\].RAM8.WORD\[5\].W.BYTE\[1\].B.BIT\[7\].OBUF0 SLICE_16\[1\].RAM16.SLICE\[0\].RAM8.WORD\[5\].W.BYTE\[1\].B.Q_WIRE\[7\]
+ SLICE_16\[1\].RAM16.SLICE\[0\].RAM8.WORD\[5\].W.BYTE\[1\].B.SEL0_B VGND VGND VPWR
+ VPWR SLICE_16\[1\].RAM16.BYTE\[1\].FLOATBUF0\[15\].Z sky130_fd_sc_hd__ebufn_2
Xfill_14_4 VGND VGND VPWR VPWR sky130_fd_sc_hd__decap_6
XSLICE_16\[0\].RAM16.SLICE\[1\].RAM8.WORD\[2\].W.BYTE\[3\].B.BIT\[6\].OBUF0 SLICE_16\[0\].RAM16.SLICE\[1\].RAM8.WORD\[2\].W.BYTE\[3\].B.Q_WIRE\[6\]
+ SLICE_16\[0\].RAM16.SLICE\[1\].RAM8.WORD\[2\].W.BYTE\[3\].B.SEL0_B VGND VGND VPWR
+ VPWR SLICE_16\[0\].RAM16.BYTE\[3\].FLOATBUF0\[30\].Z sky130_fd_sc_hd__ebufn_2
XSLICE_16\[1\].RAM16.SLICE\[1\].RAM8.WORD\[1\].W.BYTE\[2\].B.CGAND SLICE_16\[1\].RAM16.SLICE\[1\].RAM8.WORD\[1\].W.BYTE\[0\].B.SEL0
+ SLICE_16\[1\].RAM16.SLICE\[1\].RAM8.WE0_buf\[2\] VGND VGND VPWR VPWR SLICE_16\[1\].RAM16.SLICE\[1\].RAM8.WORD\[1\].W.BYTE\[2\].B.WE0_WIRE
+ sky130_fd_sc_hd__and2_1
XSLICE_16\[0\].RAM16.Do0_REG.OUTREG_BYTE\[1\].DIODE\[7\] SLICE_16\[0\].RAM16.BYTE\[1\].FLOATBUF0\[15\].Z
+ VGND VGND VPWR VPWR sky130_fd_sc_hd__diode_2
Xtap_28_28 VGND VPWR sky130_fd_sc_hd__tapvpwrvgnd_1
Xtap_28_17 VGND VPWR sky130_fd_sc_hd__tapvpwrvgnd_1
XSLICE_16\[0\].RAM16.SLICE\[1\].RAM8.WORD\[1\].W.BYTE\[1\].B.BIT\[3\].OBUF0 SLICE_16\[0\].RAM16.SLICE\[1\].RAM8.WORD\[1\].W.BYTE\[1\].B.Q_WIRE\[3\]
+ SLICE_16\[0\].RAM16.SLICE\[1\].RAM8.WORD\[1\].W.BYTE\[1\].B.SEL0_B VGND VGND VPWR
+ VPWR SLICE_16\[0\].RAM16.BYTE\[1\].FLOATBUF0\[11\].Z sky130_fd_sc_hd__ebufn_2
XSLICE_16\[1\].RAM16.SLICE\[1\].RAM8.DEC0.AND3 SLICE_16\[1\].RAM16.SLICE\[1\].RAM8.DEC0.A_buf\[2\]
+ SLICE_16\[1\].RAM16.SLICE\[1\].RAM8.DEC0.A_buf\[1\] SLICE_16\[1\].RAM16.SLICE\[1\].RAM8.DEC0.A_buf\[0\]
+ SLICE_16\[1\].RAM16.SLICE\[1\].RAM8.DEC0.EN_buf VGND VGND VPWR VPWR SLICE_16\[1\].RAM16.SLICE\[1\].RAM8.DEC0.SEL\[3\]
+ sky130_fd_sc_hd__and4b_2
XSLICE_16\[1\].RAM16.SLICE\[0\].RAM8.WORD\[7\].W.BYTE\[1\].B.BIT\[3\].genblk1.STORAGE
+ DIBUF\[11\].X SLICE_16\[1\].RAM16.SLICE\[0\].RAM8.WORD\[7\].W.BYTE\[1\].B.GCLK VGND
+ VGND VPWR VPWR SLICE_16\[1\].RAM16.SLICE\[0\].RAM8.WORD\[7\].W.BYTE\[1\].B.Q_WIRE\[3\]
+ sky130_fd_sc_hd__dlxtp_1
XSLICE_16\[1\].RAM16.SLICE\[0\].RAM8.WORD\[1\].W.BYTE\[2\].B.BIT\[4\].genblk1.STORAGE
+ DIBUF\[20\].X SLICE_16\[1\].RAM16.SLICE\[0\].RAM8.WORD\[1\].W.BYTE\[2\].B.GCLK VGND
+ VGND VPWR VPWR SLICE_16\[1\].RAM16.SLICE\[0\].RAM8.WORD\[1\].W.BYTE\[2\].B.Q_WIRE\[4\]
+ sky130_fd_sc_hd__dlxtp_1
Xfill_22_92 VGND VGND VPWR VPWR sky130_fd_sc_hd__decap_12
Xfill_22_81 VGND VPWR sky130_fd_sc_hd__tapvpwrvgnd_1
Xfill_22_70 VGND VGND VPWR VPWR sky130_fd_sc_hd__decap_12
XSLICE_16\[0\].RAM16.SLICE\[1\].RAM8.WORD\[3\].W.BYTE\[2\].B.BIT\[5\].genblk1.STORAGE
+ DIBUF\[21\].X SLICE_16\[0\].RAM16.SLICE\[1\].RAM8.WORD\[3\].W.BYTE\[2\].B.GCLK VGND
+ VGND VPWR VPWR SLICE_16\[0\].RAM16.SLICE\[1\].RAM8.WORD\[3\].W.BYTE\[2\].B.Q_WIRE\[5\]
+ sky130_fd_sc_hd__dlxtp_1
XSLICE_16\[0\].RAM16.SLICE\[0\].RAM8.WORD\[0\].W.BYTE\[3\].B.BIT\[5\].OBUF0 SLICE_16\[0\].RAM16.SLICE\[0\].RAM8.WORD\[0\].W.BYTE\[3\].B.Q_WIRE\[5\]
+ SLICE_16\[0\].RAM16.SLICE\[0\].RAM8.WORD\[0\].W.BYTE\[3\].B.SEL0_B VGND VGND VPWR
+ VPWR SLICE_16\[0\].RAM16.BYTE\[3\].FLOATBUF0\[29\].Z sky130_fd_sc_hd__ebufn_2
XSLICE_16\[1\].RAM16.SLICE\[1\].RAM8.WORD\[2\].W.BYTE\[3\].B.BIT\[2\].OBUF0 SLICE_16\[1\].RAM16.SLICE\[1\].RAM8.WORD\[2\].W.BYTE\[3\].B.Q_WIRE\[2\]
+ SLICE_16\[1\].RAM16.SLICE\[1\].RAM8.WORD\[2\].W.BYTE\[3\].B.SEL0_B VGND VGND VPWR
+ VPWR SLICE_16\[1\].RAM16.BYTE\[3\].FLOATBUF0\[26\].Z sky130_fd_sc_hd__ebufn_2
Xtap_14_19 VGND VPWR sky130_fd_sc_hd__tapvpwrvgnd_1
Xfill_12_1 VGND VPWR sky130_fd_sc_hd__tapvpwrvgnd_1
XSLICE_16\[0\].RAM16.SLICE\[1\].RAM8.WORD\[1\].W.BYTE\[0\].B.BIT\[4\].genblk1.STORAGE
+ DIBUF\[4\].X SLICE_16\[0\].RAM16.SLICE\[1\].RAM8.WORD\[1\].W.BYTE\[0\].B.GCLK VGND
+ VGND VPWR VPWR SLICE_16\[0\].RAM16.SLICE\[1\].RAM8.WORD\[1\].W.BYTE\[0\].B.Q_WIRE\[4\]
+ sky130_fd_sc_hd__dlxtp_1
Xtap_30_29 VGND VPWR sky130_fd_sc_hd__tapvpwrvgnd_1
Xtap_30_18 VGND VPWR sky130_fd_sc_hd__tapvpwrvgnd_1
XSLICE_16\[0\].RAM16.SLICE\[0\].RAM8.WORD\[2\].W.BYTE\[2\].B.BIT\[0\].genblk1.STORAGE
+ DIBUF\[16\].X SLICE_16\[0\].RAM16.SLICE\[0\].RAM8.WORD\[2\].W.BYTE\[2\].B.GCLK VGND
+ VGND VPWR VPWR SLICE_16\[0\].RAM16.SLICE\[0\].RAM8.WORD\[2\].W.BYTE\[2\].B.Q_WIRE\[0\]
+ sky130_fd_sc_hd__dlxtp_1
Xtap_34_8 VGND VPWR sky130_fd_sc_hd__tapvpwrvgnd_1
XSLICE_16\[1\].RAM16.SLICE\[0\].RAM8.WORD\[7\].W.BYTE\[2\].B.SEL0INV SLICE_16\[1\].RAM16.SLICE\[0\].RAM8.WORD\[7\].W.BYTE\[0\].B.SEL0
+ VGND VGND VPWR VPWR SLICE_16\[1\].RAM16.SLICE\[0\].RAM8.WORD\[7\].W.BYTE\[2\].B.SEL0_B
+ sky130_fd_sc_hd__inv_1
Xtap_27_7 VGND VPWR sky130_fd_sc_hd__tapvpwrvgnd_1
Xtap_1_22 VGND VPWR sky130_fd_sc_hd__tapvpwrvgnd_1
Xtap_1_11 VGND VPWR sky130_fd_sc_hd__tapvpwrvgnd_1
XSLICE_16\[1\].RAM16.SLICE\[0\].RAM8.WORD\[7\].W.BYTE\[0\].B.BIT\[4\].OBUF0 SLICE_16\[1\].RAM16.SLICE\[0\].RAM8.WORD\[7\].W.BYTE\[0\].B.Q_WIRE\[4\]
+ SLICE_16\[1\].RAM16.SLICE\[0\].RAM8.WORD\[7\].W.BYTE\[0\].B.SEL0_B VGND VGND VPWR
+ VPWR SLICE_16\[1\].RAM16.BYTE\[0\].FLOATBUF0\[4\].Z sky130_fd_sc_hd__ebufn_2
XSLICE_16\[0\].RAM16.SLICE\[1\].RAM8.WORD\[4\].W.BYTE\[2\].B.BIT\[3\].OBUF0 SLICE_16\[0\].RAM16.SLICE\[1\].RAM8.WORD\[4\].W.BYTE\[2\].B.Q_WIRE\[3\]
+ SLICE_16\[0\].RAM16.SLICE\[1\].RAM8.WORD\[4\].W.BYTE\[2\].B.SEL0_B VGND VGND VPWR
+ VPWR SLICE_16\[0\].RAM16.BYTE\[2\].FLOATBUF0\[19\].Z sky130_fd_sc_hd__ebufn_2
Xtap_1_33 VGND VPWR sky130_fd_sc_hd__tapvpwrvgnd_1
XSLICE_16\[0\].RAM16.SLICE\[0\].RAM8.WORD\[3\].W.BYTE\[2\].B.genblk1.CG SLICE_16\[0\].RAM16.SLICE\[0\].RAM8.WORD\[3\].W.BYTE\[2\].B.CLK_B
+ SLICE_16\[0\].RAM16.SLICE\[0\].RAM8.WORD\[3\].W.BYTE\[2\].B.WE0_WIRE VGND VGND VPWR
+ VPWR SLICE_16\[0\].RAM16.SLICE\[0\].RAM8.WORD\[3\].W.BYTE\[2\].B.GCLK sky130_fd_sc_hd__dlclkp_1
Xfill_43_69 VGND VPWR sky130_fd_sc_hd__tapvpwrvgnd_1
Xfill_43_58 VGND VGND VPWR VPWR sky130_fd_sc_hd__decap_12
Xfill_43_47 VGND VGND VPWR VPWR sky130_fd_sc_hd__decap_12
Xfill_43_36 VGND VPWR sky130_fd_sc_hd__tapvpwrvgnd_1
Xfill_43_25 VGND VGND VPWR VPWR sky130_fd_sc_hd__decap_12
Xfill_43_14 VGND VGND VPWR VPWR sky130_fd_sc_hd__decap_12
XSLICE_16\[1\].RAM16.Do0_REG.OUTREG_BYTE\[3\].Do_FF\[0\] SLICE_16\[1\].RAM16.Do0_REG.CLKBUF\[3\]
+ SLICE_16\[1\].RAM16.BYTE\[3\].FLOATBUF0\[24\].Z VGND VGND VPWR VPWR Do0MUX.A1\[24\]
+ sky130_fd_sc_hd__dfxtp_1
XSLICE_16\[0\].RAM16.SLICE\[0\].RAM8.WORD\[7\].W.BYTE\[1\].B.CGAND SLICE_16\[0\].RAM16.SLICE\[0\].RAM8.WORD\[7\].W.BYTE\[0\].B.SEL0
+ SLICE_16\[0\].RAM16.SLICE\[0\].RAM8.WE0_buf\[1\] VGND VGND VPWR VPWR SLICE_16\[0\].RAM16.SLICE\[0\].RAM8.WORD\[7\].W.BYTE\[1\].B.WE0_WIRE
+ sky130_fd_sc_hd__and2_1
XSLICE_16\[0\].RAM16.SLICE\[1\].RAM8.WORD\[3\].W.BYTE\[0\].B.BIT\[0\].OBUF0 SLICE_16\[0\].RAM16.SLICE\[1\].RAM8.WORD\[3\].W.BYTE\[0\].B.Q_WIRE\[0\]
+ SLICE_16\[0\].RAM16.SLICE\[1\].RAM8.WORD\[3\].W.BYTE\[0\].B.SEL0_B VGND VGND VPWR
+ VPWR SLICE_16\[0\].RAM16.BYTE\[0\].FLOATBUF0\[0\].Z sky130_fd_sc_hd__ebufn_2
XSLICE_16\[0\].RAM16.SLICE\[0\].RAM8.WORD\[5\].W.BYTE\[3\].B.SEL0INV SLICE_16\[0\].RAM16.SLICE\[0\].RAM8.WORD\[5\].W.BYTE\[0\].B.SEL0
+ VGND VGND VPWR VPWR SLICE_16\[0\].RAM16.SLICE\[0\].RAM8.WORD\[5\].W.BYTE\[3\].B.SEL0_B
+ sky130_fd_sc_hd__inv_1
XSLICE_16\[1\].RAM16.SLICE\[1\].RAM8.WORD\[2\].W.BYTE\[1\].B.BIT\[7\].OBUF0 SLICE_16\[1\].RAM16.SLICE\[1\].RAM8.WORD\[2\].W.BYTE\[1\].B.Q_WIRE\[7\]
+ SLICE_16\[1\].RAM16.SLICE\[1\].RAM8.WORD\[2\].W.BYTE\[1\].B.SEL0_B VGND VGND VPWR
+ VPWR SLICE_16\[1\].RAM16.BYTE\[1\].FLOATBUF0\[15\].Z sky130_fd_sc_hd__ebufn_2
XSLICE_16\[1\].RAM16.SLICE\[0\].RAM8.WORD\[0\].W.BYTE\[1\].B.genblk1.CG SLICE_16\[1\].RAM16.SLICE\[0\].RAM8.WORD\[0\].W.BYTE\[1\].B.CLK_B
+ SLICE_16\[1\].RAM16.SLICE\[0\].RAM8.WORD\[0\].W.BYTE\[1\].B.WE0_WIRE VGND VGND VPWR
+ VPWR SLICE_16\[1\].RAM16.SLICE\[0\].RAM8.WORD\[0\].W.BYTE\[1\].B.GCLK sky130_fd_sc_hd__dlclkp_1
XSLICE_16\[0\].RAM16.SLICE\[1\].RAM8.WORD\[7\].W.BYTE\[3\].B.BIT\[3\].OBUF0 SLICE_16\[0\].RAM16.SLICE\[1\].RAM8.WORD\[7\].W.BYTE\[3\].B.Q_WIRE\[3\]
+ SLICE_16\[0\].RAM16.SLICE\[1\].RAM8.WORD\[7\].W.BYTE\[3\].B.SEL0_B VGND VGND VPWR
+ VPWR SLICE_16\[0\].RAM16.BYTE\[3\].FLOATBUF0\[27\].Z sky130_fd_sc_hd__ebufn_2
XA0BUF\[1\].__cell__ A0[1] VGND VGND VPWR VPWR A0BUF\[1\].X sky130_fd_sc_hd__clkbuf_2
Xtap_25_29 VGND VPWR sky130_fd_sc_hd__tapvpwrvgnd_1
Xtap_25_18 VGND VPWR sky130_fd_sc_hd__tapvpwrvgnd_1
XSLICE_16\[1\].RAM16.SLICE\[0\].RAM8.WORD\[0\].W.BYTE\[3\].B.BIT\[1\].OBUF0 SLICE_16\[1\].RAM16.SLICE\[0\].RAM8.WORD\[0\].W.BYTE\[3\].B.Q_WIRE\[1\]
+ SLICE_16\[1\].RAM16.SLICE\[0\].RAM8.WORD\[0\].W.BYTE\[3\].B.SEL0_B VGND VGND VPWR
+ VPWR SLICE_16\[1\].RAM16.BYTE\[3\].FLOATBUF0\[25\].Z sky130_fd_sc_hd__ebufn_2
XSLICE_16\[1\].RAM16.SLICE\[0\].RAM8.WORD\[0\].W.BYTE\[2\].B.DIODE_CLK SLICE_16\[1\].RAM16.SLICE\[0\].RAM8.WORD\[0\].W.BYTE\[0\].B.CLK
+ VGND VGND VPWR VPWR sky130_fd_sc_hd__diode_2
XSLICE_16\[1\].RAM16.SLICE\[0\].RAM8.WORD\[4\].W.BYTE\[3\].B.BIT\[4\].genblk1.STORAGE
+ DIBUF\[28\].X SLICE_16\[1\].RAM16.SLICE\[0\].RAM8.WORD\[4\].W.BYTE\[3\].B.GCLK VGND
+ VGND VPWR VPWR SLICE_16\[1\].RAM16.SLICE\[0\].RAM8.WORD\[4\].W.BYTE\[3\].B.Q_WIRE\[4\]
+ sky130_fd_sc_hd__dlxtp_1
Xfill_8_0 VGND VPWR sky130_fd_sc_hd__tapvpwrvgnd_1
XSLICE_16\[1\].RAM16.SLICE\[0\].RAM8.WORD\[2\].W.BYTE\[1\].B.BIT\[3\].genblk1.STORAGE
+ DIBUF\[11\].X SLICE_16\[1\].RAM16.SLICE\[0\].RAM8.WORD\[2\].W.BYTE\[1\].B.GCLK VGND
+ VGND VPWR VPWR SLICE_16\[1\].RAM16.SLICE\[0\].RAM8.WORD\[2\].W.BYTE\[1\].B.Q_WIRE\[3\]
+ sky130_fd_sc_hd__dlxtp_1
XSLICE_16\[0\].RAM16.SLICE\[1\].RAM8.WORD\[6\].W.BYTE\[3\].B.BIT\[5\].genblk1.STORAGE
+ DIBUF\[29\].X SLICE_16\[0\].RAM16.SLICE\[1\].RAM8.WORD\[6\].W.BYTE\[3\].B.GCLK VGND
+ VGND VPWR VPWR SLICE_16\[0\].RAM16.SLICE\[1\].RAM8.WORD\[6\].W.BYTE\[3\].B.Q_WIRE\[5\]
+ sky130_fd_sc_hd__dlxtp_1
XSLICE_16\[0\].RAM16.SLICE\[0\].RAM8.WORD\[2\].W.BYTE\[2\].B.BIT\[2\].OBUF0 SLICE_16\[0\].RAM16.SLICE\[0\].RAM8.WORD\[2\].W.BYTE\[2\].B.Q_WIRE\[2\]
+ SLICE_16\[0\].RAM16.SLICE\[0\].RAM8.WORD\[2\].W.BYTE\[2\].B.SEL0_B VGND VGND VPWR
+ VPWR SLICE_16\[0\].RAM16.BYTE\[2\].FLOATBUF0\[18\].Z sky130_fd_sc_hd__ebufn_2
XSLICE_16\[1\].RAM16.Do0_REG.OUTREG_BYTE\[0\].DIODE\[3\] SLICE_16\[1\].RAM16.BYTE\[0\].FLOATBUF0\[3\].Z
+ VGND VGND VPWR VPWR sky130_fd_sc_hd__diode_2
Xtap_32_5 VGND VPWR sky130_fd_sc_hd__tapvpwrvgnd_1
Xtap_25_4 VGND VPWR sky130_fd_sc_hd__tapvpwrvgnd_1
Xtap_18_3 VGND VPWR sky130_fd_sc_hd__tapvpwrvgnd_1
XSLICE_16\[0\].RAM16.SLICE\[1\].RAM8.WORD\[4\].W.BYTE\[1\].B.BIT\[4\].genblk1.STORAGE
+ DIBUF\[12\].X SLICE_16\[0\].RAM16.SLICE\[1\].RAM8.WORD\[4\].W.BYTE\[1\].B.GCLK VGND
+ VGND VPWR VPWR SLICE_16\[0\].RAM16.SLICE\[1\].RAM8.WORD\[4\].W.BYTE\[1\].B.Q_WIRE\[4\]
+ sky130_fd_sc_hd__dlxtp_1
XSLICE_16\[0\].RAM16.SLICE\[0\].RAM8.WORD\[5\].W.BYTE\[3\].B.BIT\[0\].genblk1.STORAGE
+ DIBUF\[24\].X SLICE_16\[0\].RAM16.SLICE\[0\].RAM8.WORD\[5\].W.BYTE\[3\].B.GCLK VGND
+ VGND VPWR VPWR SLICE_16\[0\].RAM16.SLICE\[0\].RAM8.WORD\[5\].W.BYTE\[3\].B.Q_WIRE\[0\]
+ sky130_fd_sc_hd__dlxtp_1
XSLICE_16\[0\].RAM16.SLICE\[0\].RAM8.WORD\[3\].W.BYTE\[1\].B.DIODE_CLK SLICE_16\[0\].RAM16.SLICE\[0\].RAM8.WORD\[3\].W.BYTE\[0\].B.CLK
+ VGND VGND VPWR VPWR sky130_fd_sc_hd__diode_2
XSLICE_16\[0\].RAM16.SLICE\[1\].RAM8.WORD\[6\].W.BYTE\[1\].B.BIT\[0\].OBUF0 SLICE_16\[0\].RAM16.SLICE\[1\].RAM8.WORD\[6\].W.BYTE\[1\].B.Q_WIRE\[0\]
+ SLICE_16\[0\].RAM16.SLICE\[1\].RAM8.WORD\[6\].W.BYTE\[1\].B.SEL0_B VGND VGND VPWR
+ VPWR SLICE_16\[0\].RAM16.BYTE\[1\].FLOATBUF0\[8\].Z sky130_fd_sc_hd__ebufn_2
XSLICE_16\[1\].RAM16.SLICE\[1\].RAM8.WORD\[5\].W.BYTE\[2\].B.BIT\[7\].OBUF0 SLICE_16\[1\].RAM16.SLICE\[1\].RAM8.WORD\[5\].W.BYTE\[2\].B.Q_WIRE\[7\]
+ SLICE_16\[1\].RAM16.SLICE\[1\].RAM8.WORD\[5\].W.BYTE\[2\].B.SEL0_B VGND VGND VPWR
+ VPWR SLICE_16\[1\].RAM16.BYTE\[2\].FLOATBUF0\[23\].Z sky130_fd_sc_hd__ebufn_2
Xfill_46_7 VGND VPWR sky130_fd_sc_hd__tapvpwrvgnd_1
Xfill_39_6 VGND VPWR sky130_fd_sc_hd__tapvpwrvgnd_1
XSLICE_16\[0\].RAM16.Do0_REG.OUTREG_BYTE\[2\].DIODE\[0\] SLICE_16\[0\].RAM16.BYTE\[2\].FLOATBUF0\[16\].Z
+ VGND VGND VPWR VPWR sky130_fd_sc_hd__diode_2
XSLICE_16\[0\].RAM16.SLICE\[1\].RAM8.DEC0.AND7 SLICE_16\[0\].RAM16.SLICE\[1\].RAM8.DEC0.A_buf\[0\]
+ SLICE_16\[0\].RAM16.SLICE\[1\].RAM8.DEC0.A_buf\[1\] SLICE_16\[0\].RAM16.SLICE\[1\].RAM8.DEC0.A_buf\[2\]
+ SLICE_16\[0\].RAM16.SLICE\[1\].RAM8.DEC0.EN_buf VGND VGND VPWR VPWR SLICE_16\[0\].RAM16.SLICE\[1\].RAM8.DEC0.SEL\[7\]
+ sky130_fd_sc_hd__and4_2
Xfill_44_90 VGND VPWR sky130_fd_sc_hd__tapvpwrvgnd_1
XSLICE_16\[1\].RAM16.BYTE\[0\].FLOATBUF0\[0\].__cell__ SLICE_16\[1\].RAM16.BYTE\[0\].FLOATBUF0\[0\].A
+ SLICE_16\[1\].RAM16.BYTE\[0\].FLOATBUF0\[0\].TE_B VGND VGND VPWR VPWR SLICE_16\[1\].RAM16.BYTE\[0\].FLOATBUF0\[0\].Z
+ sky130_fd_sc_hd__ebufn_2
XSLICE_16\[1\].RAM16.SLICE\[0\].RAM8.WORD\[0\].W.BYTE\[1\].B.BIT\[6\].OBUF0 SLICE_16\[1\].RAM16.SLICE\[0\].RAM8.WORD\[0\].W.BYTE\[1\].B.Q_WIRE\[6\]
+ SLICE_16\[1\].RAM16.SLICE\[0\].RAM8.WORD\[0\].W.BYTE\[1\].B.SEL0_B VGND VGND VPWR
+ VPWR SLICE_16\[1\].RAM16.BYTE\[1\].FLOATBUF0\[14\].Z sky130_fd_sc_hd__ebufn_2
XSLICE_16\[0\].RAM16.SLICE\[0\].RAM8.WORD\[5\].W.BYTE\[3\].B.BIT\[2\].OBUF0 SLICE_16\[0\].RAM16.SLICE\[0\].RAM8.WORD\[5\].W.BYTE\[3\].B.Q_WIRE\[2\]
+ SLICE_16\[0\].RAM16.SLICE\[0\].RAM8.WORD\[5\].W.BYTE\[3\].B.SEL0_B VGND VGND VPWR
+ VPWR SLICE_16\[0\].RAM16.BYTE\[3\].FLOATBUF0\[26\].Z sky130_fd_sc_hd__ebufn_2
Xtap_36_28 VGND VPWR sky130_fd_sc_hd__tapvpwrvgnd_1
Xtap_36_17 VGND VPWR sky130_fd_sc_hd__tapvpwrvgnd_1
XSLICE_16\[0\].RAM16.SLICE\[0\].RAM8.WORD\[2\].W.BYTE\[0\].B.BIT\[7\].OBUF0 SLICE_16\[0\].RAM16.SLICE\[0\].RAM8.WORD\[2\].W.BYTE\[0\].B.Q_WIRE\[7\]
+ SLICE_16\[0\].RAM16.SLICE\[0\].RAM8.WORD\[2\].W.BYTE\[0\].B.SEL0_B VGND VGND VPWR
+ VPWR SLICE_16\[0\].RAM16.BYTE\[0\].FLOATBUF0\[7\].Z sky130_fd_sc_hd__ebufn_2
Xtap_4_9 VGND VPWR sky130_fd_sc_hd__tapvpwrvgnd_1
XSLICE_16\[1\].RAM16.SLICE\[1\].RAM8.WORD\[5\].W.BYTE\[1\].B.genblk1.CG SLICE_16\[1\].RAM16.SLICE\[1\].RAM8.WORD\[5\].W.BYTE\[1\].B.CLK_B
+ SLICE_16\[1\].RAM16.SLICE\[1\].RAM8.WORD\[5\].W.BYTE\[1\].B.WE0_WIRE VGND VGND VPWR
+ VPWR SLICE_16\[1\].RAM16.SLICE\[1\].RAM8.WORD\[5\].W.BYTE\[1\].B.GCLK sky130_fd_sc_hd__dlclkp_1
XSLICE_16\[1\].RAM16.SLICE\[1\].RAM8.WORD\[4\].W.BYTE\[0\].B.BIT\[4\].OBUF0 SLICE_16\[1\].RAM16.SLICE\[1\].RAM8.WORD\[4\].W.BYTE\[0\].B.Q_WIRE\[4\]
+ SLICE_16\[1\].RAM16.SLICE\[1\].RAM8.WORD\[4\].W.BYTE\[0\].B.SEL0_B VGND VGND VPWR
+ VPWR SLICE_16\[1\].RAM16.BYTE\[0\].FLOATBUF0\[4\].Z sky130_fd_sc_hd__ebufn_2
Xtap_7_10 VGND VPWR sky130_fd_sc_hd__tapvpwrvgnd_1
Xtap_7_21 VGND VPWR sky130_fd_sc_hd__tapvpwrvgnd_1
Xtap_7_32 VGND VPWR sky130_fd_sc_hd__tapvpwrvgnd_1
Xfill_40_26 VGND VPWR sky130_fd_sc_hd__tapvpwrvgnd_1
Xfill_40_15 VGND VPWR sky130_fd_sc_hd__tapvpwrvgnd_1
Xtap_30_2 VGND VPWR sky130_fd_sc_hd__tapvpwrvgnd_1
XSLICE_16\[1\].RAM16.SLICE\[1\].RAM8.WORD\[4\].W.BYTE\[0\].B.BIT\[7\].genblk1.STORAGE
+ DIBUF\[7\].X SLICE_16\[1\].RAM16.SLICE\[1\].RAM8.WORD\[4\].W.BYTE\[0\].B.GCLK VGND
+ VGND VPWR VPWR SLICE_16\[1\].RAM16.SLICE\[1\].RAM8.WORD\[4\].W.BYTE\[0\].B.Q_WIRE\[7\]
+ sky130_fd_sc_hd__dlxtp_1
Xtap_23_1 VGND VPWR sky130_fd_sc_hd__tapvpwrvgnd_1
Xtap_16_0 VGND VPWR sky130_fd_sc_hd__tapvpwrvgnd_1
XSLICE_16\[1\].RAM16.SLICE\[0\].RAM8.WORD\[5\].W.BYTE\[2\].B.BIT\[3\].genblk1.STORAGE
+ DIBUF\[19\].X SLICE_16\[1\].RAM16.SLICE\[0\].RAM8.WORD\[5\].W.BYTE\[2\].B.GCLK VGND
+ VGND VPWR VPWR SLICE_16\[1\].RAM16.SLICE\[0\].RAM8.WORD\[5\].W.BYTE\[2\].B.Q_WIRE\[3\]
+ sky130_fd_sc_hd__dlxtp_1
XSLICE_16\[1\].RAM16.SLICE\[0\].RAM8.WORD\[3\].W.BYTE\[2\].B.BIT\[6\].OBUF0 SLICE_16\[1\].RAM16.SLICE\[0\].RAM8.WORD\[3\].W.BYTE\[2\].B.Q_WIRE\[6\]
+ SLICE_16\[1\].RAM16.SLICE\[0\].RAM8.WORD\[3\].W.BYTE\[2\].B.SEL0_B VGND VGND VPWR
+ VPWR SLICE_16\[1\].RAM16.BYTE\[2\].FLOATBUF0\[22\].Z sky130_fd_sc_hd__ebufn_2
XSLICE_16\[1\].RAM16.SLICE\[0\].RAM8.WORD\[3\].W.BYTE\[0\].B.BIT\[2\].genblk1.STORAGE
+ DIBUF\[2\].X SLICE_16\[1\].RAM16.SLICE\[0\].RAM8.WORD\[3\].W.BYTE\[0\].B.GCLK VGND
+ VGND VPWR VPWR SLICE_16\[1\].RAM16.SLICE\[0\].RAM8.WORD\[3\].W.BYTE\[0\].B.Q_WIRE\[2\]
+ sky130_fd_sc_hd__dlxtp_1
XSLICE_16\[0\].RAM16.BYTE\[2\].FLOATBUF0\[17\].__cell__ SLICE_16\[0\].RAM16.BYTE\[2\].FLOATBUF0\[16\].A
+ SLICE_16\[0\].RAM16.BYTE\[2\].FLOATBUF0\[16\].TE_B VGND VGND VPWR VPWR SLICE_16\[0\].RAM16.BYTE\[2\].FLOATBUF0\[17\].Z
+ sky130_fd_sc_hd__ebufn_2
XSLICE_16\[0\].RAM16.SLICE\[1\].RAM8.WORD\[7\].W.BYTE\[2\].B.BIT\[4\].genblk1.STORAGE
+ DIBUF\[20\].X SLICE_16\[0\].RAM16.SLICE\[1\].RAM8.WORD\[7\].W.BYTE\[2\].B.GCLK VGND
+ VGND VPWR VPWR SLICE_16\[0\].RAM16.SLICE\[1\].RAM8.WORD\[7\].W.BYTE\[2\].B.Q_WIRE\[4\]
+ sky130_fd_sc_hd__dlxtp_1
XSLICE_16\[0\].RAM16.SLICE\[1\].RAM8.WORD\[5\].W.BYTE\[0\].B.BIT\[3\].genblk1.STORAGE
+ DIBUF\[3\].X SLICE_16\[0\].RAM16.SLICE\[1\].RAM8.WORD\[5\].W.BYTE\[0\].B.GCLK VGND
+ VGND VPWR VPWR SLICE_16\[0\].RAM16.SLICE\[1\].RAM8.WORD\[5\].W.BYTE\[0\].B.Q_WIRE\[3\]
+ sky130_fd_sc_hd__dlxtp_1
XSLICE_16\[0\].RAM16.SLICE\[1\].RAM8.WORD\[1\].W.BYTE\[3\].B.BIT\[5\].genblk1.STORAGE
+ DIBUF\[29\].X SLICE_16\[0\].RAM16.SLICE\[1\].RAM8.WORD\[1\].W.BYTE\[3\].B.GCLK VGND
+ VGND VPWR VPWR SLICE_16\[0\].RAM16.SLICE\[1\].RAM8.WORD\[1\].W.BYTE\[3\].B.Q_WIRE\[5\]
+ sky130_fd_sc_hd__dlxtp_1
XSLICE_16\[1\].RAM16.SLICE\[1\].RAM8.WORD\[2\].W.BYTE\[2\].B.DIODE_CLK SLICE_16\[1\].RAM16.SLICE\[1\].RAM8.WORD\[2\].W.BYTE\[0\].B.CLK
+ VGND VGND VPWR VPWR sky130_fd_sc_hd__diode_2
XSLICE_16\[0\].RAM16.Do0_REG.OUTREG_BYTE\[1\].Do_FF\[1\] SLICE_16\[0\].RAM16.Do0_REG.CLKBUF\[1\]
+ SLICE_16\[0\].RAM16.BYTE\[1\].FLOATBUF0\[9\].Z VGND VGND VPWR VPWR Do0MUX.A0\[9\]
+ sky130_fd_sc_hd__dfxtp_1
XSLICE_16\[0\].RAM16.SLICE\[0\].RAM8.WORD\[0\].W.BYTE\[3\].B.BIT\[0\].genblk1.STORAGE
+ DIBUF\[24\].X SLICE_16\[0\].RAM16.SLICE\[0\].RAM8.WORD\[0\].W.BYTE\[3\].B.GCLK VGND
+ VGND VPWR VPWR SLICE_16\[0\].RAM16.SLICE\[0\].RAM8.WORD\[0\].W.BYTE\[3\].B.Q_WIRE\[0\]
+ sky130_fd_sc_hd__dlxtp_1
Xfill_44_4 VGND VGND VPWR VPWR sky130_fd_sc_hd__decap_12
Xfill_37_3 VGND VGND VPWR VPWR sky130_fd_sc_hd__decap_6
XSLICE_16\[1\].RAM16.SLICE\[0\].RAM8.WORD\[3\].W.BYTE\[3\].B.SEL0INV SLICE_16\[1\].RAM16.SLICE\[0\].RAM8.WORD\[3\].W.BYTE\[0\].B.SEL0
+ VGND VGND VPWR VPWR SLICE_16\[1\].RAM16.SLICE\[0\].RAM8.WORD\[3\].W.BYTE\[3\].B.SEL0_B
+ sky130_fd_sc_hd__inv_1
XSLICE_16\[0\].RAM16.SLICE\[0\].RAM8.WORD\[5\].W.BYTE\[1\].B.BIT\[7\].OBUF0 SLICE_16\[0\].RAM16.SLICE\[0\].RAM8.WORD\[5\].W.BYTE\[1\].B.Q_WIRE\[7\]
+ SLICE_16\[0\].RAM16.SLICE\[0\].RAM8.WORD\[5\].W.BYTE\[1\].B.SEL0_B VGND VGND VPWR
+ VPWR SLICE_16\[0\].RAM16.BYTE\[1\].FLOATBUF0\[15\].Z sky130_fd_sc_hd__ebufn_2
XDo0MUX.M\[3\].MUX\[3\] Do0MUX.A0\[27\] Do0MUX.A1\[27\] Do0MUX.SEL\[3\] VGND VGND
+ VPWR VPWR Do0[27] sky130_fd_sc_hd__mux2_1
XSLICE_16\[1\].RAM16.SLICE\[1\].RAM8.WORD\[7\].W.BYTE\[1\].B.BIT\[4\].OBUF0 SLICE_16\[1\].RAM16.SLICE\[1\].RAM8.WORD\[7\].W.BYTE\[1\].B.Q_WIRE\[4\]
+ SLICE_16\[1\].RAM16.SLICE\[1\].RAM8.WORD\[7\].W.BYTE\[1\].B.SEL0_B VGND VGND VPWR
+ VPWR SLICE_16\[1\].RAM16.BYTE\[1\].FLOATBUF0\[12\].Z sky130_fd_sc_hd__ebufn_2
XSLICE_16\[1\].RAM16.SLICE\[0\].RAM8.WORD\[2\].W.BYTE\[0\].B.BIT\[3\].OBUF0 SLICE_16\[1\].RAM16.SLICE\[0\].RAM8.WORD\[2\].W.BYTE\[0\].B.Q_WIRE\[3\]
+ SLICE_16\[1\].RAM16.SLICE\[0\].RAM8.WORD\[2\].W.BYTE\[0\].B.SEL0_B VGND VGND VPWR
+ VPWR SLICE_16\[1\].RAM16.BYTE\[0\].FLOATBUF0\[3\].Z sky130_fd_sc_hd__ebufn_2
Xfill_19_49 VGND VGND VPWR VPWR sky130_fd_sc_hd__decap_12
Xfill_19_38 VGND VGND VPWR VPWR sky130_fd_sc_hd__decap_12
Xfill_19_27 VGND VPWR sky130_fd_sc_hd__tapvpwrvgnd_1
Xfill_19_16 VGND VGND VPWR VPWR sky130_fd_sc_hd__decap_12
XSLICE_16\[0\].RAM16.SLICE\[1\].RAM8.WORD\[5\].W.BYTE\[1\].B.DIODE_CLK SLICE_16\[0\].RAM16.SLICE\[1\].RAM8.WORD\[5\].W.BYTE\[0\].B.CLK
+ VGND VGND VPWR VPWR sky130_fd_sc_hd__diode_2
XSLICE_16\[1\].RAM16.SLICE\[0\].RAM8.WORD\[6\].W.BYTE\[3\].B.BIT\[6\].OBUF0 SLICE_16\[1\].RAM16.SLICE\[0\].RAM8.WORD\[6\].W.BYTE\[3\].B.Q_WIRE\[6\]
+ SLICE_16\[1\].RAM16.SLICE\[0\].RAM8.WORD\[6\].W.BYTE\[3\].B.SEL0_B VGND VGND VPWR
+ VPWR SLICE_16\[1\].RAM16.BYTE\[3\].FLOATBUF0\[30\].Z sky130_fd_sc_hd__ebufn_2
Xtap_2_6 VGND VPWR sky130_fd_sc_hd__tapvpwrvgnd_1
Xfill_20_100 VGND VGND VPWR VPWR sky130_fd_sc_hd__decap_12
Xtap_12_30 VGND VPWR sky130_fd_sc_hd__tapvpwrvgnd_1
XSLICE_16\[0\].RAM16.SLICE\[0\].RAM8.WORD\[3\].W.BYTE\[0\].B.CGAND SLICE_16\[0\].RAM16.SLICE\[0\].RAM8.WORD\[3\].W.BYTE\[0\].B.SEL0
+ SLICE_16\[0\].RAM16.SLICE\[0\].RAM8.WE0_buf\[0\] VGND VGND VPWR VPWR SLICE_16\[0\].RAM16.SLICE\[0\].RAM8.WORD\[3\].W.BYTE\[0\].B.WE0_WIRE
+ sky130_fd_sc_hd__and2_1
XDo0MUX.M\[2\].MUX\[5\] Do0MUX.A0\[21\] Do0MUX.A1\[21\] Do0MUX.SEL\[2\] VGND VGND
+ VPWR VPWR Do0[21] sky130_fd_sc_hd__mux2_1
Xfill_16_8 VGND VPWR sky130_fd_sc_hd__tapvpwrvgnd_1
Xfill_41_91 VGND VGND VPWR VPWR sky130_fd_sc_hd__decap_12
Xfill_41_80 VGND VGND VPWR VPWR sky130_fd_sc_hd__decap_12
XSLICE_16\[1\].RAM16.SLICE\[1\].RAM8.WORD\[7\].W.BYTE\[1\].B.BIT\[7\].genblk1.STORAGE
+ DIBUF\[15\].X SLICE_16\[1\].RAM16.SLICE\[1\].RAM8.WORD\[7\].W.BYTE\[1\].B.GCLK VGND
+ VGND VPWR VPWR SLICE_16\[1\].RAM16.SLICE\[1\].RAM8.WORD\[7\].W.BYTE\[1\].B.Q_WIRE\[7\]
+ sky130_fd_sc_hd__dlxtp_1
Xfill_42_1 VGND VGND VPWR VPWR sky130_fd_sc_hd__decap_12
XSLICE_16\[1\].RAM16.SLICE\[0\].RAM8.WORD\[6\].W.BYTE\[1\].B.BIT\[2\].genblk1.STORAGE
+ DIBUF\[10\].X SLICE_16\[1\].RAM16.SLICE\[0\].RAM8.WORD\[6\].W.BYTE\[1\].B.GCLK VGND
+ VGND VPWR VPWR SLICE_16\[1\].RAM16.SLICE\[0\].RAM8.WORD\[6\].W.BYTE\[1\].B.Q_WIRE\[2\]
+ sky130_fd_sc_hd__dlxtp_1
XSLICE_16\[1\].RAM16.SLICE\[0\].RAM8.WORD\[5\].W.BYTE\[1\].B.BIT\[3\].OBUF0 SLICE_16\[1\].RAM16.SLICE\[0\].RAM8.WORD\[5\].W.BYTE\[1\].B.Q_WIRE\[3\]
+ SLICE_16\[1\].RAM16.SLICE\[0\].RAM8.WORD\[5\].W.BYTE\[1\].B.SEL0_B VGND VGND VPWR
+ VPWR SLICE_16\[1\].RAM16.BYTE\[1\].FLOATBUF0\[11\].Z sky130_fd_sc_hd__ebufn_2
XSLICE_16\[0\].RAM16.SLICE\[1\].RAM8.WORD\[2\].W.BYTE\[3\].B.BIT\[2\].OBUF0 SLICE_16\[0\].RAM16.SLICE\[1\].RAM8.WORD\[2\].W.BYTE\[3\].B.Q_WIRE\[2\]
+ SLICE_16\[0\].RAM16.SLICE\[1\].RAM8.WORD\[2\].W.BYTE\[3\].B.SEL0_B VGND VGND VPWR
+ VPWR SLICE_16\[0\].RAM16.BYTE\[3\].FLOATBUF0\[26\].Z sky130_fd_sc_hd__ebufn_2
XDo0MUX.M\[1\].MUX\[7\] Do0MUX.A0\[15\] Do0MUX.A1\[15\] Do0MUX.SEL\[1\] VGND VGND
+ VPWR VPWR Do0[15] sky130_fd_sc_hd__mux2_1
Xfill_35_0 VGND VPWR sky130_fd_sc_hd__tapvpwrvgnd_1
Xtap_33_29 VGND VPWR sky130_fd_sc_hd__tapvpwrvgnd_1
Xtap_33_18 VGND VPWR sky130_fd_sc_hd__tapvpwrvgnd_1
XSLICE_16\[1\].RAM16.SLICE\[0\].RAM8.WORD\[0\].W.BYTE\[3\].B.genblk1.CLKINV SLICE_16\[1\].RAM16.SLICE\[0\].RAM8.WORD\[0\].W.BYTE\[0\].B.CLK
+ VGND VGND VPWR VPWR SLICE_16\[1\].RAM16.SLICE\[0\].RAM8.WORD\[0\].W.BYTE\[3\].B.CLK_B
+ sky130_fd_sc_hd__inv_1
XSLICE_16\[1\].RAM16.SLICE\[0\].RAM8.WORD\[0\].W.BYTE\[2\].B.BIT\[3\].genblk1.STORAGE
+ DIBUF\[19\].X SLICE_16\[1\].RAM16.SLICE\[0\].RAM8.WORD\[0\].W.BYTE\[2\].B.GCLK VGND
+ VGND VPWR VPWR SLICE_16\[1\].RAM16.SLICE\[0\].RAM8.WORD\[0\].W.BYTE\[2\].B.Q_WIRE\[3\]
+ sky130_fd_sc_hd__dlxtp_1
XSLICE_16\[0\].RAM16.SLICE\[1\].RAM8.WORD\[2\].W.BYTE\[2\].B.BIT\[4\].genblk1.STORAGE
+ DIBUF\[20\].X SLICE_16\[0\].RAM16.SLICE\[1\].RAM8.WORD\[2\].W.BYTE\[2\].B.GCLK VGND
+ VGND VPWR VPWR SLICE_16\[0\].RAM16.SLICE\[1\].RAM8.WORD\[2\].W.BYTE\[2\].B.Q_WIRE\[4\]
+ sky130_fd_sc_hd__dlxtp_1
Xfill_21_28 VGND VGND VPWR VPWR sky130_fd_sc_hd__decap_12
Xfill_21_17 VGND VGND VPWR VPWR sky130_fd_sc_hd__decap_12
XSLICE_16\[0\].RAM16.SLICE\[0\].RAM8.WORD\[7\].W.BYTE\[0\].B.BIT\[4\].OBUF0 SLICE_16\[0\].RAM16.SLICE\[0\].RAM8.WORD\[7\].W.BYTE\[0\].B.Q_WIRE\[4\]
+ SLICE_16\[0\].RAM16.SLICE\[0\].RAM8.WORD\[7\].W.BYTE\[0\].B.SEL0_B VGND VGND VPWR
+ VPWR SLICE_16\[0\].RAM16.BYTE\[0\].FLOATBUF0\[4\].Z sky130_fd_sc_hd__ebufn_2
XSLICE_16\[0\].RAM16.SLICE\[1\].RAM8.WORD\[0\].W.BYTE\[0\].B.BIT\[3\].genblk1.STORAGE
+ DIBUF\[3\].X SLICE_16\[0\].RAM16.SLICE\[1\].RAM8.WORD\[0\].W.BYTE\[0\].B.GCLK VGND
+ VGND VPWR VPWR SLICE_16\[0\].RAM16.SLICE\[1\].RAM8.WORD\[0\].W.BYTE\[0\].B.Q_WIRE\[3\]
+ sky130_fd_sc_hd__dlxtp_1
Xfill_21_39 VGND VPWR sky130_fd_sc_hd__tapvpwrvgnd_1
Xtap_4_11 VGND VPWR sky130_fd_sc_hd__tapvpwrvgnd_1
Xtap_4_22 VGND VPWR sky130_fd_sc_hd__tapvpwrvgnd_1
Xtap_4_33 VGND VPWR sky130_fd_sc_hd__tapvpwrvgnd_1
Xfill_46_69 VGND VGND VPWR VPWR sky130_fd_sc_hd__decap_4
Xfill_46_58 VGND VGND VPWR VPWR sky130_fd_sc_hd__decap_4
Xfill_46_47 VGND VPWR sky130_fd_sc_hd__tapvpwrvgnd_1
Xfill_46_36 VGND VPWR sky130_fd_sc_hd__tapvpwrvgnd_1
Xfill_46_25 VGND VGND VPWR VPWR sky130_fd_sc_hd__decap_4
Xfill_46_14 VGND VPWR sky130_fd_sc_hd__tapvpwrvgnd_1
Xtap_0_3 VGND VPWR sky130_fd_sc_hd__tapvpwrvgnd_1
XSLICE_16\[1\].RAM16.SLICE\[1\].RAM8.WORD\[0\].W.BYTE\[2\].B.BIT\[6\].OBUF0 SLICE_16\[1\].RAM16.SLICE\[1\].RAM8.WORD\[0\].W.BYTE\[2\].B.Q_WIRE\[6\]
+ SLICE_16\[1\].RAM16.SLICE\[1\].RAM8.WORD\[0\].W.BYTE\[2\].B.SEL0_B VGND VGND VPWR
+ VPWR SLICE_16\[1\].RAM16.BYTE\[2\].FLOATBUF0\[22\].Z sky130_fd_sc_hd__ebufn_2
Xfill_21_6 VGND VPWR sky130_fd_sc_hd__tapvpwrvgnd_1
Xfill_14_5 VGND VPWR sky130_fd_sc_hd__tapvpwrvgnd_1
XSLICE_16\[0\].RAM16.SLICE\[0\].RAM8.WORD\[0\].W.BYTE\[3\].B.BIT\[1\].OBUF0 SLICE_16\[0\].RAM16.SLICE\[0\].RAM8.WORD\[0\].W.BYTE\[3\].B.Q_WIRE\[1\]
+ SLICE_16\[0\].RAM16.SLICE\[0\].RAM8.WORD\[0\].W.BYTE\[3\].B.SEL0_B VGND VGND VPWR
+ VPWR SLICE_16\[0\].RAM16.BYTE\[3\].FLOATBUF0\[25\].Z sky130_fd_sc_hd__ebufn_2
XSLICE_16\[0\].RAM16.SLICE\[1\].RAM8.WORD\[2\].W.BYTE\[1\].B.BIT\[7\].OBUF0 SLICE_16\[0\].RAM16.SLICE\[1\].RAM8.WORD\[2\].W.BYTE\[1\].B.Q_WIRE\[7\]
+ SLICE_16\[0\].RAM16.SLICE\[1\].RAM8.WORD\[2\].W.BYTE\[1\].B.SEL0_B VGND VGND VPWR
+ VPWR SLICE_16\[0\].RAM16.BYTE\[1\].FLOATBUF0\[15\].Z sky130_fd_sc_hd__ebufn_2
XSLICE_16\[1\].RAM16.SLICE\[0\].RAM8.WORD\[7\].W.BYTE\[1\].B.SEL0INV SLICE_16\[1\].RAM16.SLICE\[0\].RAM8.WORD\[7\].W.BYTE\[0\].B.SEL0
+ VGND VGND VPWR VPWR SLICE_16\[1\].RAM16.SLICE\[0\].RAM8.WORD\[7\].W.BYTE\[1\].B.SEL0_B
+ sky130_fd_sc_hd__inv_1
Xtap_28_29 VGND VPWR sky130_fd_sc_hd__tapvpwrvgnd_1
Xtap_28_18 VGND VPWR sky130_fd_sc_hd__tapvpwrvgnd_1
XSLICE_16\[1\].RAM16.SLICE\[0\].RAM8.WORD\[7\].W.BYTE\[0\].B.BIT\[0\].OBUF0 SLICE_16\[1\].RAM16.SLICE\[0\].RAM8.WORD\[7\].W.BYTE\[0\].B.Q_WIRE\[0\]
+ SLICE_16\[1\].RAM16.SLICE\[0\].RAM8.WORD\[7\].W.BYTE\[0\].B.SEL0_B VGND VGND VPWR
+ VPWR SLICE_16\[1\].RAM16.BYTE\[0\].FLOATBUF0\[0\].Z sky130_fd_sc_hd__ebufn_2
XSLICE_16\[1\].RAM16.SLICE\[1\].RAM8.WORD\[2\].W.BYTE\[1\].B.BIT\[7\].genblk1.STORAGE
+ DIBUF\[15\].X SLICE_16\[1\].RAM16.SLICE\[1\].RAM8.WORD\[2\].W.BYTE\[1\].B.GCLK VGND
+ VGND VPWR VPWR SLICE_16\[1\].RAM16.SLICE\[1\].RAM8.WORD\[2\].W.BYTE\[1\].B.Q_WIRE\[7\]
+ sky130_fd_sc_hd__dlxtp_1
XSLICE_16\[1\].RAM16.SLICE\[0\].RAM8.WORD\[3\].W.BYTE\[3\].B.BIT\[3\].genblk1.STORAGE
+ DIBUF\[27\].X SLICE_16\[1\].RAM16.SLICE\[0\].RAM8.WORD\[3\].W.BYTE\[3\].B.GCLK VGND
+ VGND VPWR VPWR SLICE_16\[1\].RAM16.SLICE\[0\].RAM8.WORD\[3\].W.BYTE\[3\].B.Q_WIRE\[3\]
+ sky130_fd_sc_hd__dlxtp_1
XSLICE_16\[1\].RAM16.SLICE\[1\].RAM8.WORD\[3\].W.BYTE\[3\].B.BIT\[6\].OBUF0 SLICE_16\[1\].RAM16.SLICE\[1\].RAM8.WORD\[3\].W.BYTE\[3\].B.Q_WIRE\[6\]
+ SLICE_16\[1\].RAM16.SLICE\[1\].RAM8.WORD\[3\].W.BYTE\[3\].B.SEL0_B VGND VGND VPWR
+ VPWR SLICE_16\[1\].RAM16.BYTE\[3\].FLOATBUF0\[30\].Z sky130_fd_sc_hd__ebufn_2
XSLICE_16\[1\].RAM16.SLICE\[0\].RAM8.WORD\[7\].W.BYTE\[0\].B.BIT\[1\].genblk1.STORAGE
+ DIBUF\[1\].X SLICE_16\[1\].RAM16.SLICE\[0\].RAM8.WORD\[7\].W.BYTE\[0\].B.GCLK VGND
+ VGND VPWR VPWR SLICE_16\[1\].RAM16.SLICE\[0\].RAM8.WORD\[7\].W.BYTE\[0\].B.Q_WIRE\[1\]
+ sky130_fd_sc_hd__dlxtp_1
XSLICE_16\[1\].RAM16.SLICE\[0\].RAM8.WORD\[1\].W.BYTE\[1\].B.BIT\[2\].genblk1.STORAGE
+ DIBUF\[10\].X SLICE_16\[1\].RAM16.SLICE\[0\].RAM8.WORD\[1\].W.BYTE\[1\].B.GCLK VGND
+ VGND VPWR VPWR SLICE_16\[1\].RAM16.SLICE\[0\].RAM8.WORD\[1\].W.BYTE\[1\].B.Q_WIRE\[2\]
+ sky130_fd_sc_hd__dlxtp_1
XSLICE_16\[0\].RAM16.SLICE\[1\].RAM8.WORD\[5\].W.BYTE\[3\].B.BIT\[4\].genblk1.STORAGE
+ DIBUF\[28\].X SLICE_16\[0\].RAM16.SLICE\[1\].RAM8.WORD\[5\].W.BYTE\[3\].B.GCLK VGND
+ VGND VPWR VPWR SLICE_16\[0\].RAM16.SLICE\[1\].RAM8.WORD\[5\].W.BYTE\[3\].B.Q_WIRE\[4\]
+ sky130_fd_sc_hd__dlxtp_1
XSLICE_16\[0\].RAM16.SLICE\[1\].RAM8.WORD\[4\].W.BYTE\[1\].B.genblk1.CG SLICE_16\[0\].RAM16.SLICE\[1\].RAM8.WORD\[4\].W.BYTE\[1\].B.CLK_B
+ SLICE_16\[0\].RAM16.SLICE\[1\].RAM8.WORD\[4\].W.BYTE\[1\].B.WE0_WIRE VGND VGND VPWR
+ VPWR SLICE_16\[0\].RAM16.SLICE\[1\].RAM8.WORD\[4\].W.BYTE\[1\].B.GCLK sky130_fd_sc_hd__dlclkp_1
XSLICE_16\[0\].RAM16.SLICE\[1\].RAM8.WORD\[3\].W.BYTE\[1\].B.BIT\[3\].genblk1.STORAGE
+ DIBUF\[11\].X SLICE_16\[0\].RAM16.SLICE\[1\].RAM8.WORD\[3\].W.BYTE\[1\].B.GCLK VGND
+ VGND VPWR VPWR SLICE_16\[0\].RAM16.SLICE\[1\].RAM8.WORD\[3\].W.BYTE\[1\].B.Q_WIRE\[3\]
+ sky130_fd_sc_hd__dlxtp_1
XSLICE_16\[1\].RAM16.SLICE\[1\].RAM8.DEC0.AND4 SLICE_16\[1\].RAM16.SLICE\[1\].RAM8.DEC0.A_buf\[0\]
+ SLICE_16\[1\].RAM16.SLICE\[1\].RAM8.DEC0.A_buf\[1\] SLICE_16\[1\].RAM16.SLICE\[1\].RAM8.DEC0.A_buf\[2\]
+ SLICE_16\[1\].RAM16.SLICE\[1\].RAM8.DEC0.EN_buf VGND VGND VPWR VPWR SLICE_16\[1\].RAM16.SLICE\[1\].RAM8.DEC0.SEL\[4\]
+ sky130_fd_sc_hd__and4bb_2
XSLICE_16\[0\].RAM16.SLICE\[1\].RAM8.WORD\[5\].W.BYTE\[2\].B.BIT\[7\].OBUF0 SLICE_16\[0\].RAM16.SLICE\[1\].RAM8.WORD\[5\].W.BYTE\[2\].B.Q_WIRE\[7\]
+ SLICE_16\[0\].RAM16.SLICE\[1\].RAM8.WORD\[5\].W.BYTE\[2\].B.SEL0_B VGND VGND VPWR
+ VPWR SLICE_16\[0\].RAM16.BYTE\[2\].FLOATBUF0\[23\].Z sky130_fd_sc_hd__ebufn_2
XSLICE_16\[0\].RAM16.SLICE\[0\].RAM8.WORD\[5\].W.BYTE\[2\].B.SEL0INV SLICE_16\[0\].RAM16.SLICE\[0\].RAM8.WORD\[5\].W.BYTE\[0\].B.SEL0
+ VGND VGND VPWR VPWR SLICE_16\[0\].RAM16.SLICE\[0\].RAM8.WORD\[5\].W.BYTE\[2\].B.SEL0_B
+ sky130_fd_sc_hd__inv_1
XSLICE_16\[1\].RAM16.SLICE\[0\].RAM8.WORD\[1\].W.CLKBUF SLICE_16\[1\].RAM16.SLICE\[0\].RAM8.CLKBUF.X
+ VGND VGND VPWR VPWR SLICE_16\[1\].RAM16.SLICE\[0\].RAM8.WORD\[1\].W.BYTE\[0\].B.CLK
+ sky130_fd_sc_hd__clkbuf_4
Xfill_22_93 VGND VPWR sky130_fd_sc_hd__tapvpwrvgnd_1
Xfill_22_82 VGND VGND VPWR VPWR sky130_fd_sc_hd__decap_12
Xfill_22_71 VGND VGND VPWR VPWR sky130_fd_sc_hd__decap_12
Xfill_22_60 VGND VPWR sky130_fd_sc_hd__tapvpwrvgnd_1
XSLICE_16\[0\].RAM16.SLICE\[0\].RAM8.WORD\[0\].W.BYTE\[1\].B.BIT\[6\].OBUF0 SLICE_16\[0\].RAM16.SLICE\[0\].RAM8.WORD\[0\].W.BYTE\[1\].B.Q_WIRE\[6\]
+ SLICE_16\[0\].RAM16.SLICE\[0\].RAM8.WORD\[0\].W.BYTE\[1\].B.SEL0_B VGND VGND VPWR
+ VPWR SLICE_16\[0\].RAM16.BYTE\[1\].FLOATBUF0\[14\].Z sky130_fd_sc_hd__ebufn_2
XSLICE_16\[1\].RAM16.SLICE\[1\].RAM8.WORD\[2\].W.BYTE\[1\].B.BIT\[3\].OBUF0 SLICE_16\[1\].RAM16.SLICE\[1\].RAM8.WORD\[2\].W.BYTE\[1\].B.Q_WIRE\[3\]
+ SLICE_16\[1\].RAM16.SLICE\[1\].RAM8.WORD\[2\].W.BYTE\[1\].B.SEL0_B VGND VGND VPWR
+ VPWR SLICE_16\[1\].RAM16.BYTE\[1\].FLOATBUF0\[11\].Z sky130_fd_sc_hd__ebufn_2
XSLICE_16\[1\].RAM16.SLICE\[0\].RAM8.WORD\[5\].W.BYTE\[3\].B.CGAND SLICE_16\[1\].RAM16.SLICE\[0\].RAM8.WORD\[5\].W.BYTE\[0\].B.SEL0
+ SLICE_16\[1\].RAM16.SLICE\[0\].RAM8.WE0_buf\[3\] VGND VGND VPWR VPWR SLICE_16\[1\].RAM16.SLICE\[0\].RAM8.WORD\[5\].W.BYTE\[3\].B.WE0_WIRE
+ sky130_fd_sc_hd__and2_1
Xfill_12_2 VGND VGND VPWR VPWR sky130_fd_sc_hd__fill_2
Xtap_30_19 VGND VPWR sky130_fd_sc_hd__tapvpwrvgnd_1
Xtap_34_9 VGND VPWR sky130_fd_sc_hd__tapvpwrvgnd_1
XSLICE_16\[1\].RAM16.SLICE\[1\].RAM8.WORD\[1\].W.BYTE\[0\].B.genblk1.CG SLICE_16\[1\].RAM16.SLICE\[1\].RAM8.WORD\[1\].W.BYTE\[0\].B.CLK_B
+ SLICE_16\[1\].RAM16.SLICE\[1\].RAM8.WORD\[1\].W.BYTE\[0\].B.WE0_WIRE VGND VGND VPWR
+ VPWR SLICE_16\[1\].RAM16.SLICE\[1\].RAM8.WORD\[1\].W.BYTE\[0\].B.GCLK sky130_fd_sc_hd__dlclkp_1
Xtap_27_8 VGND VPWR sky130_fd_sc_hd__tapvpwrvgnd_1
Xtap_1_34 VGND VPWR sky130_fd_sc_hd__tapvpwrvgnd_1
Xtap_1_23 VGND VPWR sky130_fd_sc_hd__tapvpwrvgnd_1
Xtap_1_12 VGND VPWR sky130_fd_sc_hd__tapvpwrvgnd_1
XSLICE_16\[0\].RAM16.SLICE\[1\].RAM8.WORD\[4\].W.BYTE\[0\].B.BIT\[4\].OBUF0 SLICE_16\[0\].RAM16.SLICE\[1\].RAM8.WORD\[4\].W.BYTE\[0\].B.Q_WIRE\[4\]
+ SLICE_16\[0\].RAM16.SLICE\[1\].RAM8.WORD\[4\].W.BYTE\[0\].B.SEL0_B VGND VGND VPWR
+ VPWR SLICE_16\[0\].RAM16.BYTE\[0\].FLOATBUF0\[4\].Z sky130_fd_sc_hd__ebufn_2
Xfill_43_59 VGND VGND VPWR VPWR sky130_fd_sc_hd__decap_12
Xfill_43_48 VGND VPWR sky130_fd_sc_hd__tapvpwrvgnd_1
Xfill_43_37 VGND VGND VPWR VPWR sky130_fd_sc_hd__decap_12
Xfill_43_26 VGND VGND VPWR VPWR sky130_fd_sc_hd__decap_12
Xfill_43_15 VGND VPWR sky130_fd_sc_hd__tapvpwrvgnd_1
XSLICE_16\[1\].RAM16.SLICE\[0\].RAM8.WORD\[1\].W.BYTE\[3\].B.BIT\[5\].OBUF0 SLICE_16\[1\].RAM16.SLICE\[0\].RAM8.WORD\[1\].W.BYTE\[3\].B.Q_WIRE\[5\]
+ SLICE_16\[1\].RAM16.SLICE\[0\].RAM8.WORD\[1\].W.BYTE\[3\].B.SEL0_B VGND VGND VPWR
+ VPWR SLICE_16\[1\].RAM16.BYTE\[3\].FLOATBUF0\[29\].Z sky130_fd_sc_hd__ebufn_2
XSLICE_16\[0\].RAM16.SLICE\[0\].RAM8.WORD\[3\].W.BYTE\[2\].B.BIT\[6\].OBUF0 SLICE_16\[0\].RAM16.SLICE\[0\].RAM8.WORD\[3\].W.BYTE\[2\].B.Q_WIRE\[6\]
+ SLICE_16\[0\].RAM16.SLICE\[0\].RAM8.WORD\[3\].W.BYTE\[2\].B.SEL0_B VGND VGND VPWR
+ VPWR SLICE_16\[0\].RAM16.BYTE\[2\].FLOATBUF0\[22\].Z sky130_fd_sc_hd__ebufn_2
XSLICE_16\[1\].RAM16.SLICE\[1\].RAM8.WORD\[5\].W.BYTE\[2\].B.BIT\[7\].genblk1.STORAGE
+ DIBUF\[23\].X SLICE_16\[1\].RAM16.SLICE\[1\].RAM8.WORD\[5\].W.BYTE\[2\].B.GCLK VGND
+ VGND VPWR VPWR SLICE_16\[1\].RAM16.SLICE\[1\].RAM8.WORD\[5\].W.BYTE\[2\].B.Q_WIRE\[7\]
+ sky130_fd_sc_hd__dlxtp_1
XSLICE_16\[1\].RAM16.SLICE\[1\].RAM8.WORD\[5\].W.BYTE\[2\].B.BIT\[3\].OBUF0 SLICE_16\[1\].RAM16.SLICE\[1\].RAM8.WORD\[5\].W.BYTE\[2\].B.Q_WIRE\[3\]
+ SLICE_16\[1\].RAM16.SLICE\[1\].RAM8.WORD\[5\].W.BYTE\[2\].B.SEL0_B VGND VGND VPWR
+ VPWR SLICE_16\[1\].RAM16.BYTE\[2\].FLOATBUF0\[19\].Z sky130_fd_sc_hd__ebufn_2
XSLICE_16\[1\].RAM16.SLICE\[1\].RAM8.WORD\[3\].W.BYTE\[0\].B.BIT\[6\].genblk1.STORAGE
+ DIBUF\[6\].X SLICE_16\[1\].RAM16.SLICE\[1\].RAM8.WORD\[3\].W.BYTE\[0\].B.GCLK VGND
+ VGND VPWR VPWR SLICE_16\[1\].RAM16.SLICE\[1\].RAM8.WORD\[3\].W.BYTE\[0\].B.Q_WIRE\[6\]
+ sky130_fd_sc_hd__dlxtp_1
Xfill_17_60 VGND VPWR sky130_fd_sc_hd__tapvpwrvgnd_1
XSLICE_16\[1\].RAM16.SLICE\[0\].RAM8.WORD\[4\].W.BYTE\[2\].B.BIT\[2\].genblk1.STORAGE
+ DIBUF\[18\].X SLICE_16\[1\].RAM16.SLICE\[0\].RAM8.WORD\[4\].W.BYTE\[2\].B.GCLK VGND
+ VGND VPWR VPWR SLICE_16\[1\].RAM16.SLICE\[0\].RAM8.WORD\[4\].W.BYTE\[2\].B.Q_WIRE\[2\]
+ sky130_fd_sc_hd__dlxtp_1
XSLICE_16\[1\].RAM16.SLICE\[0\].RAM8.WORD\[2\].W.BYTE\[0\].B.BIT\[1\].genblk1.STORAGE
+ DIBUF\[1\].X SLICE_16\[1\].RAM16.SLICE\[0\].RAM8.WORD\[2\].W.BYTE\[0\].B.GCLK VGND
+ VGND VPWR VPWR SLICE_16\[1\].RAM16.SLICE\[0\].RAM8.WORD\[2\].W.BYTE\[0\].B.Q_WIRE\[1\]
+ sky130_fd_sc_hd__dlxtp_1
XSLICE_16\[1\].RAM16.SLICE\[0\].RAM8.WORD\[0\].W.BYTE\[1\].B.BIT\[2\].OBUF0 SLICE_16\[1\].RAM16.SLICE\[0\].RAM8.WORD\[0\].W.BYTE\[1\].B.Q_WIRE\[2\]
+ SLICE_16\[1\].RAM16.SLICE\[0\].RAM8.WORD\[0\].W.BYTE\[1\].B.SEL0_B VGND VGND VPWR
+ VPWR SLICE_16\[1\].RAM16.BYTE\[1\].FLOATBUF0\[10\].Z sky130_fd_sc_hd__ebufn_2
XSLICE_16\[0\].RAM16.SLICE\[1\].RAM8.WORD\[7\].W.BYTE\[1\].B.BIT\[4\].OBUF0 SLICE_16\[0\].RAM16.SLICE\[1\].RAM8.WORD\[7\].W.BYTE\[1\].B.Q_WIRE\[4\]
+ SLICE_16\[0\].RAM16.SLICE\[1\].RAM8.WORD\[7\].W.BYTE\[1\].B.SEL0_B VGND VGND VPWR
+ VPWR SLICE_16\[0\].RAM16.BYTE\[1\].FLOATBUF0\[12\].Z sky130_fd_sc_hd__ebufn_2
XSLICE_16\[0\].RAM16.SLICE\[1\].RAM8.WORD\[6\].W.BYTE\[2\].B.BIT\[3\].genblk1.STORAGE
+ DIBUF\[19\].X SLICE_16\[0\].RAM16.SLICE\[1\].RAM8.WORD\[6\].W.BYTE\[2\].B.GCLK VGND
+ VGND VPWR VPWR SLICE_16\[0\].RAM16.SLICE\[1\].RAM8.WORD\[6\].W.BYTE\[2\].B.Q_WIRE\[3\]
+ sky130_fd_sc_hd__dlxtp_1
XSLICE_16\[0\].RAM16.SLICE\[1\].RAM8.WORD\[0\].W.BYTE\[3\].B.BIT\[4\].genblk1.STORAGE
+ DIBUF\[28\].X SLICE_16\[0\].RAM16.SLICE\[1\].RAM8.WORD\[0\].W.BYTE\[3\].B.GCLK VGND
+ VGND VPWR VPWR SLICE_16\[0\].RAM16.SLICE\[1\].RAM8.WORD\[0\].W.BYTE\[3\].B.Q_WIRE\[4\]
+ sky130_fd_sc_hd__dlxtp_1
Xtap_25_19 VGND VPWR sky130_fd_sc_hd__tapvpwrvgnd_1
XSLICE_16\[0\].RAM16.SLICE\[1\].RAM8.WORD\[4\].W.BYTE\[0\].B.BIT\[2\].genblk1.STORAGE
+ DIBUF\[2\].X SLICE_16\[0\].RAM16.SLICE\[1\].RAM8.WORD\[4\].W.BYTE\[0\].B.GCLK VGND
+ VGND VPWR VPWR SLICE_16\[0\].RAM16.SLICE\[1\].RAM8.WORD\[4\].W.BYTE\[0\].B.Q_WIRE\[2\]
+ sky130_fd_sc_hd__dlxtp_1
XSLICE_16\[1\].RAM16.Do0_REG.OUTREG_BYTE\[1\].DIODE\[7\] SLICE_16\[1\].RAM16.BYTE\[1\].FLOATBUF0\[15\].Z
+ VGND VGND VPWR VPWR sky130_fd_sc_hd__diode_2
XSLICE_16\[1\].RAM16.SLICE\[1\].RAM8.WORD\[6\].W.BYTE\[2\].B.CGAND SLICE_16\[1\].RAM16.SLICE\[1\].RAM8.WORD\[6\].W.BYTE\[0\].B.SEL0
+ SLICE_16\[1\].RAM16.SLICE\[1\].RAM8.WE0_buf\[2\] VGND VGND VPWR VPWR SLICE_16\[1\].RAM16.SLICE\[1\].RAM8.WORD\[6\].W.BYTE\[2\].B.WE0_WIRE
+ sky130_fd_sc_hd__and2_1
Xfill_8_1 VGND VPWR sky130_fd_sc_hd__tapvpwrvgnd_1
Xtap_32_6 VGND VPWR sky130_fd_sc_hd__tapvpwrvgnd_1
XSLICE_16\[0\].RAM16.SLICE\[0\].RAM8.WORD\[2\].W.BYTE\[0\].B.BIT\[3\].OBUF0 SLICE_16\[0\].RAM16.SLICE\[0\].RAM8.WORD\[2\].W.BYTE\[0\].B.Q_WIRE\[3\]
+ SLICE_16\[0\].RAM16.SLICE\[0\].RAM8.WORD\[2\].W.BYTE\[0\].B.SEL0_B VGND VGND VPWR
+ VPWR SLICE_16\[0\].RAM16.BYTE\[0\].FLOATBUF0\[3\].Z sky130_fd_sc_hd__ebufn_2
XSLICE_16\[1\].RAM16.SLICE\[1\].RAM8.WORD\[4\].W.BYTE\[0\].B.BIT\[0\].OBUF0 SLICE_16\[1\].RAM16.SLICE\[1\].RAM8.WORD\[4\].W.BYTE\[0\].B.Q_WIRE\[0\]
+ SLICE_16\[1\].RAM16.SLICE\[1\].RAM8.WORD\[4\].W.BYTE\[0\].B.SEL0_B VGND VGND VPWR
+ VPWR SLICE_16\[1\].RAM16.BYTE\[0\].FLOATBUF0\[0\].Z sky130_fd_sc_hd__ebufn_2
Xtap_25_5 VGND VPWR sky130_fd_sc_hd__tapvpwrvgnd_1
Xtap_18_4 VGND VPWR sky130_fd_sc_hd__tapvpwrvgnd_1
XSLICE_16\[0\].RAM16.SLICE\[0\].RAM8.WORD\[6\].W.BYTE\[3\].B.BIT\[6\].OBUF0 SLICE_16\[0\].RAM16.SLICE\[0\].RAM8.WORD\[6\].W.BYTE\[3\].B.Q_WIRE\[6\]
+ SLICE_16\[0\].RAM16.SLICE\[0\].RAM8.WORD\[6\].W.BYTE\[3\].B.SEL0_B VGND VGND VPWR
+ VPWR SLICE_16\[0\].RAM16.BYTE\[3\].FLOATBUF0\[30\].Z sky130_fd_sc_hd__ebufn_2
XSLICE_16\[1\].RAM16.SLICE\[1\].RAM8.WORD\[7\].W.BYTE\[3\].B.SEL0INV SLICE_16\[1\].RAM16.SLICE\[1\].RAM8.WORD\[7\].W.BYTE\[0\].B.SEL0
+ VGND VGND VPWR VPWR SLICE_16\[1\].RAM16.SLICE\[1\].RAM8.WORD\[7\].W.BYTE\[3\].B.SEL0_B
+ sky130_fd_sc_hd__inv_1
Xtap_15_30 VGND VPWR sky130_fd_sc_hd__tapvpwrvgnd_1
XDIBUF\[3\].__cell__ Di0[3] VGND VGND VPWR VPWR DIBUF\[3\].X sky130_fd_sc_hd__clkbuf_16
XSLICE_16\[0\].RAM16.Do0_REG.OUTREG_BYTE\[3\].DIODE\[4\] SLICE_16\[0\].RAM16.BYTE\[3\].FLOATBUF0\[28\].Z
+ VGND VGND VPWR VPWR sky130_fd_sc_hd__diode_2
XSLICE_16\[1\].RAM16.BYTE\[3\].FLOATBUF0\[27\].__cell__ SLICE_16\[1\].RAM16.BYTE\[3\].FLOATBUF0\[24\].A
+ SLICE_16\[1\].RAM16.BYTE\[3\].FLOATBUF0\[24\].TE_B VGND VGND VPWR VPWR SLICE_16\[1\].RAM16.BYTE\[3\].FLOATBUF0\[27\].Z
+ sky130_fd_sc_hd__ebufn_2
XSLICE_16\[1\].RAM16.SLICE\[0\].RAM8.WORD\[3\].W.BYTE\[2\].B.BIT\[2\].OBUF0 SLICE_16\[1\].RAM16.SLICE\[0\].RAM8.WORD\[3\].W.BYTE\[2\].B.Q_WIRE\[2\]
+ SLICE_16\[1\].RAM16.SLICE\[0\].RAM8.WORD\[3\].W.BYTE\[2\].B.SEL0_B VGND VGND VPWR
+ VPWR SLICE_16\[1\].RAM16.BYTE\[2\].FLOATBUF0\[18\].Z sky130_fd_sc_hd__ebufn_2
Xfill_46_8 VGND VPWR sky130_fd_sc_hd__tapvpwrvgnd_1
Xfill_39_7 VGND VGND VPWR VPWR sky130_fd_sc_hd__decap_12
XSLICE_16\[1\].RAM16.SLICE\[0\].RAM8.WORD\[3\].W.BYTE\[2\].B.SEL0INV SLICE_16\[1\].RAM16.SLICE\[0\].RAM8.WORD\[3\].W.BYTE\[0\].B.SEL0
+ VGND VGND VPWR VPWR SLICE_16\[1\].RAM16.SLICE\[0\].RAM8.WORD\[3\].W.BYTE\[2\].B.SEL0_B
+ sky130_fd_sc_hd__inv_1
Xfill_44_91 VGND VGND VPWR VPWR sky130_fd_sc_hd__decap_12
Xfill_44_80 VGND VGND VPWR VPWR sky130_fd_sc_hd__decap_12
XSLICE_16\[0\].RAM16.SLICE\[0\].RAM8.WORD\[0\].W.BYTE\[3\].B.genblk1.CLKINV SLICE_16\[0\].RAM16.SLICE\[0\].RAM8.WORD\[0\].W.BYTE\[0\].B.CLK
+ VGND VGND VPWR VPWR SLICE_16\[0\].RAM16.SLICE\[0\].RAM8.WORD\[0\].W.BYTE\[3\].B.CLK_B
+ sky130_fd_sc_hd__inv_1
XSLICE_16\[0\].RAM16.SLICE\[0\].RAM8.WORD\[5\].W.BYTE\[1\].B.BIT\[3\].OBUF0 SLICE_16\[0\].RAM16.SLICE\[0\].RAM8.WORD\[5\].W.BYTE\[1\].B.Q_WIRE\[3\]
+ SLICE_16\[0\].RAM16.SLICE\[0\].RAM8.WORD\[5\].W.BYTE\[1\].B.SEL0_B VGND VGND VPWR
+ VPWR SLICE_16\[0\].RAM16.BYTE\[1\].FLOATBUF0\[11\].Z sky130_fd_sc_hd__ebufn_2
XSLICE_16\[1\].RAM16.SLICE\[1\].RAM8.WORD\[7\].W.BYTE\[1\].B.BIT\[0\].OBUF0 SLICE_16\[1\].RAM16.SLICE\[1\].RAM8.WORD\[7\].W.BYTE\[1\].B.Q_WIRE\[0\]
+ SLICE_16\[1\].RAM16.SLICE\[1\].RAM8.WORD\[7\].W.BYTE\[1\].B.SEL0_B VGND VGND VPWR
+ VPWR SLICE_16\[1\].RAM16.BYTE\[1\].FLOATBUF0\[8\].Z sky130_fd_sc_hd__ebufn_2
XSLICE_16\[1\].RAM16.SLICE\[1\].RAM8.WORD\[6\].W.BYTE\[1\].B.BIT\[6\].genblk1.STORAGE
+ DIBUF\[14\].X SLICE_16\[1\].RAM16.SLICE\[1\].RAM8.WORD\[6\].W.BYTE\[1\].B.GCLK VGND
+ VGND VPWR VPWR SLICE_16\[1\].RAM16.SLICE\[1\].RAM8.WORD\[6\].W.BYTE\[1\].B.Q_WIRE\[6\]
+ sky130_fd_sc_hd__dlxtp_1
Xtap_36_29 VGND VPWR sky130_fd_sc_hd__tapvpwrvgnd_1
Xtap_36_18 VGND VPWR sky130_fd_sc_hd__tapvpwrvgnd_1
XSLICE_16\[1\].RAM16.SLICE\[1\].RAM8.WORD\[0\].W.BYTE\[2\].B.BIT\[7\].genblk1.STORAGE
+ DIBUF\[23\].X SLICE_16\[1\].RAM16.SLICE\[1\].RAM8.WORD\[0\].W.BYTE\[2\].B.GCLK VGND
+ VGND VPWR VPWR SLICE_16\[1\].RAM16.SLICE\[1\].RAM8.WORD\[0\].W.BYTE\[2\].B.Q_WIRE\[7\]
+ sky130_fd_sc_hd__dlxtp_1
XSLICE_16\[1\].RAM16.SLICE\[0\].RAM8.WORD\[7\].W.BYTE\[3\].B.BIT\[2\].genblk1.STORAGE
+ DIBUF\[26\].X SLICE_16\[1\].RAM16.SLICE\[0\].RAM8.WORD\[7\].W.BYTE\[3\].B.GCLK VGND
+ VGND VPWR VPWR SLICE_16\[1\].RAM16.SLICE\[0\].RAM8.WORD\[7\].W.BYTE\[3\].B.Q_WIRE\[2\]
+ sky130_fd_sc_hd__dlxtp_1
Xfill_40_27 VGND VPWR sky130_fd_sc_hd__tapvpwrvgnd_1
Xfill_40_16 VGND VGND VPWR VPWR sky130_fd_sc_hd__decap_12
XSLICE_16\[1\].RAM16.SLICE\[0\].RAM8.WORD\[5\].W.BYTE\[1\].B.BIT\[1\].genblk1.STORAGE
+ DIBUF\[9\].X SLICE_16\[1\].RAM16.SLICE\[0\].RAM8.WORD\[5\].W.BYTE\[1\].B.GCLK VGND
+ VGND VPWR VPWR SLICE_16\[1\].RAM16.SLICE\[0\].RAM8.WORD\[5\].W.BYTE\[1\].B.Q_WIRE\[1\]
+ sky130_fd_sc_hd__dlxtp_1
Xtap_7_11 VGND VPWR sky130_fd_sc_hd__tapvpwrvgnd_1
Xtap_7_22 VGND VPWR sky130_fd_sc_hd__tapvpwrvgnd_1
Xtap_7_33 VGND VPWR sky130_fd_sc_hd__tapvpwrvgnd_1
Xtap_30_3 VGND VPWR sky130_fd_sc_hd__tapvpwrvgnd_1
XSLICE_16\[1\].RAM16.SLICE\[0\].RAM8.WORD\[6\].W.BYTE\[3\].B.BIT\[2\].OBUF0 SLICE_16\[1\].RAM16.SLICE\[0\].RAM8.WORD\[6\].W.BYTE\[3\].B.Q_WIRE\[2\]
+ SLICE_16\[1\].RAM16.SLICE\[0\].RAM8.WORD\[6\].W.BYTE\[3\].B.SEL0_B VGND VGND VPWR
+ VPWR SLICE_16\[1\].RAM16.BYTE\[3\].FLOATBUF0\[26\].Z sky130_fd_sc_hd__ebufn_2
Xtap_23_2 VGND VPWR sky130_fd_sc_hd__tapvpwrvgnd_1
XSLICE_16\[0\].RAM16.SLICE\[1\].RAM8.WORD\[7\].W.BYTE\[1\].B.BIT\[2\].genblk1.STORAGE
+ DIBUF\[10\].X SLICE_16\[0\].RAM16.SLICE\[1\].RAM8.WORD\[7\].W.BYTE\[1\].B.GCLK VGND
+ VGND VPWR VPWR SLICE_16\[0\].RAM16.SLICE\[1\].RAM8.WORD\[7\].W.BYTE\[1\].B.Q_WIRE\[2\]
+ sky130_fd_sc_hd__dlxtp_1
XSLICE_16\[0\].RAM16.SLICE\[0\].RAM8.WORD\[1\].W.BYTE\[3\].B.SEL0INV SLICE_16\[0\].RAM16.SLICE\[0\].RAM8.WORD\[1\].W.BYTE\[0\].B.SEL0
+ VGND VGND VPWR VPWR SLICE_16\[0\].RAM16.SLICE\[0\].RAM8.WORD\[1\].W.BYTE\[3\].B.SEL0_B
+ sky130_fd_sc_hd__inv_1
XSLICE_16\[0\].RAM16.SLICE\[1\].RAM8.WORD\[1\].W.BYTE\[2\].B.BIT\[3\].genblk1.STORAGE
+ DIBUF\[19\].X SLICE_16\[0\].RAM16.SLICE\[1\].RAM8.WORD\[1\].W.BYTE\[2\].B.GCLK VGND
+ VGND VPWR VPWR SLICE_16\[0\].RAM16.SLICE\[1\].RAM8.WORD\[1\].W.BYTE\[2\].B.Q_WIRE\[3\]
+ sky130_fd_sc_hd__dlxtp_1
XSLICE_16\[0\].RAM16.BYTE\[1\].FLOATBUF0\[8\].__cell__ SLICE_16\[0\].RAM16.BYTE\[1\].FLOATBUF0\[10\].A
+ SLICE_16\[0\].RAM16.BYTE\[1\].FLOATBUF0\[10\].TE_B VGND VGND VPWR VPWR SLICE_16\[0\].RAM16.BYTE\[1\].FLOATBUF0\[8\].Z
+ sky130_fd_sc_hd__ebufn_2
Xtap_16_1 VGND VPWR sky130_fd_sc_hd__tapvpwrvgnd_1
Xtap_9_0 VGND VPWR sky130_fd_sc_hd__tapvpwrvgnd_1
XSLICE_16\[1\].RAM16.SLICE\[0\].RAM8.WORD\[3\].W.BYTE\[0\].B.BIT\[7\].OBUF0 SLICE_16\[1\].RAM16.SLICE\[0\].RAM8.WORD\[3\].W.BYTE\[0\].B.Q_WIRE\[7\]
+ SLICE_16\[1\].RAM16.SLICE\[0\].RAM8.WORD\[3\].W.BYTE\[0\].B.SEL0_B VGND VGND VPWR
+ VPWR SLICE_16\[1\].RAM16.BYTE\[0\].FLOATBUF0\[7\].Z sky130_fd_sc_hd__ebufn_2
XSLICE_16\[0\].RAM16.Do0_REG.OUTREG_BYTE\[2\].Do_FF\[5\] SLICE_16\[0\].RAM16.Do0_REG.CLKBUF\[2\]
+ SLICE_16\[0\].RAM16.BYTE\[2\].FLOATBUF0\[21\].Z VGND VGND VPWR VPWR Do0MUX.A0\[21\]
+ sky130_fd_sc_hd__dfxtp_1
XSLICE_16\[0\].RAM16.SLICE\[1\].RAM8.WORD\[0\].W.BYTE\[2\].B.BIT\[6\].OBUF0 SLICE_16\[0\].RAM16.SLICE\[1\].RAM8.WORD\[0\].W.BYTE\[2\].B.Q_WIRE\[6\]
+ SLICE_16\[0\].RAM16.SLICE\[1\].RAM8.WORD\[0\].W.BYTE\[2\].B.SEL0_B VGND VGND VPWR
+ VPWR SLICE_16\[0\].RAM16.BYTE\[2\].FLOATBUF0\[22\].Z sky130_fd_sc_hd__ebufn_2
XSLICE_16\[1\].RAM16.SLICE\[0\].RAM8.WORD\[1\].W.BYTE\[2\].B.CGAND SLICE_16\[1\].RAM16.SLICE\[0\].RAM8.WORD\[1\].W.BYTE\[0\].B.SEL0
+ SLICE_16\[1\].RAM16.SLICE\[0\].RAM8.WE0_buf\[2\] VGND VGND VPWR VPWR SLICE_16\[1\].RAM16.SLICE\[0\].RAM8.WORD\[1\].W.BYTE\[2\].B.WE0_WIRE
+ sky130_fd_sc_hd__and2_1
Xfill_44_5 VGND VGND VPWR VPWR sky130_fd_sc_hd__decap_12
Xfill_37_4 VGND VPWR sky130_fd_sc_hd__tapvpwrvgnd_1
Xfill_19_39 VGND VPWR sky130_fd_sc_hd__tapvpwrvgnd_1
Xfill_19_28 VGND VGND VPWR VPWR sky130_fd_sc_hd__decap_12
Xfill_19_17 VGND VGND VPWR VPWR sky130_fd_sc_hd__decap_12
Xtap_2_7 VGND VPWR sky130_fd_sc_hd__tapvpwrvgnd_1
XSLICE_16\[0\].RAM16.SLICE\[0\].RAM8.WORD\[7\].W.BYTE\[0\].B.BIT\[0\].OBUF0 SLICE_16\[0\].RAM16.SLICE\[0\].RAM8.WORD\[7\].W.BYTE\[0\].B.Q_WIRE\[0\]
+ SLICE_16\[0\].RAM16.SLICE\[0\].RAM8.WORD\[7\].W.BYTE\[0\].B.SEL0_B VGND VGND VPWR
+ VPWR SLICE_16\[0\].RAM16.BYTE\[0\].FLOATBUF0\[0\].Z sky130_fd_sc_hd__ebufn_2
XSLICE_16\[0\].RAM16.SLICE\[1\].RAM8.WORD\[0\].W.BYTE\[0\].B.genblk1.CG SLICE_16\[0\].RAM16.SLICE\[1\].RAM8.WORD\[0\].W.BYTE\[0\].B.CLK_B
+ SLICE_16\[0\].RAM16.SLICE\[1\].RAM8.WORD\[0\].W.BYTE\[0\].B.WE0_WIRE VGND VGND VPWR
+ VPWR SLICE_16\[0\].RAM16.SLICE\[1\].RAM8.WORD\[0\].W.BYTE\[0\].B.GCLK sky130_fd_sc_hd__dlclkp_1
XDo0MUX.M\[2\].DIODE_A0MUX\[21\] Do0MUX.A0\[21\] VGND VGND VPWR VPWR sky130_fd_sc_hd__diode_2
XSLICE_16\[1\].RAM16.SLICE\[0\].RAM8.WORD\[6\].W.BYTE\[1\].B.BIT\[7\].OBUF0 SLICE_16\[1\].RAM16.SLICE\[0\].RAM8.WORD\[6\].W.BYTE\[1\].B.Q_WIRE\[7\]
+ SLICE_16\[1\].RAM16.SLICE\[0\].RAM8.WORD\[6\].W.BYTE\[1\].B.SEL0_B VGND VGND VPWR
+ VPWR SLICE_16\[1\].RAM16.BYTE\[1\].FLOATBUF0\[15\].Z sky130_fd_sc_hd__ebufn_2
XSLICE_16\[0\].RAM16.SLICE\[1\].RAM8.WORD\[6\].W.CLKBUF SLICE_16\[0\].RAM16.SLICE\[1\].RAM8.CLKBUF.X
+ VGND VGND VPWR VPWR SLICE_16\[0\].RAM16.SLICE\[1\].RAM8.WORD\[6\].W.BYTE\[0\].B.CLK
+ sky130_fd_sc_hd__clkbuf_4
XSLICE_16\[0\].RAM16.SLICE\[1\].RAM8.WORD\[3\].W.BYTE\[3\].B.BIT\[6\].OBUF0 SLICE_16\[0\].RAM16.SLICE\[1\].RAM8.WORD\[3\].W.BYTE\[3\].B.Q_WIRE\[6\]
+ SLICE_16\[0\].RAM16.SLICE\[1\].RAM8.WORD\[3\].W.BYTE\[3\].B.SEL0_B VGND VGND VPWR
+ VPWR SLICE_16\[0\].RAM16.BYTE\[3\].FLOATBUF0\[30\].Z sky130_fd_sc_hd__ebufn_2
Xtap_12_31 VGND VPWR sky130_fd_sc_hd__tapvpwrvgnd_1
Xtap_12_20 VGND VPWR sky130_fd_sc_hd__tapvpwrvgnd_1
XSLICE_16\[1\].RAM16.SLICE\[1\].RAM8.WORD\[3\].W.BYTE\[3\].B.BIT\[7\].genblk1.STORAGE
+ DIBUF\[31\].X SLICE_16\[1\].RAM16.SLICE\[1\].RAM8.WORD\[3\].W.BYTE\[3\].B.GCLK VGND
+ VGND VPWR VPWR SLICE_16\[1\].RAM16.SLICE\[1\].RAM8.WORD\[3\].W.BYTE\[3\].B.Q_WIRE\[7\]
+ sky130_fd_sc_hd__dlxtp_1
Xfill_20_101 VGND VGND VPWR VPWR sky130_fd_sc_hd__decap_12
XSLICE_16\[1\].RAM16.SLICE\[1\].RAM8.WORD\[7\].W.BYTE\[0\].B.BIT\[5\].genblk1.STORAGE
+ DIBUF\[5\].X SLICE_16\[1\].RAM16.SLICE\[1\].RAM8.WORD\[7\].W.BYTE\[0\].B.GCLK VGND
+ VGND VPWR VPWR SLICE_16\[1\].RAM16.SLICE\[1\].RAM8.WORD\[7\].W.BYTE\[0\].B.Q_WIRE\[5\]
+ sky130_fd_sc_hd__dlxtp_1
XSLICE_16\[1\].RAM16.SLICE\[1\].RAM8.WORD\[2\].W.BYTE\[3\].B.genblk1.CG SLICE_16\[1\].RAM16.SLICE\[1\].RAM8.WORD\[2\].W.BYTE\[3\].B.CLK_B
+ SLICE_16\[1\].RAM16.SLICE\[1\].RAM8.WORD\[2\].W.BYTE\[3\].B.WE0_WIRE VGND VGND VPWR
+ VPWR SLICE_16\[1\].RAM16.SLICE\[1\].RAM8.WORD\[2\].W.BYTE\[3\].B.GCLK sky130_fd_sc_hd__dlclkp_1
XSLICE_16\[1\].RAM16.SLICE\[1\].RAM8.WORD\[1\].W.BYTE\[1\].B.BIT\[6\].genblk1.STORAGE
+ DIBUF\[14\].X SLICE_16\[1\].RAM16.SLICE\[1\].RAM8.WORD\[1\].W.BYTE\[1\].B.GCLK VGND
+ VGND VPWR VPWR SLICE_16\[1\].RAM16.SLICE\[1\].RAM8.WORD\[1\].W.BYTE\[1\].B.Q_WIRE\[6\]
+ sky130_fd_sc_hd__dlxtp_1
XSLICE_16\[1\].RAM16.SLICE\[0\].RAM8.WORD\[6\].W.BYTE\[0\].B.BIT\[0\].genblk1.STORAGE
+ DIBUF\[0\].X SLICE_16\[1\].RAM16.SLICE\[0\].RAM8.WORD\[6\].W.BYTE\[0\].B.GCLK VGND
+ VGND VPWR VPWR SLICE_16\[1\].RAM16.SLICE\[0\].RAM8.WORD\[6\].W.BYTE\[0\].B.Q_WIRE\[0\]
+ sky130_fd_sc_hd__dlxtp_1
XSLICE_16\[1\].RAM16.SLICE\[0\].RAM8.WORD\[2\].W.BYTE\[3\].B.BIT\[2\].genblk1.STORAGE
+ DIBUF\[26\].X SLICE_16\[1\].RAM16.SLICE\[0\].RAM8.WORD\[2\].W.BYTE\[3\].B.GCLK VGND
+ VGND VPWR VPWR SLICE_16\[1\].RAM16.SLICE\[0\].RAM8.WORD\[2\].W.BYTE\[3\].B.Q_WIRE\[2\]
+ sky130_fd_sc_hd__dlxtp_1
XSLICE_16\[1\].RAM16.SLICE\[0\].RAM8.WORD\[0\].W.BYTE\[1\].B.BIT\[1\].genblk1.STORAGE
+ DIBUF\[9\].X SLICE_16\[1\].RAM16.SLICE\[0\].RAM8.WORD\[0\].W.BYTE\[1\].B.GCLK VGND
+ VGND VPWR VPWR SLICE_16\[1\].RAM16.SLICE\[0\].RAM8.WORD\[0\].W.BYTE\[1\].B.Q_WIRE\[1\]
+ sky130_fd_sc_hd__dlxtp_1
Xfill_16_9 VGND VGND VPWR VPWR sky130_fd_sc_hd__fill_2
XSLICE_16\[0\].RAM16.SLICE\[1\].RAM8.WORD\[4\].W.BYTE\[3\].B.BIT\[3\].genblk1.STORAGE
+ DIBUF\[27\].X SLICE_16\[0\].RAM16.SLICE\[1\].RAM8.WORD\[4\].W.BYTE\[3\].B.GCLK VGND
+ VGND VPWR VPWR SLICE_16\[0\].RAM16.SLICE\[1\].RAM8.WORD\[4\].W.BYTE\[3\].B.Q_WIRE\[3\]
+ sky130_fd_sc_hd__dlxtp_1
XSLICE_16\[1\].RAM16.SLICE\[1\].RAM8.WORD\[0\].W.BYTE\[2\].B.BIT\[2\].OBUF0 SLICE_16\[1\].RAM16.SLICE\[1\].RAM8.WORD\[0\].W.BYTE\[2\].B.Q_WIRE\[2\]
+ SLICE_16\[1\].RAM16.SLICE\[1\].RAM8.WORD\[0\].W.BYTE\[2\].B.SEL0_B VGND VGND VPWR
+ VPWR SLICE_16\[1\].RAM16.BYTE\[2\].FLOATBUF0\[18\].Z sky130_fd_sc_hd__ebufn_2
XSLICE_16\[1\].RAM16.SLICE\[0\].RAM8.WORD\[2\].W.BYTE\[3\].B.DIODE_CLK SLICE_16\[1\].RAM16.SLICE\[0\].RAM8.WORD\[2\].W.BYTE\[0\].B.CLK
+ VGND VGND VPWR VPWR sky130_fd_sc_hd__diode_2
XSLICE_16\[0\].RAM16.SLICE\[1\].RAM8.WORD\[2\].W.BYTE\[1\].B.BIT\[2\].genblk1.STORAGE
+ DIBUF\[10\].X SLICE_16\[0\].RAM16.SLICE\[1\].RAM8.WORD\[2\].W.BYTE\[1\].B.GCLK VGND
+ VGND VPWR VPWR SLICE_16\[0\].RAM16.SLICE\[1\].RAM8.WORD\[2\].W.BYTE\[1\].B.Q_WIRE\[2\]
+ sky130_fd_sc_hd__dlxtp_1
XDo0MUX.M\[3\].DIODE_A0MUX\[25\] Do0MUX.A0\[25\] VGND VGND VPWR VPWR sky130_fd_sc_hd__diode_2
Xfill_41_92 VGND VGND VPWR VPWR sky130_fd_sc_hd__decap_12
Xfill_41_81 VGND VPWR sky130_fd_sc_hd__tapvpwrvgnd_1
Xfill_41_70 VGND VGND VPWR VPWR sky130_fd_sc_hd__decap_12
XSLICE_16\[1\].RAM16.Do0_REG.OUTREG_BYTE\[2\].DIODE\[0\] SLICE_16\[1\].RAM16.BYTE\[2\].FLOATBUF0\[16\].Z
+ VGND VGND VPWR VPWR sky130_fd_sc_hd__diode_2
XSLICE_16\[1\].RAM16.SLICE\[0\].RAM8.WORD\[7\].W.BYTE\[0\].B.SEL0INV SLICE_16\[1\].RAM16.SLICE\[0\].RAM8.WORD\[7\].W.BYTE\[0\].B.SEL0
+ VGND VGND VPWR VPWR SLICE_16\[1\].RAM16.SLICE\[0\].RAM8.WORD\[7\].W.BYTE\[0\].B.SEL0_B
+ sky130_fd_sc_hd__inv_1
Xfill_42_2 VGND VGND VPWR VPWR sky130_fd_sc_hd__decap_12
Xfill_35_1 VGND VGND VPWR VPWR sky130_fd_sc_hd__decap_4
XSLICE_16\[1\].RAM16.SLICE\[1\].RAM8.WORD\[2\].W.BYTE\[1\].B.CGAND SLICE_16\[1\].RAM16.SLICE\[1\].RAM8.WORD\[2\].W.BYTE\[0\].B.SEL0
+ SLICE_16\[1\].RAM16.SLICE\[1\].RAM8.WE0_buf\[1\] VGND VGND VPWR VPWR SLICE_16\[1\].RAM16.SLICE\[1\].RAM8.WORD\[2\].W.BYTE\[1\].B.WE0_WIRE
+ sky130_fd_sc_hd__and2_1
XSLICE_16\[0\].RAM16.SLICE\[1\].RAM8.WORD\[2\].W.BYTE\[1\].B.BIT\[3\].OBUF0 SLICE_16\[0\].RAM16.SLICE\[1\].RAM8.WORD\[2\].W.BYTE\[1\].B.Q_WIRE\[3\]
+ SLICE_16\[0\].RAM16.SLICE\[1\].RAM8.WORD\[2\].W.BYTE\[1\].B.SEL0_B VGND VGND VPWR
+ VPWR SLICE_16\[0\].RAM16.BYTE\[1\].FLOATBUF0\[11\].Z sky130_fd_sc_hd__ebufn_2
Xtap_33_19 VGND VPWR sky130_fd_sc_hd__tapvpwrvgnd_1
Xfill_28_0 VGND VPWR sky130_fd_sc_hd__tapvpwrvgnd_1
XSLICE_16\[0\].RAM16.SLICE\[0\].RAM8.WORD\[5\].W.BYTE\[2\].B.DIODE_CLK SLICE_16\[0\].RAM16.SLICE\[0\].RAM8.WORD\[5\].W.BYTE\[0\].B.CLK
+ VGND VGND VPWR VPWR sky130_fd_sc_hd__diode_2
XSLICE_16\[1\].RAM16.SLICE\[1\].RAM8.WORD\[1\].W.BYTE\[0\].B.DIODE_CLK SLICE_16\[1\].RAM16.SLICE\[1\].RAM8.WORD\[1\].W.BYTE\[0\].B.CLK
+ VGND VGND VPWR VPWR sky130_fd_sc_hd__diode_2
Xfill_21_29 VGND VGND VPWR VPWR sky130_fd_sc_hd__decap_12
Xfill_21_18 VGND VPWR sky130_fd_sc_hd__tapvpwrvgnd_1
Xtap_4_12 VGND VPWR sky130_fd_sc_hd__tapvpwrvgnd_1
Xtap_4_23 VGND VPWR sky130_fd_sc_hd__tapvpwrvgnd_1
XSLICE_16\[0\].RAM16.SLICE\[0\].RAM8.WORD\[5\].W.BYTE\[0\].B.BIT\[7\].genblk1.STORAGE
+ DIBUF\[7\].X SLICE_16\[0\].RAM16.SLICE\[0\].RAM8.WORD\[5\].W.BYTE\[0\].B.GCLK VGND
+ VGND VPWR VPWR SLICE_16\[0\].RAM16.SLICE\[0\].RAM8.WORD\[5\].W.BYTE\[0\].B.Q_WIRE\[7\]
+ sky130_fd_sc_hd__dlxtp_1
XSLICE_16\[0\].RAM16.SLICE\[0\].RAM8.WORD\[1\].W.BYTE\[3\].B.BIT\[5\].OBUF0 SLICE_16\[0\].RAM16.SLICE\[0\].RAM8.WORD\[1\].W.BYTE\[3\].B.Q_WIRE\[5\]
+ SLICE_16\[0\].RAM16.SLICE\[0\].RAM8.WORD\[1\].W.BYTE\[3\].B.SEL0_B VGND VGND VPWR
+ VPWR SLICE_16\[0\].RAM16.BYTE\[3\].FLOATBUF0\[29\].Z sky130_fd_sc_hd__ebufn_2
Xtap_4_34 VGND VPWR sky130_fd_sc_hd__tapvpwrvgnd_1
Xfill_46_59 VGND VPWR sky130_fd_sc_hd__tapvpwrvgnd_1
Xfill_46_48 VGND VGND VPWR VPWR sky130_fd_sc_hd__decap_4
Xfill_46_37 VGND VGND VPWR VPWR sky130_fd_sc_hd__decap_4
Xfill_46_26 VGND VPWR sky130_fd_sc_hd__tapvpwrvgnd_1
Xfill_46_15 VGND VPWR sky130_fd_sc_hd__tapvpwrvgnd_1
XSLICE_16\[1\].RAM16.SLICE\[1\].RAM8.WORD\[3\].W.BYTE\[3\].B.BIT\[2\].OBUF0 SLICE_16\[1\].RAM16.SLICE\[1\].RAM8.WORD\[3\].W.BYTE\[3\].B.Q_WIRE\[2\]
+ SLICE_16\[1\].RAM16.SLICE\[1\].RAM8.WORD\[3\].W.BYTE\[3\].B.SEL0_B VGND VGND VPWR
+ VPWR SLICE_16\[1\].RAM16.BYTE\[3\].FLOATBUF0\[26\].Z sky130_fd_sc_hd__ebufn_2
Xtap_0_4 VGND VPWR sky130_fd_sc_hd__tapvpwrvgnd_1
XDo0MUX.M\[1\].DIODE_A1MUX\[15\] Do0MUX.A1\[15\] VGND VGND VPWR VPWR sky130_fd_sc_hd__diode_2
XSLICE_16\[1\].RAM16.SLICE\[0\].RAM8.DEC0.ABUF\[1\] SLICE_16\[1\].RAM16.A0BUF\[1\].X
+ VGND VGND VPWR VPWR SLICE_16\[1\].RAM16.SLICE\[0\].RAM8.DEC0.A_buf\[1\] sky130_fd_sc_hd__clkbuf_2
Xtap_23_30 VGND VPWR sky130_fd_sc_hd__tapvpwrvgnd_1
XSLICE_16\[0\].RAM16.SLICE\[0\].RAM8.WORD\[5\].W.BYTE\[1\].B.SEL0INV SLICE_16\[0\].RAM16.SLICE\[0\].RAM8.WORD\[5\].W.BYTE\[0\].B.SEL0
+ VGND VGND VPWR VPWR SLICE_16\[0\].RAM16.SLICE\[0\].RAM8.WORD\[5\].W.BYTE\[1\].B.SEL0_B
+ sky130_fd_sc_hd__inv_1
XSLICE_16\[1\].RAM16.SLICE\[1\].RAM8.WORD\[0\].W.BYTE\[0\].B.BIT\[7\].OBUF0 SLICE_16\[1\].RAM16.SLICE\[1\].RAM8.WORD\[0\].W.BYTE\[0\].B.Q_WIRE\[7\]
+ SLICE_16\[1\].RAM16.SLICE\[1\].RAM8.WORD\[0\].W.BYTE\[0\].B.SEL0_B VGND VGND VPWR
+ VPWR SLICE_16\[1\].RAM16.BYTE\[0\].FLOATBUF0\[7\].Z sky130_fd_sc_hd__ebufn_2
XSLICE_16\[0\].RAM16.SLICE\[1\].RAM8.WORD\[4\].W.BYTE\[3\].B.CGAND SLICE_16\[0\].RAM16.SLICE\[1\].RAM8.WORD\[4\].W.BYTE\[0\].B.SEL0
+ SLICE_16\[0\].RAM16.SLICE\[1\].RAM8.WE0_buf\[3\] VGND VGND VPWR VPWR SLICE_16\[0\].RAM16.SLICE\[1\].RAM8.WORD\[4\].W.BYTE\[3\].B.WE0_WIRE
+ sky130_fd_sc_hd__and2_1
XSLICE_16\[0\].RAM16.SLICE\[1\].RAM8.WORD\[5\].W.BYTE\[2\].B.BIT\[3\].OBUF0 SLICE_16\[0\].RAM16.SLICE\[1\].RAM8.WORD\[5\].W.BYTE\[2\].B.Q_WIRE\[3\]
+ SLICE_16\[0\].RAM16.SLICE\[1\].RAM8.WORD\[5\].W.BYTE\[2\].B.SEL0_B VGND VGND VPWR
+ VPWR SLICE_16\[0\].RAM16.BYTE\[2\].FLOATBUF0\[19\].Z sky130_fd_sc_hd__ebufn_2
Xfill_21_7 VGND VGND VPWR VPWR sky130_fd_sc_hd__decap_12
Xfill_14_6 VGND VGND VPWR VPWR sky130_fd_sc_hd__fill_2
XSLICE_16\[1\].RAM16.Do0_REG.OUTREG_BYTE\[1\].Do_FF\[1\] SLICE_16\[1\].RAM16.Do0_REG.CLKBUF\[1\]
+ SLICE_16\[1\].RAM16.BYTE\[1\].FLOATBUF0\[9\].Z VGND VGND VPWR VPWR Do0MUX.A1\[9\]
+ sky130_fd_sc_hd__dfxtp_1
XSLICE_16\[1\].RAM16.SLICE\[1\].RAM8.WORD\[4\].W.BYTE\[2\].B.BIT\[6\].genblk1.STORAGE
+ DIBUF\[22\].X SLICE_16\[1\].RAM16.SLICE\[1\].RAM8.WORD\[4\].W.BYTE\[2\].B.GCLK VGND
+ VGND VPWR VPWR SLICE_16\[1\].RAM16.SLICE\[1\].RAM8.WORD\[4\].W.BYTE\[2\].B.Q_WIRE\[6\]
+ sky130_fd_sc_hd__dlxtp_1
XSLICE_16\[0\].RAM16.SLICE\[0\].RAM8.WORD\[0\].W.BYTE\[1\].B.BIT\[2\].OBUF0 SLICE_16\[0\].RAM16.SLICE\[0\].RAM8.WORD\[0\].W.BYTE\[1\].B.Q_WIRE\[2\]
+ SLICE_16\[0\].RAM16.SLICE\[0\].RAM8.WORD\[0\].W.BYTE\[1\].B.SEL0_B VGND VGND VPWR
+ VPWR SLICE_16\[0\].RAM16.BYTE\[1\].FLOATBUF0\[10\].Z sky130_fd_sc_hd__ebufn_2
XDo0MUX.M\[2\].DIODE_A1MUX\[19\] Do0MUX.A1\[19\] VGND VGND VPWR VPWR sky130_fd_sc_hd__diode_2
XSLICE_16\[1\].RAM16.SLICE\[1\].RAM8.WORD\[2\].W.BYTE\[0\].B.BIT\[5\].genblk1.STORAGE
+ DIBUF\[5\].X SLICE_16\[1\].RAM16.SLICE\[1\].RAM8.WORD\[2\].W.BYTE\[0\].B.GCLK VGND
+ VGND VPWR VPWR SLICE_16\[1\].RAM16.SLICE\[1\].RAM8.WORD\[2\].W.BYTE\[0\].B.Q_WIRE\[5\]
+ sky130_fd_sc_hd__dlxtp_1
Xtap_28_19 VGND VPWR sky130_fd_sc_hd__tapvpwrvgnd_1
XSLICE_16\[1\].RAM16.SLICE\[0\].RAM8.WORD\[3\].W.BYTE\[2\].B.BIT\[1\].genblk1.STORAGE
+ DIBUF\[17\].X SLICE_16\[1\].RAM16.SLICE\[0\].RAM8.WORD\[3\].W.BYTE\[2\].B.GCLK VGND
+ VGND VPWR VPWR SLICE_16\[1\].RAM16.SLICE\[0\].RAM8.WORD\[3\].W.BYTE\[2\].B.Q_WIRE\[1\]
+ sky130_fd_sc_hd__dlxtp_1
XSLICE_16\[1\].RAM16.SLICE\[0\].RAM8.WORD\[1\].W.BYTE\[0\].B.BIT\[0\].genblk1.STORAGE
+ DIBUF\[0\].X SLICE_16\[1\].RAM16.SLICE\[0\].RAM8.WORD\[1\].W.BYTE\[0\].B.GCLK VGND
+ VGND VPWR VPWR SLICE_16\[1\].RAM16.SLICE\[0\].RAM8.WORD\[1\].W.BYTE\[0\].B.Q_WIRE\[0\]
+ sky130_fd_sc_hd__dlxtp_1
XSLICE_16\[0\].RAM16.SLICE\[1\].RAM8.WORD\[5\].W.BYTE\[2\].B.BIT\[2\].genblk1.STORAGE
+ DIBUF\[18\].X SLICE_16\[0\].RAM16.SLICE\[1\].RAM8.WORD\[5\].W.BYTE\[2\].B.GCLK VGND
+ VGND VPWR VPWR SLICE_16\[0\].RAM16.SLICE\[1\].RAM8.WORD\[5\].W.BYTE\[2\].B.Q_WIRE\[2\]
+ sky130_fd_sc_hd__dlxtp_1
XSLICE_16\[0\].RAM16.SLICE\[1\].RAM8.WORD\[3\].W.BYTE\[0\].B.BIT\[1\].genblk1.STORAGE
+ DIBUF\[1\].X SLICE_16\[0\].RAM16.SLICE\[1\].RAM8.WORD\[3\].W.BYTE\[0\].B.GCLK VGND
+ VGND VPWR VPWR SLICE_16\[0\].RAM16.SLICE\[1\].RAM8.WORD\[3\].W.BYTE\[0\].B.Q_WIRE\[1\]
+ sky130_fd_sc_hd__dlxtp_1
XSLICE_16\[0\].RAM16.SLICE\[1\].RAM8.WORD\[4\].W.BYTE\[0\].B.BIT\[0\].OBUF0 SLICE_16\[0\].RAM16.SLICE\[1\].RAM8.WORD\[4\].W.BYTE\[0\].B.Q_WIRE\[0\]
+ SLICE_16\[0\].RAM16.SLICE\[1\].RAM8.WORD\[4\].W.BYTE\[0\].B.SEL0_B VGND VGND VPWR
+ VPWR SLICE_16\[0\].RAM16.BYTE\[0\].FLOATBUF0\[0\].Z sky130_fd_sc_hd__ebufn_2
XSLICE_16\[1\].RAM16.SLICE\[1\].RAM8.WORD\[3\].W.BYTE\[1\].B.BIT\[7\].OBUF0 SLICE_16\[1\].RAM16.SLICE\[1\].RAM8.WORD\[3\].W.BYTE\[1\].B.Q_WIRE\[7\]
+ SLICE_16\[1\].RAM16.SLICE\[1\].RAM8.WORD\[3\].W.BYTE\[1\].B.SEL0_B VGND VGND VPWR
+ VPWR SLICE_16\[1\].RAM16.BYTE\[1\].FLOATBUF0\[15\].Z sky130_fd_sc_hd__ebufn_2
XSLICE_16\[1\].RAM16.SLICE\[0\].RAM8.WORD\[1\].W.BYTE\[3\].B.BIT\[1\].OBUF0 SLICE_16\[1\].RAM16.SLICE\[0\].RAM8.WORD\[1\].W.BYTE\[3\].B.Q_WIRE\[1\]
+ SLICE_16\[1\].RAM16.SLICE\[0\].RAM8.WORD\[1\].W.BYTE\[3\].B.SEL0_B VGND VGND VPWR
+ VPWR SLICE_16\[1\].RAM16.BYTE\[3\].FLOATBUF0\[25\].Z sky130_fd_sc_hd__ebufn_2
Xtap_18_30 VGND VPWR sky130_fd_sc_hd__tapvpwrvgnd_1
XSLICE_16\[1\].RAM16.SLICE\[1\].RAM8.WORD\[4\].W.BYTE\[3\].B.DIODE_CLK SLICE_16\[1\].RAM16.SLICE\[1\].RAM8.WORD\[4\].W.BYTE\[0\].B.CLK
+ VGND VGND VPWR VPWR sky130_fd_sc_hd__diode_2
XSLICE_16\[1\].RAM16.SLICE\[1\].RAM8.DEC0.AND5 SLICE_16\[1\].RAM16.SLICE\[1\].RAM8.DEC0.A_buf\[1\]
+ SLICE_16\[1\].RAM16.SLICE\[1\].RAM8.DEC0.A_buf\[0\] SLICE_16\[1\].RAM16.SLICE\[1\].RAM8.DEC0.A_buf\[2\]
+ SLICE_16\[1\].RAM16.SLICE\[1\].RAM8.DEC0.EN_buf VGND VGND VPWR VPWR SLICE_16\[1\].RAM16.SLICE\[1\].RAM8.DEC0.SEL\[5\]
+ sky130_fd_sc_hd__and4b_2
Xfill_22_61 VGND VGND VPWR VPWR sky130_fd_sc_hd__decap_12
Xfill_22_50 VGND VGND VPWR VPWR sky130_fd_sc_hd__decap_12
XSLICE_16\[0\].RAM16.SLICE\[0\].RAM8.WORD\[0\].W.BYTE\[0\].B.BIT\[7\].genblk1.STORAGE
+ DIBUF\[7\].X SLICE_16\[0\].RAM16.SLICE\[0\].RAM8.WORD\[0\].W.BYTE\[0\].B.GCLK VGND
+ VGND VPWR VPWR SLICE_16\[0\].RAM16.SLICE\[0\].RAM8.WORD\[0\].W.BYTE\[0\].B.Q_WIRE\[7\]
+ sky130_fd_sc_hd__dlxtp_1
XSLICE_16\[0\].RAM16.SLICE\[0\].RAM8.WORD\[3\].W.BYTE\[2\].B.BIT\[2\].OBUF0 SLICE_16\[0\].RAM16.SLICE\[0\].RAM8.WORD\[3\].W.BYTE\[2\].B.Q_WIRE\[2\]
+ SLICE_16\[0\].RAM16.SLICE\[0\].RAM8.WORD\[3\].W.BYTE\[2\].B.SEL0_B VGND VGND VPWR
+ VPWR SLICE_16\[0\].RAM16.BYTE\[2\].FLOATBUF0\[18\].Z sky130_fd_sc_hd__ebufn_2
Xfill_22_94 VGND VGND VPWR VPWR sky130_fd_sc_hd__decap_12
Xfill_22_83 VGND VGND VPWR VPWR sky130_fd_sc_hd__decap_12
Xfill_22_72 VGND VPWR sky130_fd_sc_hd__tapvpwrvgnd_1
XSLICE_16\[0\].RAM16.SLICE\[1\].RAM8.WORD\[7\].W.BYTE\[2\].B.DIODE_CLK SLICE_16\[0\].RAM16.SLICE\[1\].RAM8.WORD\[7\].W.BYTE\[0\].B.CLK
+ VGND VGND VPWR VPWR sky130_fd_sc_hd__diode_2
XSLICE_16\[0\].RAM16.SLICE\[1\].RAM8.WORD\[7\].W.BYTE\[1\].B.BIT\[0\].OBUF0 SLICE_16\[0\].RAM16.SLICE\[1\].RAM8.WORD\[7\].W.BYTE\[1\].B.Q_WIRE\[0\]
+ SLICE_16\[0\].RAM16.SLICE\[1\].RAM8.WORD\[7\].W.BYTE\[1\].B.SEL0_B VGND VGND VPWR
+ VPWR SLICE_16\[0\].RAM16.BYTE\[1\].FLOATBUF0\[8\].Z sky130_fd_sc_hd__ebufn_2
Xfill_12_3 VGND VPWR sky130_fd_sc_hd__tapvpwrvgnd_1
XSLICE_16\[1\].RAM16.SLICE\[1\].RAM8.WORD\[6\].W.BYTE\[2\].B.BIT\[7\].OBUF0 SLICE_16\[1\].RAM16.SLICE\[1\].RAM8.WORD\[6\].W.BYTE\[2\].B.Q_WIRE\[7\]
+ SLICE_16\[1\].RAM16.SLICE\[1\].RAM8.WORD\[6\].W.BYTE\[2\].B.SEL0_B VGND VGND VPWR
+ VPWR SLICE_16\[1\].RAM16.BYTE\[2\].FLOATBUF0\[23\].Z sky130_fd_sc_hd__ebufn_2
XSLICE_16\[1\].RAM16.SLICE\[1\].RAM8.WORD\[7\].W.BYTE\[2\].B.SEL0INV SLICE_16\[1\].RAM16.SLICE\[1\].RAM8.WORD\[7\].W.BYTE\[0\].B.SEL0
+ VGND VGND VPWR VPWR SLICE_16\[1\].RAM16.SLICE\[1\].RAM8.WORD\[7\].W.BYTE\[2\].B.SEL0_B
+ sky130_fd_sc_hd__inv_1
Xtap_27_9 VGND VPWR sky130_fd_sc_hd__tapvpwrvgnd_1
XSLICE_16\[0\].RAM16.SLICE\[1\].RAM8.WEBUF\[3\].__cell__ SLICE_16\[0\].RAM16.SLICE\[0\].RAM8.WE0\[3\]
+ VGND VGND VPWR VPWR SLICE_16\[0\].RAM16.SLICE\[1\].RAM8.WE0_buf\[3\] sky130_fd_sc_hd__clkbuf_2
Xtap_1_35 VGND VPWR sky130_fd_sc_hd__tapvpwrvgnd_1
Xtap_1_24 VGND VPWR sky130_fd_sc_hd__tapvpwrvgnd_1
Xtap_1_13 VGND VPWR sky130_fd_sc_hd__tapvpwrvgnd_1
XSLICE_16\[1\].RAM16.SLICE\[1\].RAM8.WORD\[7\].W.BYTE\[3\].B.BIT\[6\].genblk1.STORAGE
+ DIBUF\[30\].X SLICE_16\[1\].RAM16.SLICE\[1\].RAM8.WORD\[7\].W.BYTE\[3\].B.GCLK VGND
+ VGND VPWR VPWR SLICE_16\[1\].RAM16.SLICE\[1\].RAM8.WORD\[7\].W.BYTE\[3\].B.Q_WIRE\[6\]
+ sky130_fd_sc_hd__dlxtp_1
XSLICE_16\[1\].RAM16.SLICE\[1\].RAM8.WORD\[5\].W.BYTE\[1\].B.BIT\[5\].genblk1.STORAGE
+ DIBUF\[13\].X SLICE_16\[1\].RAM16.SLICE\[1\].RAM8.WORD\[5\].W.BYTE\[1\].B.GCLK VGND
+ VGND VPWR VPWR SLICE_16\[1\].RAM16.SLICE\[1\].RAM8.WORD\[5\].W.BYTE\[1\].B.Q_WIRE\[5\]
+ sky130_fd_sc_hd__dlxtp_1
XSLICE_16\[0\].RAM16.Do0_REG.OUTREG_BYTE\[0\].DIODE\[1\] SLICE_16\[0\].RAM16.BYTE\[0\].FLOATBUF0\[1\].Z
+ VGND VGND VPWR VPWR sky130_fd_sc_hd__diode_2
Xfill_43_49 VGND VGND VPWR VPWR sky130_fd_sc_hd__decap_12
Xfill_43_38 VGND VGND VPWR VPWR sky130_fd_sc_hd__decap_12
Xfill_43_27 VGND VPWR sky130_fd_sc_hd__tapvpwrvgnd_1
Xfill_43_16 VGND VGND VPWR VPWR sky130_fd_sc_hd__decap_12
XSLICE_16\[1\].RAM16.SLICE\[0\].RAM8.WORD\[6\].W.BYTE\[3\].B.BIT\[1\].genblk1.STORAGE
+ DIBUF\[25\].X SLICE_16\[1\].RAM16.SLICE\[0\].RAM8.WORD\[6\].W.BYTE\[3\].B.GCLK VGND
+ VGND VPWR VPWR SLICE_16\[1\].RAM16.SLICE\[0\].RAM8.WORD\[6\].W.BYTE\[3\].B.Q_WIRE\[1\]
+ sky130_fd_sc_hd__dlxtp_1
XSLICE_16\[1\].RAM16.SLICE\[0\].RAM8.WORD\[1\].W.BYTE\[1\].B.BIT\[6\].OBUF0 SLICE_16\[1\].RAM16.SLICE\[0\].RAM8.WORD\[1\].W.BYTE\[1\].B.Q_WIRE\[6\]
+ SLICE_16\[1\].RAM16.SLICE\[0\].RAM8.WORD\[1\].W.BYTE\[1\].B.SEL0_B VGND VGND VPWR
+ VPWR SLICE_16\[1\].RAM16.BYTE\[1\].FLOATBUF0\[14\].Z sky130_fd_sc_hd__ebufn_2
XSLICE_16\[0\].RAM16.WEBUF\[2\].__cell__ SLICE_16\[0\].RAM16.WE0\[2\] VGND VGND VPWR
+ VPWR SLICE_16\[0\].RAM16.SLICE\[0\].RAM8.WE0\[2\] sky130_fd_sc_hd__clkbuf_2
XSLICE_16\[0\].RAM16.SLICE\[0\].RAM8.WORD\[6\].W.BYTE\[3\].B.BIT\[2\].OBUF0 SLICE_16\[0\].RAM16.SLICE\[0\].RAM8.WORD\[6\].W.BYTE\[3\].B.Q_WIRE\[2\]
+ SLICE_16\[0\].RAM16.SLICE\[0\].RAM8.WORD\[6\].W.BYTE\[3\].B.SEL0_B VGND VGND VPWR
+ VPWR SLICE_16\[0\].RAM16.BYTE\[3\].FLOATBUF0\[26\].Z sky130_fd_sc_hd__ebufn_2
Xtap_39_0 VGND VPWR sky130_fd_sc_hd__tapvpwrvgnd_1
XSLICE_16\[1\].RAM16.SLICE\[0\].RAM8.WORD\[4\].W.BYTE\[1\].B.BIT\[0\].genblk1.STORAGE
+ DIBUF\[8\].X SLICE_16\[1\].RAM16.SLICE\[0\].RAM8.WORD\[4\].W.BYTE\[1\].B.GCLK VGND
+ VGND VPWR VPWR SLICE_16\[1\].RAM16.SLICE\[0\].RAM8.WORD\[4\].W.BYTE\[1\].B.Q_WIRE\[0\]
+ sky130_fd_sc_hd__dlxtp_1
XSLICE_16\[1\].RAM16.SLICE\[0\].RAM8.WORD\[3\].W.BYTE\[1\].B.SEL0INV SLICE_16\[1\].RAM16.SLICE\[0\].RAM8.WORD\[3\].W.BYTE\[0\].B.SEL0
+ VGND VGND VPWR VPWR SLICE_16\[1\].RAM16.SLICE\[0\].RAM8.WORD\[3\].W.BYTE\[1\].B.SEL0_B
+ sky130_fd_sc_hd__inv_1
XSLICE_16\[0\].RAM16.SLICE\[1\].RAM8.WORD\[6\].W.BYTE\[1\].B.BIT\[1\].genblk1.STORAGE
+ DIBUF\[9\].X SLICE_16\[0\].RAM16.SLICE\[1\].RAM8.WORD\[6\].W.BYTE\[1\].B.GCLK VGND
+ VGND VPWR VPWR SLICE_16\[0\].RAM16.SLICE\[1\].RAM8.WORD\[6\].W.BYTE\[1\].B.Q_WIRE\[1\]
+ sky130_fd_sc_hd__dlxtp_1
XSLICE_16\[0\].RAM16.SLICE\[0\].RAM8.WORD\[3\].W.BYTE\[0\].B.BIT\[7\].OBUF0 SLICE_16\[0\].RAM16.SLICE\[0\].RAM8.WORD\[3\].W.BYTE\[0\].B.Q_WIRE\[7\]
+ SLICE_16\[0\].RAM16.SLICE\[0\].RAM8.WORD\[3\].W.BYTE\[0\].B.SEL0_B VGND VGND VPWR
+ VPWR SLICE_16\[0\].RAM16.BYTE\[0\].FLOATBUF0\[7\].Z sky130_fd_sc_hd__ebufn_2
XSLICE_16\[0\].RAM16.SLICE\[1\].RAM8.WORD\[0\].W.BYTE\[2\].B.BIT\[2\].genblk1.STORAGE
+ DIBUF\[18\].X SLICE_16\[0\].RAM16.SLICE\[1\].RAM8.WORD\[0\].W.BYTE\[2\].B.GCLK VGND
+ VGND VPWR VPWR SLICE_16\[0\].RAM16.SLICE\[1\].RAM8.WORD\[0\].W.BYTE\[2\].B.Q_WIRE\[2\]
+ sky130_fd_sc_hd__dlxtp_1
XSLICE_16\[1\].RAM16.SLICE\[1\].RAM8.WORD\[5\].W.BYTE\[0\].B.BIT\[4\].OBUF0 SLICE_16\[1\].RAM16.SLICE\[1\].RAM8.WORD\[5\].W.BYTE\[0\].B.Q_WIRE\[4\]
+ SLICE_16\[1\].RAM16.SLICE\[1\].RAM8.WORD\[5\].W.BYTE\[0\].B.SEL0_B VGND VGND VPWR
+ VPWR SLICE_16\[1\].RAM16.BYTE\[0\].FLOATBUF0\[4\].Z sky130_fd_sc_hd__ebufn_2
XSLICE_16\[1\].RAM16.A0BUF\[0\].__cell__ A0BUF\[0\].X VGND VGND VPWR VPWR SLICE_16\[1\].RAM16.A0BUF\[0\].X
+ sky130_fd_sc_hd__clkbuf_2
XSLICE_16\[1\].RAM16.FBUFENBUF0\[1\].__cell__ DEC0.SEL\[1\] VGND VGND VPWR VPWR SLICE_16\[1\].RAM16.BYTE\[1\].FLOATBUF0\[10\].TE_B
+ sky130_fd_sc_hd__clkbuf_2
Xfill_17_61 VGND VGND VPWR VPWR sky130_fd_sc_hd__decap_12
Xfill_17_50 VGND VGND VPWR VPWR sky130_fd_sc_hd__decap_12
XSLICE_16\[0\].RAM16.SLICE\[1\].RAM8.WORD\[1\].W.BYTE\[3\].B.genblk1.CG SLICE_16\[0\].RAM16.SLICE\[1\].RAM8.WORD\[1\].W.BYTE\[3\].B.CLK_B
+ SLICE_16\[0\].RAM16.SLICE\[1\].RAM8.WORD\[1\].W.BYTE\[3\].B.WE0_WIRE VGND VGND VPWR
+ VPWR SLICE_16\[0\].RAM16.SLICE\[1\].RAM8.WORD\[1\].W.BYTE\[3\].B.GCLK sky130_fd_sc_hd__dlclkp_1
XSLICE_16\[0\].RAM16.SLICE\[1\].RAM8.WORD\[5\].W.BYTE\[3\].B.SEL0INV SLICE_16\[0\].RAM16.SLICE\[1\].RAM8.WORD\[5\].W.BYTE\[0\].B.SEL0
+ VGND VGND VPWR VPWR SLICE_16\[0\].RAM16.SLICE\[1\].RAM8.WORD\[5\].W.BYTE\[3\].B.SEL0_B
+ sky130_fd_sc_hd__inv_1
XSLICE_16\[1\].RAM16.SLICE\[0\].RAM8.WORD\[4\].W.BYTE\[2\].B.BIT\[6\].OBUF0 SLICE_16\[1\].RAM16.SLICE\[0\].RAM8.WORD\[4\].W.BYTE\[2\].B.Q_WIRE\[6\]
+ SLICE_16\[1\].RAM16.SLICE\[0\].RAM8.WORD\[4\].W.BYTE\[2\].B.SEL0_B VGND VGND VPWR
+ VPWR SLICE_16\[1\].RAM16.BYTE\[2\].FLOATBUF0\[22\].Z sky130_fd_sc_hd__ebufn_2
XSLICE_16\[0\].RAM16.SLICE\[0\].RAM8.WORD\[3\].W.BYTE\[1\].B.BIT\[7\].genblk1.STORAGE
+ DIBUF\[15\].X SLICE_16\[0\].RAM16.SLICE\[0\].RAM8.WORD\[3\].W.BYTE\[1\].B.GCLK VGND
+ VGND VPWR VPWR SLICE_16\[0\].RAM16.SLICE\[0\].RAM8.WORD\[3\].W.BYTE\[1\].B.Q_WIRE\[7\]
+ sky130_fd_sc_hd__dlxtp_1
Xfill_8_2 VGND VGND VPWR VPWR sky130_fd_sc_hd__decap_3
Xfill_10_0 VGND VPWR sky130_fd_sc_hd__tapvpwrvgnd_1
Xtap_32_7 VGND VPWR sky130_fd_sc_hd__tapvpwrvgnd_1
Xtap_25_6 VGND VPWR sky130_fd_sc_hd__tapvpwrvgnd_1
XSLICE_16\[0\].RAM16.SLICE\[0\].RAM8.WORD\[1\].W.BYTE\[2\].B.SEL0INV SLICE_16\[0\].RAM16.SLICE\[0\].RAM8.WORD\[1\].W.BYTE\[0\].B.SEL0
+ VGND VGND VPWR VPWR SLICE_16\[0\].RAM16.SLICE\[0\].RAM8.WORD\[1\].W.BYTE\[2\].B.SEL0_B
+ sky130_fd_sc_hd__inv_1
Xtap_18_5 VGND VPWR sky130_fd_sc_hd__tapvpwrvgnd_1
XSLICE_16\[0\].RAM16.SLICE\[0\].RAM8.WORD\[6\].W.BYTE\[1\].B.BIT\[7\].OBUF0 SLICE_16\[0\].RAM16.SLICE\[0\].RAM8.WORD\[6\].W.BYTE\[1\].B.Q_WIRE\[7\]
+ SLICE_16\[0\].RAM16.SLICE\[0\].RAM8.WORD\[6\].W.BYTE\[1\].B.SEL0_B VGND VGND VPWR
+ VPWR SLICE_16\[0\].RAM16.BYTE\[1\].FLOATBUF0\[15\].Z sky130_fd_sc_hd__ebufn_2
XSLICE_16\[0\].RAM16.BYTE\[0\].FLOATBUF0\[0\].__cell__ SLICE_16\[0\].RAM16.BYTE\[0\].FLOATBUF0\[0\].A
+ SLICE_16\[0\].RAM16.BYTE\[0\].FLOATBUF0\[0\].TE_B VGND VGND VPWR VPWR SLICE_16\[0\].RAM16.BYTE\[0\].FLOATBUF0\[0\].Z
+ sky130_fd_sc_hd__ebufn_2
Xtap_15_31 VGND VPWR sky130_fd_sc_hd__tapvpwrvgnd_1
Xtap_15_20 VGND VPWR sky130_fd_sc_hd__tapvpwrvgnd_1
XSLICE_16\[0\].RAM16.SLICE\[1\].RAM8.WORD\[0\].W.BYTE\[2\].B.CGAND SLICE_16\[0\].RAM16.SLICE\[1\].RAM8.WORD\[0\].W.BYTE\[0\].B.SEL0
+ SLICE_16\[0\].RAM16.SLICE\[1\].RAM8.WE0_buf\[2\] VGND VGND VPWR VPWR SLICE_16\[0\].RAM16.SLICE\[1\].RAM8.WORD\[0\].W.BYTE\[2\].B.WE0_WIRE
+ sky130_fd_sc_hd__and2_1
XDo0MUX.M\[0\].DIODE_A0MUX\[3\] Do0MUX.A0\[3\] VGND VGND VPWR VPWR sky130_fd_sc_hd__diode_2
Xtap_31_30 VGND VPWR sky130_fd_sc_hd__tapvpwrvgnd_1
XSLICE_16\[1\].RAM16.SLICE\[1\].RAM8.WORD\[2\].W.BYTE\[3\].B.BIT\[6\].genblk1.STORAGE
+ DIBUF\[30\].X SLICE_16\[1\].RAM16.SLICE\[1\].RAM8.WORD\[2\].W.BYTE\[3\].B.GCLK VGND
+ VGND VPWR VPWR SLICE_16\[1\].RAM16.SLICE\[1\].RAM8.WORD\[2\].W.BYTE\[3\].B.Q_WIRE\[6\]
+ sky130_fd_sc_hd__dlxtp_1
XSLICE_16\[1\].RAM16.SLICE\[0\].RAM8.WORD\[3\].W.BYTE\[0\].B.BIT\[3\].OBUF0 SLICE_16\[1\].RAM16.SLICE\[0\].RAM8.WORD\[3\].W.BYTE\[0\].B.Q_WIRE\[3\]
+ SLICE_16\[1\].RAM16.SLICE\[0\].RAM8.WORD\[3\].W.BYTE\[0\].B.SEL0_B VGND VGND VPWR
+ VPWR SLICE_16\[1\].RAM16.BYTE\[0\].FLOATBUF0\[3\].Z sky130_fd_sc_hd__ebufn_2
XSLICE_16\[0\].RAM16.SLICE\[1\].RAM8.WORD\[0\].W.BYTE\[2\].B.BIT\[2\].OBUF0 SLICE_16\[0\].RAM16.SLICE\[1\].RAM8.WORD\[0\].W.BYTE\[2\].B.Q_WIRE\[2\]
+ SLICE_16\[0\].RAM16.SLICE\[1\].RAM8.WORD\[0\].W.BYTE\[2\].B.SEL0_B VGND VGND VPWR
+ VPWR SLICE_16\[0\].RAM16.BYTE\[2\].FLOATBUF0\[18\].Z sky130_fd_sc_hd__ebufn_2
Xfill_46_9 VGND VGND VPWR VPWR sky130_fd_sc_hd__decap_4
Xfill_39_8 VGND VGND VPWR VPWR sky130_fd_sc_hd__decap_12
XSLICE_16\[1\].RAM16.BYTE\[2\].FLOATBUF0\[19\].__cell__ SLICE_16\[1\].RAM16.BYTE\[2\].FLOATBUF0\[16\].A
+ SLICE_16\[1\].RAM16.BYTE\[2\].FLOATBUF0\[16\].TE_B VGND VGND VPWR VPWR SLICE_16\[1\].RAM16.BYTE\[2\].FLOATBUF0\[19\].Z
+ sky130_fd_sc_hd__ebufn_2
XSLICE_16\[1\].RAM16.SLICE\[1\].RAM8.WORD\[6\].W.BYTE\[0\].B.BIT\[4\].genblk1.STORAGE
+ DIBUF\[4\].X SLICE_16\[1\].RAM16.SLICE\[1\].RAM8.WORD\[6\].W.BYTE\[0\].B.GCLK VGND
+ VGND VPWR VPWR SLICE_16\[1\].RAM16.SLICE\[1\].RAM8.WORD\[6\].W.BYTE\[0\].B.Q_WIRE\[4\]
+ sky130_fd_sc_hd__dlxtp_1
XSLICE_16\[1\].RAM16.SLICE\[1\].RAM8.WORD\[0\].W.BYTE\[1\].B.BIT\[5\].genblk1.STORAGE
+ DIBUF\[13\].X SLICE_16\[1\].RAM16.SLICE\[1\].RAM8.WORD\[0\].W.BYTE\[1\].B.GCLK VGND
+ VGND VPWR VPWR SLICE_16\[1\].RAM16.SLICE\[1\].RAM8.WORD\[0\].W.BYTE\[1\].B.Q_WIRE\[5\]
+ sky130_fd_sc_hd__dlxtp_1
XSLICE_16\[1\].RAM16.SLICE\[0\].RAM8.WORD\[7\].W.BYTE\[3\].B.BIT\[6\].OBUF0 SLICE_16\[1\].RAM16.SLICE\[0\].RAM8.WORD\[7\].W.BYTE\[3\].B.Q_WIRE\[6\]
+ SLICE_16\[1\].RAM16.SLICE\[0\].RAM8.WORD\[7\].W.BYTE\[3\].B.SEL0_B VGND VGND VPWR
+ VPWR SLICE_16\[1\].RAM16.BYTE\[3\].FLOATBUF0\[30\].Z sky130_fd_sc_hd__ebufn_2
Xfill_44_92 VGND VGND VPWR VPWR sky130_fd_sc_hd__decap_12
Xfill_44_81 VGND VPWR sky130_fd_sc_hd__tapvpwrvgnd_1
Xfill_44_70 VGND VGND VPWR VPWR sky130_fd_sc_hd__decap_12
XSLICE_16\[1\].RAM16.SLICE\[0\].RAM8.WORD\[7\].W.BYTE\[2\].B.BIT\[0\].genblk1.STORAGE
+ DIBUF\[16\].X SLICE_16\[1\].RAM16.SLICE\[0\].RAM8.WORD\[7\].W.BYTE\[2\].B.GCLK VGND
+ VGND VPWR VPWR SLICE_16\[1\].RAM16.SLICE\[0\].RAM8.WORD\[7\].W.BYTE\[2\].B.Q_WIRE\[0\]
+ sky130_fd_sc_hd__dlxtp_1
XSLICE_16\[1\].RAM16.SLICE\[0\].RAM8.WORD\[5\].W.BYTE\[1\].B.genblk1.CG SLICE_16\[1\].RAM16.SLICE\[0\].RAM8.WORD\[5\].W.BYTE\[1\].B.CLK_B
+ SLICE_16\[1\].RAM16.SLICE\[0\].RAM8.WORD\[5\].W.BYTE\[1\].B.WE0_WIRE VGND VGND VPWR
+ VPWR SLICE_16\[1\].RAM16.SLICE\[0\].RAM8.WORD\[5\].W.BYTE\[1\].B.GCLK sky130_fd_sc_hd__dlclkp_1
XSLICE_16\[1\].RAM16.SLICE\[0\].RAM8.WORD\[1\].W.BYTE\[3\].B.BIT\[1\].genblk1.STORAGE
+ DIBUF\[25\].X SLICE_16\[1\].RAM16.SLICE\[0\].RAM8.WORD\[1\].W.BYTE\[3\].B.GCLK VGND
+ VGND VPWR VPWR SLICE_16\[1\].RAM16.SLICE\[0\].RAM8.WORD\[1\].W.BYTE\[3\].B.Q_WIRE\[1\]
+ sky130_fd_sc_hd__dlxtp_1
XSLICE_16\[0\].RAM16.SLICE\[1\].RAM8.WORD\[7\].W.BYTE\[0\].B.BIT\[0\].genblk1.STORAGE
+ DIBUF\[0\].X SLICE_16\[0\].RAM16.SLICE\[1\].RAM8.WORD\[7\].W.BYTE\[0\].B.GCLK VGND
+ VGND VPWR VPWR SLICE_16\[0\].RAM16.SLICE\[1\].RAM8.WORD\[7\].W.BYTE\[0\].B.Q_WIRE\[0\]
+ sky130_fd_sc_hd__dlxtp_1
XSLICE_16\[0\].RAM16.SLICE\[1\].RAM8.WORD\[3\].W.BYTE\[3\].B.BIT\[2\].genblk1.STORAGE
+ DIBUF\[26\].X SLICE_16\[0\].RAM16.SLICE\[1\].RAM8.WORD\[3\].W.BYTE\[3\].B.GCLK VGND
+ VGND VPWR VPWR SLICE_16\[0\].RAM16.SLICE\[1\].RAM8.WORD\[3\].W.BYTE\[3\].B.Q_WIRE\[2\]
+ sky130_fd_sc_hd__dlxtp_1
Xtap_36_19 VGND VPWR sky130_fd_sc_hd__tapvpwrvgnd_1
XSLICE_16\[0\].RAM16.SLICE\[1\].RAM8.WORD\[1\].W.BYTE\[1\].B.BIT\[1\].genblk1.STORAGE
+ DIBUF\[9\].X SLICE_16\[0\].RAM16.SLICE\[1\].RAM8.WORD\[1\].W.BYTE\[1\].B.GCLK VGND
+ VGND VPWR VPWR SLICE_16\[0\].RAM16.SLICE\[1\].RAM8.WORD\[1\].W.BYTE\[1\].B.Q_WIRE\[1\]
+ sky130_fd_sc_hd__dlxtp_1
Xfill_40_28 VGND VPWR sky130_fd_sc_hd__tapvpwrvgnd_1
Xfill_40_17 VGND VGND VPWR VPWR sky130_fd_sc_hd__decap_12
Xtap_7_12 VGND VPWR sky130_fd_sc_hd__tapvpwrvgnd_1
Xtap_7_23 VGND VPWR sky130_fd_sc_hd__tapvpwrvgnd_1
Xtap_7_34 VGND VPWR sky130_fd_sc_hd__tapvpwrvgnd_1
Xtap_30_4 VGND VPWR sky130_fd_sc_hd__tapvpwrvgnd_1
XSLICE_16\[1\].RAM16.SLICE\[0\].RAM8.WORD\[6\].W.BYTE\[1\].B.BIT\[3\].OBUF0 SLICE_16\[1\].RAM16.SLICE\[0\].RAM8.WORD\[6\].W.BYTE\[1\].B.Q_WIRE\[3\]
+ SLICE_16\[1\].RAM16.SLICE\[0\].RAM8.WORD\[6\].W.BYTE\[1\].B.SEL0_B VGND VGND VPWR
+ VPWR SLICE_16\[1\].RAM16.BYTE\[1\].FLOATBUF0\[11\].Z sky130_fd_sc_hd__ebufn_2
Xtap_23_3 VGND VPWR sky130_fd_sc_hd__tapvpwrvgnd_1
Xtap_16_2 VGND VPWR sky130_fd_sc_hd__tapvpwrvgnd_1
XSLICE_16\[0\].RAM16.SLICE\[1\].RAM8.WORD\[3\].W.BYTE\[3\].B.BIT\[2\].OBUF0 SLICE_16\[0\].RAM16.SLICE\[1\].RAM8.WORD\[3\].W.BYTE\[3\].B.Q_WIRE\[2\]
+ SLICE_16\[0\].RAM16.SLICE\[1\].RAM8.WORD\[3\].W.BYTE\[3\].B.SEL0_B VGND VGND VPWR
+ VPWR SLICE_16\[0\].RAM16.BYTE\[3\].FLOATBUF0\[26\].Z sky130_fd_sc_hd__ebufn_2
XSLICE_16\[0\].RAM16.SLICE\[0\].RAM8.WORD\[6\].W.BYTE\[2\].B.BIT\[7\].genblk1.STORAGE
+ DIBUF\[23\].X SLICE_16\[0\].RAM16.SLICE\[0\].RAM8.WORD\[6\].W.BYTE\[2\].B.GCLK VGND
+ VGND VPWR VPWR SLICE_16\[0\].RAM16.SLICE\[0\].RAM8.WORD\[6\].W.BYTE\[2\].B.Q_WIRE\[7\]
+ sky130_fd_sc_hd__dlxtp_1
Xtap_26_30 VGND VPWR sky130_fd_sc_hd__tapvpwrvgnd_1
XSLICE_16\[1\].RAM16.SLICE\[0\].RAM8.WORD\[1\].W.BYTE\[3\].B.genblk1.CLKINV SLICE_16\[1\].RAM16.SLICE\[0\].RAM8.WORD\[1\].W.BYTE\[0\].B.CLK
+ VGND VGND VPWR VPWR SLICE_16\[1\].RAM16.SLICE\[0\].RAM8.WORD\[1\].W.BYTE\[3\].B.CLK_B
+ sky130_fd_sc_hd__inv_1
XSLICE_16\[0\].RAM16.SLICE\[0\].RAM8.WORD\[4\].W.BYTE\[0\].B.BIT\[6\].genblk1.STORAGE
+ DIBUF\[6\].X SLICE_16\[0\].RAM16.SLICE\[0\].RAM8.WORD\[4\].W.BYTE\[0\].B.GCLK VGND
+ VGND VPWR VPWR SLICE_16\[0\].RAM16.SLICE\[0\].RAM8.WORD\[4\].W.BYTE\[0\].B.Q_WIRE\[6\]
+ sky130_fd_sc_hd__dlxtp_1
Xtap_9_1 VGND VPWR sky130_fd_sc_hd__tapvpwrvgnd_1
XSLICE_16\[0\].RAM16.SLICE\[1\].RAM8.WORD\[0\].W.BYTE\[0\].B.BIT\[7\].OBUF0 SLICE_16\[0\].RAM16.SLICE\[1\].RAM8.WORD\[0\].W.BYTE\[0\].B.Q_WIRE\[7\]
+ SLICE_16\[0\].RAM16.SLICE\[1\].RAM8.WORD\[0\].W.BYTE\[0\].B.SEL0_B VGND VGND VPWR
+ VPWR SLICE_16\[0\].RAM16.BYTE\[0\].FLOATBUF0\[7\].Z sky130_fd_sc_hd__ebufn_2
XDo0MUX.M\[1\].DIODE_A0MUX\[10\] Do0MUX.A0\[10\] VGND VGND VPWR VPWR sky130_fd_sc_hd__diode_2
Xfill_44_6 VGND VPWR sky130_fd_sc_hd__tapvpwrvgnd_1
Xfill_37_5 VGND VGND VPWR VPWR sky130_fd_sc_hd__fill_2
XSLICE_16\[1\].RAM16.SLICE\[1\].RAM8.WORD\[3\].W.BYTE\[3\].B.SEL0INV SLICE_16\[1\].RAM16.SLICE\[1\].RAM8.WORD\[3\].W.BYTE\[0\].B.SEL0
+ VGND VGND VPWR VPWR SLICE_16\[1\].RAM16.SLICE\[1\].RAM8.WORD\[3\].W.BYTE\[3\].B.SEL0_B
+ sky130_fd_sc_hd__inv_1
XSLICE_16\[1\].RAM16.TIE0\[2\].__cell__ VGND VGND VPWR VPWR SLICE_16\[1\].RAM16.TIE0\[2\].__cell__/HI
+ SLICE_16\[1\].RAM16.BYTE\[2\].FLOATBUF0\[16\].A sky130_fd_sc_hd__conb_1
XSLICE_16\[1\].RAM16.SLICE\[1\].RAM8.WORD\[3\].W.BYTE\[2\].B.BIT\[5\].genblk1.STORAGE
+ DIBUF\[21\].X SLICE_16\[1\].RAM16.SLICE\[1\].RAM8.WORD\[3\].W.BYTE\[2\].B.GCLK VGND
+ VGND VPWR VPWR SLICE_16\[1\].RAM16.SLICE\[1\].RAM8.WORD\[3\].W.BYTE\[2\].B.Q_WIRE\[5\]
+ sky130_fd_sc_hd__dlxtp_1
XSLICE_16\[1\].RAM16.SLICE\[1\].RAM8.WORD\[1\].W.BYTE\[2\].B.BIT\[6\].OBUF0 SLICE_16\[1\].RAM16.SLICE\[1\].RAM8.WORD\[1\].W.BYTE\[2\].B.Q_WIRE\[6\]
+ SLICE_16\[1\].RAM16.SLICE\[1\].RAM8.WORD\[1\].W.BYTE\[2\].B.SEL0_B VGND VGND VPWR
+ VPWR SLICE_16\[1\].RAM16.BYTE\[2\].FLOATBUF0\[22\].Z sky130_fd_sc_hd__ebufn_2
XSLICE_16\[1\].RAM16.BYTE\[1\].FLOATBUF0\[10\].__cell__ SLICE_16\[1\].RAM16.BYTE\[1\].FLOATBUF0\[10\].A
+ SLICE_16\[1\].RAM16.BYTE\[1\].FLOATBUF0\[10\].TE_B VGND VGND VPWR VPWR SLICE_16\[1\].RAM16.BYTE\[1\].FLOATBUF0\[10\].Z
+ sky130_fd_sc_hd__ebufn_2
XSLICE_16\[1\].RAM16.SLICE\[1\].RAM8.WORD\[1\].W.BYTE\[0\].B.BIT\[4\].genblk1.STORAGE
+ DIBUF\[4\].X SLICE_16\[1\].RAM16.SLICE\[1\].RAM8.WORD\[1\].W.BYTE\[0\].B.GCLK VGND
+ VGND VPWR VPWR SLICE_16\[1\].RAM16.SLICE\[1\].RAM8.WORD\[1\].W.BYTE\[0\].B.Q_WIRE\[4\]
+ sky130_fd_sc_hd__dlxtp_1
XSLICE_16\[1\].RAM16.SLICE\[0\].RAM8.WORD\[2\].W.BYTE\[2\].B.BIT\[0\].genblk1.STORAGE
+ DIBUF\[16\].X SLICE_16\[1\].RAM16.SLICE\[0\].RAM8.WORD\[2\].W.BYTE\[2\].B.GCLK VGND
+ VGND VPWR VPWR SLICE_16\[1\].RAM16.SLICE\[0\].RAM8.WORD\[2\].W.BYTE\[2\].B.Q_WIRE\[0\]
+ sky130_fd_sc_hd__dlxtp_1
Xfill_19_29 VGND VGND VPWR VPWR sky130_fd_sc_hd__decap_12
Xfill_19_18 VGND VPWR sky130_fd_sc_hd__tapvpwrvgnd_1
Xtap_2_8 VGND VPWR sky130_fd_sc_hd__tapvpwrvgnd_1
XSLICE_16\[0\].RAM16.SLICE\[1\].RAM8.WORD\[4\].W.BYTE\[2\].B.BIT\[1\].genblk1.STORAGE
+ DIBUF\[17\].X SLICE_16\[0\].RAM16.SLICE\[1\].RAM8.WORD\[4\].W.BYTE\[2\].B.GCLK VGND
+ VGND VPWR VPWR SLICE_16\[0\].RAM16.SLICE\[1\].RAM8.WORD\[4\].W.BYTE\[2\].B.Q_WIRE\[1\]
+ sky130_fd_sc_hd__dlxtp_1
Xtap_12_32 VGND VPWR sky130_fd_sc_hd__tapvpwrvgnd_1
Xtap_12_21 VGND VPWR sky130_fd_sc_hd__tapvpwrvgnd_1
XSLICE_16\[0\].RAM16.SLICE\[1\].RAM8.WORD\[3\].W.BYTE\[1\].B.BIT\[7\].OBUF0 SLICE_16\[0\].RAM16.SLICE\[1\].RAM8.WORD\[3\].W.BYTE\[1\].B.Q_WIRE\[7\]
+ SLICE_16\[0\].RAM16.SLICE\[1\].RAM8.WORD\[3\].W.BYTE\[1\].B.SEL0_B VGND VGND VPWR
+ VPWR SLICE_16\[0\].RAM16.BYTE\[1\].FLOATBUF0\[15\].Z sky130_fd_sc_hd__ebufn_2
Xtap_12_10 VGND VPWR sky130_fd_sc_hd__tapvpwrvgnd_1
XSLICE_16\[0\].RAM16.SLICE\[0\].RAM8.WORD\[1\].W.BYTE\[3\].B.BIT\[1\].OBUF0 SLICE_16\[0\].RAM16.SLICE\[0\].RAM8.WORD\[1\].W.BYTE\[3\].B.Q_WIRE\[1\]
+ SLICE_16\[0\].RAM16.SLICE\[0\].RAM8.WORD\[1\].W.BYTE\[3\].B.SEL0_B VGND VGND VPWR
+ VPWR SLICE_16\[0\].RAM16.BYTE\[3\].FLOATBUF0\[25\].Z sky130_fd_sc_hd__ebufn_2
XSLICE_16\[0\].RAM16.SLICE\[0\].RAM8.WORD\[5\].W.BYTE\[0\].B.SEL0INV SLICE_16\[0\].RAM16.SLICE\[0\].RAM8.WORD\[5\].W.BYTE\[0\].B.SEL0
+ VGND VGND VPWR VPWR SLICE_16\[0\].RAM16.SLICE\[0\].RAM8.WORD\[5\].W.BYTE\[0\].B.SEL0_B
+ sky130_fd_sc_hd__inv_1
Xfill_20_102 VGND VPWR sky130_fd_sc_hd__tapvpwrvgnd_1
XSLICE_16\[0\].RAM16.SLICE\[1\].RAM8.WORD\[2\].W.BYTE\[0\].B.BIT\[0\].genblk1.STORAGE
+ DIBUF\[0\].X SLICE_16\[0\].RAM16.SLICE\[1\].RAM8.WORD\[2\].W.BYTE\[0\].B.GCLK VGND
+ VGND VPWR VPWR SLICE_16\[0\].RAM16.SLICE\[1\].RAM8.WORD\[2\].W.BYTE\[0\].B.Q_WIRE\[0\]
+ sky130_fd_sc_hd__dlxtp_1
Xtap_21_0 VGND VPWR sky130_fd_sc_hd__tapvpwrvgnd_1
XSLICE_16\[1\].RAM16.Do0_REG.OUTREG_BYTE\[3\].DIODE\[4\] SLICE_16\[1\].RAM16.BYTE\[3\].FLOATBUF0\[28\].Z
+ VGND VGND VPWR VPWR sky130_fd_sc_hd__diode_2
Xfill_41_60 VGND VPWR sky130_fd_sc_hd__tapvpwrvgnd_1
XSLICE_16\[1\].RAM16.SLICE\[1\].RAM8.WORD\[0\].W.BYTE\[0\].B.BIT\[3\].OBUF0 SLICE_16\[1\].RAM16.SLICE\[1\].RAM8.WORD\[0\].W.BYTE\[0\].B.Q_WIRE\[3\]
+ SLICE_16\[1\].RAM16.SLICE\[1\].RAM8.WORD\[0\].W.BYTE\[0\].B.SEL0_B VGND VGND VPWR
+ VPWR SLICE_16\[1\].RAM16.BYTE\[0\].FLOATBUF0\[3\].Z sky130_fd_sc_hd__ebufn_2
XSLICE_16\[0\].RAM16.SLICE\[0\].RAM8.WORD\[7\].W.BYTE\[1\].B.BIT\[6\].genblk1.STORAGE
+ DIBUF\[14\].X SLICE_16\[0\].RAM16.SLICE\[0\].RAM8.WORD\[7\].W.BYTE\[1\].B.GCLK VGND
+ VGND VPWR VPWR SLICE_16\[0\].RAM16.SLICE\[0\].RAM8.WORD\[7\].W.BYTE\[1\].B.Q_WIRE\[6\]
+ sky130_fd_sc_hd__dlxtp_1
Xfill_41_93 VGND VPWR sky130_fd_sc_hd__tapvpwrvgnd_1
Xfill_41_82 VGND VGND VPWR VPWR sky130_fd_sc_hd__decap_12
Xfill_41_71 VGND VGND VPWR VPWR sky130_fd_sc_hd__decap_12
XSLICE_16\[1\].RAM16.SLICE\[1\].RAM8.WORD\[4\].W.BYTE\[3\].B.BIT\[6\].OBUF0 SLICE_16\[1\].RAM16.SLICE\[1\].RAM8.WORD\[4\].W.BYTE\[3\].B.Q_WIRE\[6\]
+ SLICE_16\[1\].RAM16.SLICE\[1\].RAM8.WORD\[4\].W.BYTE\[3\].B.SEL0_B VGND VGND VPWR
+ VPWR SLICE_16\[1\].RAM16.BYTE\[3\].FLOATBUF0\[30\].Z sky130_fd_sc_hd__ebufn_2
XSLICE_16\[0\].RAM16.SLICE\[0\].RAM8.WORD\[1\].W.BYTE\[2\].B.BIT\[7\].genblk1.STORAGE
+ DIBUF\[23\].X SLICE_16\[0\].RAM16.SLICE\[0\].RAM8.WORD\[1\].W.BYTE\[2\].B.GCLK VGND
+ VGND VPWR VPWR SLICE_16\[0\].RAM16.SLICE\[0\].RAM8.WORD\[1\].W.BYTE\[2\].B.Q_WIRE\[7\]
+ sky130_fd_sc_hd__dlxtp_1
Xfill_42_3 VGND VPWR sky130_fd_sc_hd__tapvpwrvgnd_1
Xfill_35_2 VGND VPWR sky130_fd_sc_hd__tapvpwrvgnd_1
Xfill_28_1 VGND VPWR sky130_fd_sc_hd__tapvpwrvgnd_1
XSLICE_16\[0\].RAM16.SLICE\[1\].RAM8.WORD\[6\].W.BYTE\[2\].B.BIT\[7\].OBUF0 SLICE_16\[0\].RAM16.SLICE\[1\].RAM8.WORD\[6\].W.BYTE\[2\].B.Q_WIRE\[7\]
+ SLICE_16\[0\].RAM16.SLICE\[1\].RAM8.WORD\[6\].W.BYTE\[2\].B.SEL0_B VGND VGND VPWR
+ VPWR SLICE_16\[0\].RAM16.BYTE\[2\].FLOATBUF0\[23\].Z sky130_fd_sc_hd__ebufn_2
Xfill_21_19 VGND VGND VPWR VPWR sky130_fd_sc_hd__decap_12
XSLICE_16\[0\].RAM16.BYTE\[3\].FLOATBUF0\[24\].__cell__ SLICE_16\[0\].RAM16.BYTE\[3\].FLOATBUF0\[24\].A
+ SLICE_16\[0\].RAM16.BYTE\[3\].FLOATBUF0\[24\].TE_B VGND VGND VPWR VPWR SLICE_16\[0\].RAM16.BYTE\[3\].FLOATBUF0\[24\].Z
+ sky130_fd_sc_hd__ebufn_2
Xtap_4_13 VGND VPWR sky130_fd_sc_hd__tapvpwrvgnd_1
Xtap_4_24 VGND VPWR sky130_fd_sc_hd__tapvpwrvgnd_1
Xtap_4_35 VGND VPWR sky130_fd_sc_hd__tapvpwrvgnd_1
XSLICE_16\[0\].RAM16.SLICE\[0\].RAM8.WORD\[1\].W.BYTE\[1\].B.BIT\[6\].OBUF0 SLICE_16\[0\].RAM16.SLICE\[0\].RAM8.WORD\[1\].W.BYTE\[1\].B.Q_WIRE\[6\]
+ SLICE_16\[0\].RAM16.SLICE\[0\].RAM8.WORD\[1\].W.BYTE\[1\].B.SEL0_B VGND VGND VPWR
+ VPWR SLICE_16\[0\].RAM16.BYTE\[1\].FLOATBUF0\[14\].Z sky130_fd_sc_hd__ebufn_2
Xfill_46_49 VGND VPWR sky130_fd_sc_hd__tapvpwrvgnd_1
Xfill_46_38 VGND VPWR sky130_fd_sc_hd__tapvpwrvgnd_1
Xfill_46_27 VGND VGND VPWR VPWR sky130_fd_sc_hd__decap_4
Xfill_46_16 VGND VGND VPWR VPWR sky130_fd_sc_hd__decap_4
XSLICE_16\[1\].RAM16.SLICE\[1\].RAM8.WORD\[3\].W.BYTE\[1\].B.BIT\[3\].OBUF0 SLICE_16\[1\].RAM16.SLICE\[1\].RAM8.WORD\[3\].W.BYTE\[1\].B.Q_WIRE\[3\]
+ SLICE_16\[1\].RAM16.SLICE\[1\].RAM8.WORD\[3\].W.BYTE\[1\].B.SEL0_B VGND VGND VPWR
+ VPWR SLICE_16\[1\].RAM16.BYTE\[1\].FLOATBUF0\[11\].Z sky130_fd_sc_hd__ebufn_2
Xtap_23_31 VGND VPWR sky130_fd_sc_hd__tapvpwrvgnd_1
Xtap_23_20 VGND VPWR sky130_fd_sc_hd__tapvpwrvgnd_1
Xtap_0_5 VGND VPWR sky130_fd_sc_hd__tapvpwrvgnd_1
XSLICE_16\[1\].RAM16.SLICE\[1\].RAM8.WORD\[6\].W.BYTE\[3\].B.BIT\[5\].genblk1.STORAGE
+ DIBUF\[29\].X SLICE_16\[1\].RAM16.SLICE\[1\].RAM8.WORD\[6\].W.BYTE\[3\].B.GCLK VGND
+ VGND VPWR VPWR SLICE_16\[1\].RAM16.SLICE\[1\].RAM8.WORD\[6\].W.BYTE\[3\].B.Q_WIRE\[5\]
+ sky130_fd_sc_hd__dlxtp_1
XSLICE_16\[1\].RAM16.SLICE\[1\].RAM8.WORD\[4\].W.BYTE\[1\].B.BIT\[4\].genblk1.STORAGE
+ DIBUF\[12\].X SLICE_16\[1\].RAM16.SLICE\[1\].RAM8.WORD\[4\].W.BYTE\[1\].B.GCLK VGND
+ VGND VPWR VPWR SLICE_16\[1\].RAM16.SLICE\[1\].RAM8.WORD\[4\].W.BYTE\[1\].B.Q_WIRE\[4\]
+ sky130_fd_sc_hd__dlxtp_1
XSLICE_16\[1\].RAM16.SLICE\[0\].RAM8.WORD\[5\].W.BYTE\[3\].B.BIT\[0\].genblk1.STORAGE
+ DIBUF\[24\].X SLICE_16\[1\].RAM16.SLICE\[0\].RAM8.WORD\[5\].W.BYTE\[3\].B.GCLK VGND
+ VGND VPWR VPWR SLICE_16\[1\].RAM16.SLICE\[0\].RAM8.WORD\[5\].W.BYTE\[3\].B.Q_WIRE\[0\]
+ sky130_fd_sc_hd__dlxtp_1
XSLICE_16\[1\].RAM16.Do0_REG.OUTREG_BYTE\[2\].Do_FF\[5\] SLICE_16\[1\].RAM16.Do0_REG.CLKBUF\[2\]
+ SLICE_16\[1\].RAM16.BYTE\[2\].FLOATBUF0\[21\].Z VGND VGND VPWR VPWR Do0MUX.A1\[21\]
+ sky130_fd_sc_hd__dfxtp_1
XSLICE_16\[0\].RAM16.SLICE\[1\].RAM8.WORD\[7\].W.BYTE\[3\].B.BIT\[1\].genblk1.STORAGE
+ DIBUF\[25\].X SLICE_16\[0\].RAM16.SLICE\[1\].RAM8.WORD\[7\].W.BYTE\[3\].B.GCLK VGND
+ VGND VPWR VPWR SLICE_16\[0\].RAM16.SLICE\[1\].RAM8.WORD\[7\].W.BYTE\[3\].B.Q_WIRE\[1\]
+ sky130_fd_sc_hd__dlxtp_1
XSLICE_16\[0\].RAM16.SLICE\[1\].RAM8.WORD\[5\].W.BYTE\[0\].B.BIT\[4\].OBUF0 SLICE_16\[0\].RAM16.SLICE\[1\].RAM8.WORD\[5\].W.BYTE\[0\].B.Q_WIRE\[4\]
+ SLICE_16\[0\].RAM16.SLICE\[1\].RAM8.WORD\[5\].W.BYTE\[0\].B.SEL0_B VGND VGND VPWR
+ VPWR SLICE_16\[0\].RAM16.BYTE\[0\].FLOATBUF0\[4\].Z sky130_fd_sc_hd__ebufn_2
XSLICE_16\[1\].RAM16.SLICE\[0\].RAM8.WORD\[6\].W.BYTE\[2\].B.CGAND SLICE_16\[1\].RAM16.SLICE\[0\].RAM8.WORD\[6\].W.BYTE\[0\].B.SEL0
+ SLICE_16\[1\].RAM16.SLICE\[0\].RAM8.WE0_buf\[2\] VGND VGND VPWR VPWR SLICE_16\[1\].RAM16.SLICE\[0\].RAM8.WORD\[6\].W.BYTE\[2\].B.WE0_WIRE
+ sky130_fd_sc_hd__and2_1
XSLICE_16\[1\].RAM16.SLICE\[0\].RAM8.WORD\[2\].W.BYTE\[3\].B.BIT\[5\].OBUF0 SLICE_16\[1\].RAM16.SLICE\[0\].RAM8.WORD\[2\].W.BYTE\[3\].B.Q_WIRE\[5\]
+ SLICE_16\[1\].RAM16.SLICE\[0\].RAM8.WORD\[2\].W.BYTE\[3\].B.SEL0_B VGND VGND VPWR
+ VPWR SLICE_16\[1\].RAM16.BYTE\[3\].FLOATBUF0\[29\].Z sky130_fd_sc_hd__ebufn_2
Xfill_21_8 VGND VGND VPWR VPWR sky130_fd_sc_hd__decap_12
Xfill_14_7 VGND VPWR sky130_fd_sc_hd__tapvpwrvgnd_1
XSLICE_16\[0\].RAM16.SLICE\[1\].RAM8.WORD\[5\].W.BYTE\[1\].B.BIT\[0\].genblk1.STORAGE
+ DIBUF\[8\].X SLICE_16\[0\].RAM16.SLICE\[1\].RAM8.WORD\[5\].W.BYTE\[1\].B.GCLK VGND
+ VGND VPWR VPWR SLICE_16\[0\].RAM16.SLICE\[1\].RAM8.WORD\[5\].W.BYTE\[1\].B.Q_WIRE\[0\]
+ sky130_fd_sc_hd__dlxtp_1
XSLICE_16\[1\].RAM16.SLICE\[1\].RAM8.WORD\[7\].W.BYTE\[1\].B.SEL0INV SLICE_16\[1\].RAM16.SLICE\[1\].RAM8.WORD\[7\].W.BYTE\[0\].B.SEL0
+ VGND VGND VPWR VPWR SLICE_16\[1\].RAM16.SLICE\[1\].RAM8.WORD\[7\].W.BYTE\[1\].B.SEL0_B
+ sky130_fd_sc_hd__inv_1
XSLICE_16\[1\].RAM16.SLICE\[0\].RAM8.WORD\[1\].W.BYTE\[1\].B.DIODE_CLK SLICE_16\[1\].RAM16.SLICE\[0\].RAM8.WORD\[1\].W.BYTE\[0\].B.CLK
+ VGND VGND VPWR VPWR sky130_fd_sc_hd__diode_2
XSLICE_16\[0\].RAM16.SLICE\[0\].RAM8.WORD\[4\].W.BYTE\[1\].B.genblk1.CG SLICE_16\[0\].RAM16.SLICE\[0\].RAM8.WORD\[4\].W.BYTE\[1\].B.CLK_B
+ SLICE_16\[0\].RAM16.SLICE\[0\].RAM8.WORD\[4\].W.BYTE\[1\].B.WE0_WIRE VGND VGND VPWR
+ VPWR SLICE_16\[0\].RAM16.SLICE\[0\].RAM8.WORD\[4\].W.BYTE\[1\].B.GCLK sky130_fd_sc_hd__dlclkp_1
XSLICE_16\[0\].RAM16.SLICE\[0\].RAM8.WORD\[4\].W.BYTE\[2\].B.BIT\[6\].OBUF0 SLICE_16\[0\].RAM16.SLICE\[0\].RAM8.WORD\[4\].W.BYTE\[2\].B.Q_WIRE\[6\]
+ SLICE_16\[0\].RAM16.SLICE\[0\].RAM8.WORD\[4\].W.BYTE\[2\].B.SEL0_B VGND VGND VPWR
+ VPWR SLICE_16\[0\].RAM16.BYTE\[2\].FLOATBUF0\[22\].Z sky130_fd_sc_hd__ebufn_2
Xfill_40_0 VGND VPWR sky130_fd_sc_hd__tapvpwrvgnd_1
XSLICE_16\[1\].RAM16.SLICE\[1\].RAM8.WORD\[6\].W.BYTE\[2\].B.BIT\[3\].OBUF0 SLICE_16\[1\].RAM16.SLICE\[1\].RAM8.WORD\[6\].W.BYTE\[2\].B.Q_WIRE\[3\]
+ SLICE_16\[1\].RAM16.SLICE\[1\].RAM8.WORD\[6\].W.BYTE\[2\].B.SEL0_B VGND VGND VPWR
+ VPWR SLICE_16\[1\].RAM16.BYTE\[2\].FLOATBUF0\[19\].Z sky130_fd_sc_hd__ebufn_2
XSLICE_16\[0\].RAM16.SLICE\[0\].RAM8.WORD\[4\].W.BYTE\[3\].B.BIT\[7\].genblk1.STORAGE
+ DIBUF\[31\].X SLICE_16\[0\].RAM16.SLICE\[0\].RAM8.WORD\[4\].W.BYTE\[3\].B.GCLK VGND
+ VGND VPWR VPWR SLICE_16\[0\].RAM16.SLICE\[0\].RAM8.WORD\[4\].W.BYTE\[3\].B.Q_WIRE\[7\]
+ sky130_fd_sc_hd__dlxtp_1
XSLICE_16\[0\].RAM16.SLICE\[0\].RAM8.WORD\[2\].W.BYTE\[1\].B.BIT\[6\].genblk1.STORAGE
+ DIBUF\[14\].X SLICE_16\[0\].RAM16.SLICE\[0\].RAM8.WORD\[2\].W.BYTE\[1\].B.GCLK VGND
+ VGND VPWR VPWR SLICE_16\[0\].RAM16.SLICE\[0\].RAM8.WORD\[2\].W.BYTE\[1\].B.Q_WIRE\[6\]
+ sky130_fd_sc_hd__dlxtp_1
XSLICE_16\[1\].RAM16.SLICE\[0\].RAM8.WORD\[3\].W.BYTE\[0\].B.SEL0INV SLICE_16\[1\].RAM16.SLICE\[0\].RAM8.WORD\[3\].W.BYTE\[0\].B.SEL0
+ VGND VGND VPWR VPWR SLICE_16\[1\].RAM16.SLICE\[0\].RAM8.WORD\[3\].W.BYTE\[0\].B.SEL0_B
+ sky130_fd_sc_hd__inv_1
XSLICE_16\[1\].RAM16.SLICE\[0\].RAM8.WORD\[1\].W.BYTE\[1\].B.BIT\[2\].OBUF0 SLICE_16\[1\].RAM16.SLICE\[0\].RAM8.WORD\[1\].W.BYTE\[1\].B.Q_WIRE\[2\]
+ SLICE_16\[1\].RAM16.SLICE\[0\].RAM8.WORD\[1\].W.BYTE\[1\].B.SEL0_B VGND VGND VPWR
+ VPWR SLICE_16\[1\].RAM16.BYTE\[1\].FLOATBUF0\[10\].Z sky130_fd_sc_hd__ebufn_2
Xtap_18_20 VGND VPWR sky130_fd_sc_hd__tapvpwrvgnd_1
XSLICE_16\[0\].RAM16.SLICE\[0\].RAM8.WORD\[4\].W.BYTE\[0\].B.DIODE_CLK SLICE_16\[0\].RAM16.SLICE\[0\].RAM8.WORD\[4\].W.BYTE\[0\].B.CLK
+ VGND VGND VPWR VPWR sky130_fd_sc_hd__diode_2
Xtap_34_30 VGND VPWR sky130_fd_sc_hd__tapvpwrvgnd_1
XSLICE_16\[1\].RAM16.SLICE\[1\].RAM8.DEC0.AND6 SLICE_16\[1\].RAM16.SLICE\[1\].RAM8.DEC0.A_buf\[0\]
+ SLICE_16\[1\].RAM16.SLICE\[1\].RAM8.DEC0.A_buf\[1\] SLICE_16\[1\].RAM16.SLICE\[1\].RAM8.DEC0.A_buf\[2\]
+ SLICE_16\[1\].RAM16.SLICE\[1\].RAM8.DEC0.EN_buf VGND VGND VPWR VPWR SLICE_16\[1\].RAM16.SLICE\[1\].RAM8.DEC0.SEL\[6\]
+ sky130_fd_sc_hd__and4b_2
XSLICE_16\[1\].RAM16.SLICE\[0\].RAM8.WORD\[1\].W.BYTE\[0\].B.genblk1.CG SLICE_16\[1\].RAM16.SLICE\[0\].RAM8.WORD\[1\].W.BYTE\[0\].B.CLK_B
+ SLICE_16\[1\].RAM16.SLICE\[0\].RAM8.WORD\[1\].W.BYTE\[0\].B.WE0_WIRE VGND VGND VPWR
+ VPWR SLICE_16\[1\].RAM16.SLICE\[0\].RAM8.WORD\[1\].W.BYTE\[0\].B.GCLK sky130_fd_sc_hd__dlclkp_1
Xfill_22_95 VGND VGND VPWR VPWR sky130_fd_sc_hd__decap_12
Xfill_22_84 VGND VPWR sky130_fd_sc_hd__tapvpwrvgnd_1
Xfill_22_73 VGND VGND VPWR VPWR sky130_fd_sc_hd__decap_12
Xfill_22_62 VGND VGND VPWR VPWR sky130_fd_sc_hd__decap_12
Xfill_22_51 VGND VPWR sky130_fd_sc_hd__tapvpwrvgnd_1
Xfill_22_40 VGND VGND VPWR VPWR sky130_fd_sc_hd__decap_12
XSLICE_16\[0\].RAM16.SLICE\[0\].RAM8.WORD\[3\].W.BYTE\[0\].B.BIT\[3\].OBUF0 SLICE_16\[0\].RAM16.SLICE\[0\].RAM8.WORD\[3\].W.BYTE\[0\].B.Q_WIRE\[3\]
+ SLICE_16\[0\].RAM16.SLICE\[0\].RAM8.WORD\[3\].W.BYTE\[0\].B.SEL0_B VGND VGND VPWR
+ VPWR SLICE_16\[0\].RAM16.BYTE\[0\].FLOATBUF0\[3\].Z sky130_fd_sc_hd__ebufn_2
XSLICE_16\[1\].RAM16.SLICE\[1\].RAM8.WORD\[5\].W.BYTE\[0\].B.BIT\[0\].OBUF0 SLICE_16\[1\].RAM16.SLICE\[1\].RAM8.WORD\[5\].W.BYTE\[0\].B.Q_WIRE\[0\]
+ SLICE_16\[1\].RAM16.SLICE\[1\].RAM8.WORD\[5\].W.BYTE\[0\].B.SEL0_B VGND VGND VPWR
+ VPWR SLICE_16\[1\].RAM16.BYTE\[0\].FLOATBUF0\[0\].Z sky130_fd_sc_hd__ebufn_2
XSLICE_16\[0\].RAM16.SLICE\[1\].RAM8.WORD\[5\].W.BYTE\[2\].B.SEL0INV SLICE_16\[0\].RAM16.SLICE\[1\].RAM8.WORD\[5\].W.BYTE\[0\].B.SEL0
+ VGND VGND VPWR VPWR SLICE_16\[0\].RAM16.SLICE\[1\].RAM8.WORD\[5\].W.BYTE\[2\].B.SEL0_B
+ sky130_fd_sc_hd__inv_1
XSLICE_16\[0\].RAM16.SLICE\[0\].RAM8.WORD\[7\].W.BYTE\[3\].B.BIT\[6\].OBUF0 SLICE_16\[0\].RAM16.SLICE\[0\].RAM8.WORD\[7\].W.BYTE\[3\].B.Q_WIRE\[6\]
+ SLICE_16\[0\].RAM16.SLICE\[0\].RAM8.WORD\[7\].W.BYTE\[3\].B.SEL0_B VGND VGND VPWR
+ VPWR SLICE_16\[0\].RAM16.BYTE\[3\].FLOATBUF0\[30\].Z sky130_fd_sc_hd__ebufn_2
XSLICE_16\[1\].RAM16.SLICE\[1\].RAM8.WORD\[7\].W.BYTE\[2\].B.BIT\[4\].genblk1.STORAGE
+ DIBUF\[20\].X SLICE_16\[1\].RAM16.SLICE\[1\].RAM8.WORD\[7\].W.BYTE\[2\].B.GCLK VGND
+ VGND VPWR VPWR SLICE_16\[1\].RAM16.SLICE\[1\].RAM8.WORD\[7\].W.BYTE\[2\].B.Q_WIRE\[4\]
+ sky130_fd_sc_hd__dlxtp_1
XSLICE_16\[1\].RAM16.SLICE\[1\].RAM8.WORD\[5\].W.BYTE\[0\].B.BIT\[3\].genblk1.STORAGE
+ DIBUF\[3\].X SLICE_16\[1\].RAM16.SLICE\[1\].RAM8.WORD\[5\].W.BYTE\[0\].B.GCLK VGND
+ VGND VPWR VPWR SLICE_16\[1\].RAM16.SLICE\[1\].RAM8.WORD\[5\].W.BYTE\[0\].B.Q_WIRE\[3\]
+ sky130_fd_sc_hd__dlxtp_1
XSLICE_16\[1\].RAM16.SLICE\[1\].RAM8.WORD\[1\].W.BYTE\[3\].B.BIT\[5\].genblk1.STORAGE
+ DIBUF\[29\].X SLICE_16\[1\].RAM16.SLICE\[1\].RAM8.WORD\[1\].W.BYTE\[3\].B.GCLK VGND
+ VGND VPWR VPWR SLICE_16\[1\].RAM16.SLICE\[1\].RAM8.WORD\[1\].W.BYTE\[3\].B.Q_WIRE\[5\]
+ sky130_fd_sc_hd__dlxtp_1
Xfill_12_4 VGND VGND VPWR VPWR sky130_fd_sc_hd__fill_2
XSLICE_16\[1\].RAM16.SLICE\[1\].RAM8.WORD\[7\].W.BYTE\[1\].B.CGAND SLICE_16\[1\].RAM16.SLICE\[1\].RAM8.WORD\[7\].W.BYTE\[0\].B.SEL0
+ SLICE_16\[1\].RAM16.SLICE\[1\].RAM8.WE0_buf\[1\] VGND VGND VPWR VPWR SLICE_16\[1\].RAM16.SLICE\[1\].RAM8.WORD\[7\].W.BYTE\[1\].B.WE0_WIRE
+ sky130_fd_sc_hd__and2_1
XSLICE_16\[1\].RAM16.SLICE\[0\].RAM8.WORD\[4\].W.BYTE\[2\].B.BIT\[2\].OBUF0 SLICE_16\[1\].RAM16.SLICE\[0\].RAM8.WORD\[4\].W.BYTE\[2\].B.Q_WIRE\[2\]
+ SLICE_16\[1\].RAM16.SLICE\[0\].RAM8.WORD\[4\].W.BYTE\[2\].B.SEL0_B VGND VGND VPWR
+ VPWR SLICE_16\[1\].RAM16.BYTE\[2\].FLOATBUF0\[18\].Z sky130_fd_sc_hd__ebufn_2
XSLICE_16\[1\].RAM16.SLICE\[0\].RAM8.WORD\[0\].W.BYTE\[3\].B.BIT\[0\].genblk1.STORAGE
+ DIBUF\[24\].X SLICE_16\[1\].RAM16.SLICE\[0\].RAM8.WORD\[0\].W.BYTE\[3\].B.GCLK VGND
+ VGND VPWR VPWR SLICE_16\[1\].RAM16.SLICE\[0\].RAM8.WORD\[0\].W.BYTE\[3\].B.Q_WIRE\[0\]
+ sky130_fd_sc_hd__dlxtp_1
XSLICE_16\[0\].RAM16.Do0_REG.OUTREG_BYTE\[1\].DIODE\[5\] SLICE_16\[0\].RAM16.BYTE\[1\].FLOATBUF0\[13\].Z
+ VGND VGND VPWR VPWR sky130_fd_sc_hd__diode_2
XSLICE_16\[0\].RAM16.SLICE\[0\].RAM8.WORD\[1\].W.BYTE\[1\].B.SEL0INV SLICE_16\[0\].RAM16.SLICE\[0\].RAM8.WORD\[1\].W.BYTE\[0\].B.SEL0
+ VGND VGND VPWR VPWR SLICE_16\[0\].RAM16.SLICE\[0\].RAM8.WORD\[1\].W.BYTE\[1\].B.SEL0_B
+ sky130_fd_sc_hd__inv_1
Xtap_1_36 VGND VPWR sky130_fd_sc_hd__tapvpwrvgnd_1
Xtap_1_25 VGND VPWR sky130_fd_sc_hd__tapvpwrvgnd_1
Xtap_1_14 VGND VPWR sky130_fd_sc_hd__tapvpwrvgnd_1
XSLICE_16\[0\].RAM16.SLICE\[1\].RAM8.WORD\[2\].W.BYTE\[3\].B.BIT\[1\].genblk1.STORAGE
+ DIBUF\[25\].X SLICE_16\[0\].RAM16.SLICE\[1\].RAM8.WORD\[2\].W.BYTE\[3\].B.GCLK VGND
+ VGND VPWR VPWR SLICE_16\[0\].RAM16.SLICE\[1\].RAM8.WORD\[2\].W.BYTE\[3\].B.Q_WIRE\[1\]
+ sky130_fd_sc_hd__dlxtp_1
Xfill_43_39 VGND VPWR sky130_fd_sc_hd__tapvpwrvgnd_1
Xfill_43_28 VGND VGND VPWR VPWR sky130_fd_sc_hd__decap_12
Xfill_43_17 VGND VGND VPWR VPWR sky130_fd_sc_hd__decap_12
XSLICE_16\[0\].RAM16.SLICE\[1\].RAM8.WORD\[0\].W.BYTE\[1\].B.BIT\[0\].genblk1.STORAGE
+ DIBUF\[8\].X SLICE_16\[0\].RAM16.SLICE\[1\].RAM8.WORD\[0\].W.BYTE\[1\].B.GCLK VGND
+ VGND VPWR VPWR SLICE_16\[0\].RAM16.SLICE\[1\].RAM8.WORD\[0\].W.BYTE\[1\].B.Q_WIRE\[0\]
+ sky130_fd_sc_hd__dlxtp_1
XSLICE_16\[0\].RAM16.SLICE\[0\].RAM8.WORD\[1\].W.BYTE\[3\].B.genblk1.CLKINV SLICE_16\[0\].RAM16.SLICE\[0\].RAM8.WORD\[1\].W.BYTE\[0\].B.CLK
+ VGND VGND VPWR VPWR SLICE_16\[0\].RAM16.SLICE\[0\].RAM8.WORD\[1\].W.BYTE\[3\].B.CLK_B
+ sky130_fd_sc_hd__inv_1
XSLICE_16\[0\].RAM16.SLICE\[0\].RAM8.WORD\[6\].W.BYTE\[1\].B.BIT\[3\].OBUF0 SLICE_16\[0\].RAM16.SLICE\[0\].RAM8.WORD\[6\].W.BYTE\[1\].B.Q_WIRE\[3\]
+ SLICE_16\[0\].RAM16.SLICE\[0\].RAM8.WORD\[6\].W.BYTE\[1\].B.SEL0_B VGND VGND VPWR
+ VPWR SLICE_16\[0\].RAM16.BYTE\[1\].FLOATBUF0\[11\].Z sky130_fd_sc_hd__ebufn_2
Xtap_39_1 VGND VPWR sky130_fd_sc_hd__tapvpwrvgnd_1
Xtap_29_30 VGND VPWR sky130_fd_sc_hd__tapvpwrvgnd_1
Xfill_17_51 VGND VPWR sky130_fd_sc_hd__tapvpwrvgnd_1
Xfill_17_40 VGND VGND VPWR VPWR sky130_fd_sc_hd__decap_12
XSLICE_16\[0\].RAM16.SLICE\[0\].RAM8.WORD\[5\].W.BYTE\[2\].B.BIT\[6\].genblk1.STORAGE
+ DIBUF\[22\].X SLICE_16\[0\].RAM16.SLICE\[0\].RAM8.WORD\[5\].W.BYTE\[2\].B.GCLK VGND
+ VGND VPWR VPWR SLICE_16\[0\].RAM16.SLICE\[0\].RAM8.WORD\[5\].W.BYTE\[2\].B.Q_WIRE\[6\]
+ sky130_fd_sc_hd__dlxtp_1
Xfill_17_62 VGND VGND VPWR VPWR sky130_fd_sc_hd__decap_12
XSLICE_16\[0\].RAM16.SLICE\[0\].RAM8.WORD\[3\].W.BYTE\[0\].B.BIT\[5\].genblk1.STORAGE
+ DIBUF\[5\].X SLICE_16\[0\].RAM16.SLICE\[0\].RAM8.WORD\[3\].W.BYTE\[0\].B.GCLK VGND
+ VGND VPWR VPWR SLICE_16\[0\].RAM16.SLICE\[0\].RAM8.WORD\[3\].W.BYTE\[0\].B.Q_WIRE\[5\]
+ sky130_fd_sc_hd__dlxtp_1
XSLICE_16\[0\].RAM16.SLICE\[0\].RAM8.WORD\[7\].W.BYTE\[3\].B.DIODE_CLK SLICE_16\[0\].RAM16.SLICE\[0\].RAM8.WORD\[7\].W.BYTE\[0\].B.CLK
+ VGND VGND VPWR VPWR sky130_fd_sc_hd__diode_2
XSLICE_16\[1\].RAM16.SLICE\[0\].RAM8.WORD\[7\].W.BYTE\[3\].B.BIT\[2\].OBUF0 SLICE_16\[1\].RAM16.SLICE\[0\].RAM8.WORD\[7\].W.BYTE\[3\].B.Q_WIRE\[2\]
+ SLICE_16\[1\].RAM16.SLICE\[0\].RAM8.WORD\[7\].W.BYTE\[3\].B.SEL0_B VGND VGND VPWR
+ VPWR SLICE_16\[1\].RAM16.BYTE\[3\].FLOATBUF0\[26\].Z sky130_fd_sc_hd__ebufn_2
XSLICE_16\[1\].RAM16.SLICE\[1\].RAM8.WORD\[3\].W.BYTE\[1\].B.DIODE_CLK SLICE_16\[1\].RAM16.SLICE\[1\].RAM8.WORD\[3\].W.BYTE\[0\].B.CLK
+ VGND VGND VPWR VPWR sky130_fd_sc_hd__diode_2
XSLICE_16\[1\].RAM16.SLICE\[1\].RAM8.WORD\[6\].W.BYTE\[0\].B.genblk1.CG SLICE_16\[1\].RAM16.SLICE\[1\].RAM8.WORD\[6\].W.BYTE\[0\].B.CLK_B
+ SLICE_16\[1\].RAM16.SLICE\[1\].RAM8.WORD\[6\].W.BYTE\[0\].B.WE0_WIRE VGND VGND VPWR
+ VPWR SLICE_16\[1\].RAM16.SLICE\[1\].RAM8.WORD\[6\].W.BYTE\[0\].B.GCLK sky130_fd_sc_hd__dlclkp_1
XSLICE_16\[1\].RAM16.SLICE\[0\].RAM8.WORD\[4\].W.BYTE\[0\].B.BIT\[7\].OBUF0 SLICE_16\[1\].RAM16.SLICE\[0\].RAM8.WORD\[4\].W.BYTE\[0\].B.Q_WIRE\[7\]
+ SLICE_16\[1\].RAM16.SLICE\[0\].RAM8.WORD\[4\].W.BYTE\[0\].B.SEL0_B VGND VGND VPWR
+ VPWR SLICE_16\[1\].RAM16.BYTE\[0\].FLOATBUF0\[7\].Z sky130_fd_sc_hd__ebufn_2
Xfill_8_3 VGND VPWR sky130_fd_sc_hd__tapvpwrvgnd_1
XSLICE_16\[0\].RAM16.SLICE\[1\].RAM8.WORD\[1\].W.BYTE\[2\].B.BIT\[6\].OBUF0 SLICE_16\[0\].RAM16.SLICE\[1\].RAM8.WORD\[1\].W.BYTE\[2\].B.Q_WIRE\[6\]
+ SLICE_16\[0\].RAM16.SLICE\[1\].RAM8.WORD\[1\].W.BYTE\[2\].B.SEL0_B VGND VGND VPWR
+ VPWR SLICE_16\[0\].RAM16.BYTE\[2\].FLOATBUF0\[22\].Z sky130_fd_sc_hd__ebufn_2
Xfill_10_1 VGND VPWR sky130_fd_sc_hd__tapvpwrvgnd_1
XSLICE_16\[0\].RAM16.Do0_REG.OUTREG_BYTE\[0\].Do_FF\[6\] SLICE_16\[0\].RAM16.Do0_REG.CLKBUF\[0\]
+ SLICE_16\[0\].RAM16.BYTE\[0\].FLOATBUF0\[6\].Z VGND VGND VPWR VPWR Do0MUX.A0\[6\]
+ sky130_fd_sc_hd__dfxtp_1
Xtap_32_8 VGND VPWR sky130_fd_sc_hd__tapvpwrvgnd_1
Xtap_25_7 VGND VPWR sky130_fd_sc_hd__tapvpwrvgnd_1
XSLICE_16\[0\].RAM16.SLICE\[1\].RAM8.WORD\[6\].W.BYTE\[0\].B.DIODE_CLK SLICE_16\[0\].RAM16.SLICE\[1\].RAM8.WORD\[6\].W.BYTE\[0\].B.CLK
+ VGND VGND VPWR VPWR sky130_fd_sc_hd__diode_2
XSLICE_16\[1\].RAM16.SLICE\[1\].RAM8.WORD\[2\].W.BYTE\[2\].B.BIT\[4\].genblk1.STORAGE
+ DIBUF\[20\].X SLICE_16\[1\].RAM16.SLICE\[1\].RAM8.WORD\[2\].W.BYTE\[2\].B.GCLK VGND
+ VGND VPWR VPWR SLICE_16\[1\].RAM16.SLICE\[1\].RAM8.WORD\[2\].W.BYTE\[2\].B.Q_WIRE\[4\]
+ sky130_fd_sc_hd__dlxtp_1
Xtap_18_6 VGND VPWR sky130_fd_sc_hd__tapvpwrvgnd_1
Xtap_15_32 VGND VPWR sky130_fd_sc_hd__tapvpwrvgnd_1
Xtap_15_21 VGND VPWR sky130_fd_sc_hd__tapvpwrvgnd_1
Xtap_15_10 VGND VPWR sky130_fd_sc_hd__tapvpwrvgnd_1
Xtap_31_31 VGND VPWR sky130_fd_sc_hd__tapvpwrvgnd_1
Xtap_31_20 VGND VPWR sky130_fd_sc_hd__tapvpwrvgnd_1
XSLICE_16\[1\].RAM16.SLICE\[1\].RAM8.WORD\[0\].W.BYTE\[0\].B.BIT\[3\].genblk1.STORAGE
+ DIBUF\[3\].X SLICE_16\[1\].RAM16.SLICE\[1\].RAM8.WORD\[0\].W.BYTE\[0\].B.GCLK VGND
+ VGND VPWR VPWR SLICE_16\[1\].RAM16.SLICE\[1\].RAM8.WORD\[0\].W.BYTE\[0\].B.Q_WIRE\[3\]
+ sky130_fd_sc_hd__dlxtp_1
XSLICE_16\[1\].RAM16.SLICE\[0\].RAM8.WORD\[2\].W.BYTE\[1\].B.CGAND SLICE_16\[1\].RAM16.SLICE\[0\].RAM8.WORD\[2\].W.BYTE\[0\].B.SEL0
+ SLICE_16\[1\].RAM16.SLICE\[0\].RAM8.WE0_buf\[1\] VGND VGND VPWR VPWR SLICE_16\[1\].RAM16.SLICE\[0\].RAM8.WORD\[2\].W.BYTE\[1\].B.WE0_WIRE
+ sky130_fd_sc_hd__and2_1
XSLICE_16\[0\].RAM16.SLICE\[1\].RAM8.WORD\[3\].W.BYTE\[2\].B.BIT\[0\].genblk1.STORAGE
+ DIBUF\[16\].X SLICE_16\[0\].RAM16.SLICE\[1\].RAM8.WORD\[3\].W.BYTE\[2\].B.GCLK VGND
+ VGND VPWR VPWR SLICE_16\[0\].RAM16.SLICE\[1\].RAM8.WORD\[3\].W.BYTE\[2\].B.Q_WIRE\[0\]
+ sky130_fd_sc_hd__dlxtp_1
XSLICE_16\[0\].RAM16.SLICE\[1\].RAM8.WORD\[0\].W.BYTE\[0\].B.BIT\[3\].OBUF0 SLICE_16\[0\].RAM16.SLICE\[1\].RAM8.WORD\[0\].W.BYTE\[0\].B.Q_WIRE\[3\]
+ SLICE_16\[0\].RAM16.SLICE\[1\].RAM8.WORD\[0\].W.BYTE\[0\].B.SEL0_B VGND VGND VPWR
+ VPWR SLICE_16\[0\].RAM16.BYTE\[0\].FLOATBUF0\[3\].Z sky130_fd_sc_hd__ebufn_2
Xfill_39_9 VGND VPWR sky130_fd_sc_hd__tapvpwrvgnd_1
XSLICE_16\[1\].RAM16.SLICE\[1\].RAM8.WORD\[3\].W.BYTE\[2\].B.SEL0INV SLICE_16\[1\].RAM16.SLICE\[1\].RAM8.WORD\[3\].W.BYTE\[0\].B.SEL0
+ VGND VGND VPWR VPWR SLICE_16\[1\].RAM16.SLICE\[1\].RAM8.WORD\[3\].W.BYTE\[2\].B.SEL0_B
+ sky130_fd_sc_hd__inv_1
XSLICE_16\[1\].RAM16.SLICE\[0\].RAM8.WORD\[7\].W.BYTE\[1\].B.BIT\[7\].OBUF0 SLICE_16\[1\].RAM16.SLICE\[0\].RAM8.WORD\[7\].W.BYTE\[1\].B.Q_WIRE\[7\]
+ SLICE_16\[1\].RAM16.SLICE\[0\].RAM8.WORD\[7\].W.BYTE\[1\].B.SEL0_B VGND VGND VPWR
+ VPWR SLICE_16\[1\].RAM16.BYTE\[1\].FLOATBUF0\[15\].Z sky130_fd_sc_hd__ebufn_2
XSLICE_16\[0\].RAM16.SLICE\[1\].RAM8.WORD\[4\].W.BYTE\[3\].B.BIT\[6\].OBUF0 SLICE_16\[0\].RAM16.SLICE\[1\].RAM8.WORD\[4\].W.BYTE\[3\].B.Q_WIRE\[6\]
+ SLICE_16\[0\].RAM16.SLICE\[1\].RAM8.WORD\[4\].W.BYTE\[3\].B.SEL0_B VGND VGND VPWR
+ VPWR SLICE_16\[0\].RAM16.BYTE\[3\].FLOATBUF0\[30\].Z sky130_fd_sc_hd__ebufn_2
Xfill_44_93 VGND VPWR sky130_fd_sc_hd__tapvpwrvgnd_1
Xfill_44_82 VGND VGND VPWR VPWR sky130_fd_sc_hd__decap_12
Xfill_44_71 VGND VGND VPWR VPWR sky130_fd_sc_hd__decap_12
Xfill_44_60 VGND VPWR sky130_fd_sc_hd__tapvpwrvgnd_1
Xfill_41_100 VGND VGND VPWR VPWR sky130_fd_sc_hd__decap_12
XSLICE_16\[0\].RAM16.SLICE\[0\].RAM8.WORD\[0\].W.BYTE\[2\].B.BIT\[6\].genblk1.STORAGE
+ DIBUF\[22\].X SLICE_16\[0\].RAM16.SLICE\[0\].RAM8.WORD\[0\].W.BYTE\[2\].B.GCLK VGND
+ VGND VPWR VPWR SLICE_16\[0\].RAM16.SLICE\[0\].RAM8.WORD\[0\].W.BYTE\[2\].B.Q_WIRE\[6\]
+ sky130_fd_sc_hd__dlxtp_1
XSLICE_16\[0\].RAM16.SLICE\[0\].RAM8.WORD\[6\].W.BYTE\[1\].B.BIT\[5\].genblk1.STORAGE
+ DIBUF\[13\].X SLICE_16\[0\].RAM16.SLICE\[0\].RAM8.WORD\[6\].W.BYTE\[1\].B.GCLK VGND
+ VGND VPWR VPWR SLICE_16\[0\].RAM16.SLICE\[0\].RAM8.WORD\[6\].W.BYTE\[1\].B.Q_WIRE\[5\]
+ sky130_fd_sc_hd__dlxtp_1
XSLICE_16\[1\].RAM16.SLICE\[1\].RAM8.WORD\[1\].W.BYTE\[2\].B.BIT\[2\].OBUF0 SLICE_16\[1\].RAM16.SLICE\[1\].RAM8.WORD\[1\].W.BYTE\[2\].B.Q_WIRE\[2\]
+ SLICE_16\[1\].RAM16.SLICE\[1\].RAM8.WORD\[1\].W.BYTE\[2\].B.SEL0_B VGND VGND VPWR
+ VPWR SLICE_16\[1\].RAM16.BYTE\[2\].FLOATBUF0\[18\].Z sky130_fd_sc_hd__ebufn_2
Xtap_7_13 VGND VPWR sky130_fd_sc_hd__tapvpwrvgnd_1
Xtap_7_24 VGND VPWR sky130_fd_sc_hd__tapvpwrvgnd_1
Xtap_7_35 VGND VPWR sky130_fd_sc_hd__tapvpwrvgnd_1
Xfill_6_0 VGND VPWR sky130_fd_sc_hd__tapvpwrvgnd_1
Xfill_40_29 VGND VGND VPWR VPWR sky130_fd_sc_hd__fill_2
Xfill_40_18 VGND VPWR sky130_fd_sc_hd__tapvpwrvgnd_1
XSLICE_16\[1\].RAM16.SLICE\[1\].RAM8.WEBUF\[3\].__cell__ SLICE_16\[1\].RAM16.SLICE\[0\].RAM8.WE0\[3\]
+ VGND VGND VPWR VPWR SLICE_16\[1\].RAM16.SLICE\[1\].RAM8.WE0_buf\[3\] sky130_fd_sc_hd__clkbuf_2
XSLICE_16\[1\].RAM16.Do0_REG.OUTREG_BYTE\[0\].DIODE\[1\] SLICE_16\[1\].RAM16.BYTE\[0\].FLOATBUF0\[1\].Z
+ VGND VGND VPWR VPWR sky130_fd_sc_hd__diode_2
Xtap_30_5 VGND VPWR sky130_fd_sc_hd__tapvpwrvgnd_1
Xtap_23_4 VGND VPWR sky130_fd_sc_hd__tapvpwrvgnd_1
Xtap_16_3 VGND VPWR sky130_fd_sc_hd__tapvpwrvgnd_1
XSLICE_16\[0\].RAM16.SLICE\[1\].RAM8.WORD\[3\].W.BYTE\[1\].B.BIT\[3\].OBUF0 SLICE_16\[0\].RAM16.SLICE\[1\].RAM8.WORD\[3\].W.BYTE\[1\].B.Q_WIRE\[3\]
+ SLICE_16\[0\].RAM16.SLICE\[1\].RAM8.WORD\[3\].W.BYTE\[1\].B.SEL0_B VGND VGND VPWR
+ VPWR SLICE_16\[0\].RAM16.BYTE\[1\].FLOATBUF0\[11\].Z sky130_fd_sc_hd__ebufn_2
XSLICE_16\[0\].RAM16.SLICE\[0\].RAM8.WORD\[4\].W.BYTE\[3\].B.CGAND SLICE_16\[0\].RAM16.SLICE\[0\].RAM8.WORD\[4\].W.BYTE\[0\].B.SEL0
+ SLICE_16\[0\].RAM16.SLICE\[0\].RAM8.WE0_buf\[3\] VGND VGND VPWR VPWR SLICE_16\[0\].RAM16.SLICE\[0\].RAM8.WORD\[4\].W.BYTE\[3\].B.WE0_WIRE
+ sky130_fd_sc_hd__and2_1
Xtap_26_31 VGND VPWR sky130_fd_sc_hd__tapvpwrvgnd_1
Xtap_26_20 VGND VPWR sky130_fd_sc_hd__tapvpwrvgnd_1
XA0BUF\[0\].__cell__ A0[0] VGND VGND VPWR VPWR A0BUF\[0\].X sky130_fd_sc_hd__clkbuf_2
Xtap_9_2 VGND VPWR sky130_fd_sc_hd__tapvpwrvgnd_1
XSLICE_16\[0\].RAM16.SLICE\[1\].RAM8.WORD\[1\].W.BYTE\[3\].B.SEL0INV SLICE_16\[0\].RAM16.SLICE\[1\].RAM8.WORD\[1\].W.BYTE\[0\].B.SEL0
+ VGND VGND VPWR VPWR SLICE_16\[0\].RAM16.SLICE\[1\].RAM8.WORD\[1\].W.BYTE\[3\].B.SEL0_B
+ sky130_fd_sc_hd__inv_1
XSLICE_16\[1\].RAM16.SLICE\[1\].RAM8.WORD\[5\].W.BYTE\[3\].B.BIT\[4\].genblk1.STORAGE
+ DIBUF\[28\].X SLICE_16\[1\].RAM16.SLICE\[1\].RAM8.WORD\[5\].W.BYTE\[3\].B.GCLK VGND
+ VGND VPWR VPWR SLICE_16\[1\].RAM16.SLICE\[1\].RAM8.WORD\[5\].W.BYTE\[3\].B.Q_WIRE\[4\]
+ sky130_fd_sc_hd__dlxtp_1
XSLICE_16\[0\].RAM16.SLICE\[0\].RAM8.WORD\[2\].W.BYTE\[3\].B.BIT\[5\].OBUF0 SLICE_16\[0\].RAM16.SLICE\[0\].RAM8.WORD\[2\].W.BYTE\[3\].B.Q_WIRE\[5\]
+ SLICE_16\[0\].RAM16.SLICE\[0\].RAM8.WORD\[2\].W.BYTE\[3\].B.SEL0_B VGND VGND VPWR
+ VPWR SLICE_16\[0\].RAM16.BYTE\[3\].FLOATBUF0\[29\].Z sky130_fd_sc_hd__ebufn_2
Xfill_44_7 VGND VGND VPWR VPWR sky130_fd_sc_hd__decap_12
Xfill_39_60 VGND VPWR sky130_fd_sc_hd__tapvpwrvgnd_1
Xfill_37_6 VGND VPWR sky130_fd_sc_hd__tapvpwrvgnd_1
XSLICE_16\[1\].RAM16.SLICE\[1\].RAM8.WORD\[3\].W.BYTE\[1\].B.BIT\[3\].genblk1.STORAGE
+ DIBUF\[11\].X SLICE_16\[1\].RAM16.SLICE\[1\].RAM8.WORD\[3\].W.BYTE\[1\].B.GCLK VGND
+ VGND VPWR VPWR SLICE_16\[1\].RAM16.SLICE\[1\].RAM8.WORD\[3\].W.BYTE\[1\].B.Q_WIRE\[3\]
+ sky130_fd_sc_hd__dlxtp_1
XSLICE_16\[1\].RAM16.SLICE\[1\].RAM8.WORD\[3\].W.BYTE\[0\].B.CGAND SLICE_16\[1\].RAM16.SLICE\[1\].RAM8.WORD\[3\].W.BYTE\[0\].B.SEL0
+ SLICE_16\[1\].RAM16.SLICE\[1\].RAM8.WE0_buf\[0\] VGND VGND VPWR VPWR SLICE_16\[1\].RAM16.SLICE\[1\].RAM8.WORD\[3\].W.BYTE\[0\].B.WE0_WIRE
+ sky130_fd_sc_hd__and2_1
XSLICE_16\[0\].RAM16.SLICE\[0\].RAM8.WORD\[0\].W.BYTE\[0\].B.genblk1.CG SLICE_16\[0\].RAM16.SLICE\[0\].RAM8.WORD\[0\].W.BYTE\[0\].B.CLK_B
+ SLICE_16\[0\].RAM16.SLICE\[0\].RAM8.WORD\[0\].W.BYTE\[0\].B.WE0_WIRE VGND VGND VPWR
+ VPWR SLICE_16\[0\].RAM16.SLICE\[0\].RAM8.WORD\[0\].W.BYTE\[0\].B.GCLK sky130_fd_sc_hd__dlclkp_1
XSLICE_16\[1\].RAM16.SLICE\[1\].RAM8.WORD\[4\].W.BYTE\[3\].B.BIT\[2\].OBUF0 SLICE_16\[1\].RAM16.SLICE\[1\].RAM8.WORD\[4\].W.BYTE\[3\].B.Q_WIRE\[2\]
+ SLICE_16\[1\].RAM16.SLICE\[1\].RAM8.WORD\[4\].W.BYTE\[3\].B.SEL0_B VGND VGND VPWR
+ VPWR SLICE_16\[1\].RAM16.BYTE\[3\].FLOATBUF0\[26\].Z sky130_fd_sc_hd__ebufn_2
XSLICE_16\[0\].RAM16.SLICE\[1\].RAM8.WORD\[6\].W.BYTE\[3\].B.BIT\[0\].genblk1.STORAGE
+ DIBUF\[24\].X SLICE_16\[0\].RAM16.SLICE\[1\].RAM8.WORD\[6\].W.BYTE\[3\].B.GCLK VGND
+ VGND VPWR VPWR SLICE_16\[0\].RAM16.SLICE\[1\].RAM8.WORD\[6\].W.BYTE\[3\].B.Q_WIRE\[0\]
+ sky130_fd_sc_hd__dlxtp_1
XSLICE_16\[1\].RAM16.SLICE\[0\].RAM8.WORD\[2\].W.BYTE\[3\].B.genblk1.CG SLICE_16\[1\].RAM16.SLICE\[0\].RAM8.WORD\[2\].W.BYTE\[3\].B.CLK_B
+ SLICE_16\[1\].RAM16.SLICE\[0\].RAM8.WORD\[2\].W.BYTE\[3\].B.WE0_WIRE VGND VGND VPWR
+ VPWR SLICE_16\[1\].RAM16.SLICE\[0\].RAM8.WORD\[2\].W.BYTE\[3\].B.GCLK sky130_fd_sc_hd__dlclkp_1
XSLICE_16\[1\].RAM16.SLICE\[1\].RAM8.WORD\[1\].W.BYTE\[0\].B.BIT\[7\].OBUF0 SLICE_16\[1\].RAM16.SLICE\[1\].RAM8.WORD\[1\].W.BYTE\[0\].B.Q_WIRE\[7\]
+ SLICE_16\[1\].RAM16.SLICE\[1\].RAM8.WORD\[1\].W.BYTE\[0\].B.SEL0_B VGND VGND VPWR
+ VPWR SLICE_16\[1\].RAM16.BYTE\[0\].FLOATBUF0\[7\].Z sky130_fd_sc_hd__ebufn_2
Xfill_19_19 VGND VGND VPWR VPWR sky130_fd_sc_hd__decap_12
XSLICE_16\[0\].RAM16.SLICE\[1\].RAM8.WORD\[6\].W.BYTE\[2\].B.BIT\[3\].OBUF0 SLICE_16\[0\].RAM16.SLICE\[1\].RAM8.WORD\[6\].W.BYTE\[2\].B.Q_WIRE\[3\]
+ SLICE_16\[0\].RAM16.SLICE\[1\].RAM8.WORD\[6\].W.BYTE\[2\].B.SEL0_B VGND VGND VPWR
+ VPWR SLICE_16\[0\].RAM16.BYTE\[2\].FLOATBUF0\[19\].Z sky130_fd_sc_hd__ebufn_2
Xtap_2_9 VGND VPWR sky130_fd_sc_hd__tapvpwrvgnd_1
Xtap_12_33 VGND VPWR sky130_fd_sc_hd__tapvpwrvgnd_1
Xtap_12_22 VGND VPWR sky130_fd_sc_hd__tapvpwrvgnd_1
Xtap_12_11 VGND VPWR sky130_fd_sc_hd__tapvpwrvgnd_1
XSLICE_16\[0\].RAM16.SLICE\[0\].RAM8.WORD\[1\].W.BYTE\[1\].B.BIT\[2\].OBUF0 SLICE_16\[0\].RAM16.SLICE\[0\].RAM8.WORD\[1\].W.BYTE\[1\].B.Q_WIRE\[2\]
+ SLICE_16\[0\].RAM16.SLICE\[0\].RAM8.WORD\[1\].W.BYTE\[1\].B.SEL0_B VGND VGND VPWR
+ VPWR SLICE_16\[0\].RAM16.BYTE\[1\].FLOATBUF0\[10\].Z sky130_fd_sc_hd__ebufn_2
Xfill_20_103 VGND VGND VPWR VPWR sky130_fd_sc_hd__fill_2
XSLICE_16\[0\].RAM16.SLICE\[0\].RAM8.WORD\[1\].W.BYTE\[1\].B.BIT\[5\].genblk1.STORAGE
+ DIBUF\[13\].X SLICE_16\[0\].RAM16.SLICE\[0\].RAM8.WORD\[1\].W.BYTE\[1\].B.GCLK VGND
+ VGND VPWR VPWR SLICE_16\[0\].RAM16.SLICE\[0\].RAM8.WORD\[1\].W.BYTE\[1\].B.Q_WIRE\[5\]
+ sky130_fd_sc_hd__dlxtp_1
XSLICE_16\[0\].RAM16.SLICE\[0\].RAM8.WORD\[3\].W.BYTE\[3\].B.BIT\[6\].genblk1.STORAGE
+ DIBUF\[30\].X SLICE_16\[0\].RAM16.SLICE\[0\].RAM8.WORD\[3\].W.BYTE\[3\].B.GCLK VGND
+ VGND VPWR VPWR SLICE_16\[0\].RAM16.SLICE\[0\].RAM8.WORD\[3\].W.BYTE\[3\].B.Q_WIRE\[6\]
+ sky130_fd_sc_hd__dlxtp_1
XSLICE_16\[0\].RAM16.SLICE\[0\].RAM8.WORD\[7\].W.BYTE\[0\].B.BIT\[4\].genblk1.STORAGE
+ DIBUF\[4\].X SLICE_16\[0\].RAM16.SLICE\[0\].RAM8.WORD\[7\].W.BYTE\[0\].B.GCLK VGND
+ VGND VPWR VPWR SLICE_16\[0\].RAM16.SLICE\[0\].RAM8.WORD\[7\].W.BYTE\[0\].B.Q_WIRE\[4\]
+ sky130_fd_sc_hd__dlxtp_1
Xtap_37_30 VGND VPWR sky130_fd_sc_hd__tapvpwrvgnd_1
XSLICE_16\[0\].RAM16.SLICE\[1\].RAM8.WORD\[5\].W.BYTE\[2\].B.CGAND SLICE_16\[0\].RAM16.SLICE\[1\].RAM8.WORD\[5\].W.BYTE\[0\].B.SEL0
+ SLICE_16\[0\].RAM16.SLICE\[1\].RAM8.WE0_buf\[2\] VGND VGND VPWR VPWR SLICE_16\[0\].RAM16.SLICE\[1\].RAM8.WORD\[5\].W.BYTE\[2\].B.WE0_WIRE
+ sky130_fd_sc_hd__and2_1
Xtap_14_0 VGND VPWR sky130_fd_sc_hd__tapvpwrvgnd_1
Xfill_41_94 VGND VGND VPWR VPWR sky130_fd_sc_hd__decap_12
Xfill_41_83 VGND VGND VPWR VPWR sky130_fd_sc_hd__decap_12
Xfill_41_72 VGND VPWR sky130_fd_sc_hd__tapvpwrvgnd_1
Xfill_41_61 VGND VGND VPWR VPWR sky130_fd_sc_hd__decap_12
Xfill_41_50 VGND VGND VPWR VPWR sky130_fd_sc_hd__decap_12
XSLICE_16\[0\].RAM16.SLICE\[1\].RAM8.WORD\[5\].W.BYTE\[0\].B.BIT\[0\].OBUF0 SLICE_16\[0\].RAM16.SLICE\[1\].RAM8.WORD\[5\].W.BYTE\[0\].B.Q_WIRE\[0\]
+ SLICE_16\[0\].RAM16.SLICE\[1\].RAM8.WORD\[5\].W.BYTE\[0\].B.SEL0_B VGND VGND VPWR
+ VPWR SLICE_16\[0\].RAM16.BYTE\[0\].FLOATBUF0\[0\].Z sky130_fd_sc_hd__ebufn_2
XSLICE_16\[1\].RAM16.SLICE\[1\].RAM8.WORD\[7\].W.BYTE\[0\].B.SEL0INV SLICE_16\[1\].RAM16.SLICE\[1\].RAM8.WORD\[7\].W.BYTE\[0\].B.SEL0
+ VGND VGND VPWR VPWR SLICE_16\[1\].RAM16.SLICE\[1\].RAM8.WORD\[7\].W.BYTE\[0\].B.SEL0_B
+ sky130_fd_sc_hd__inv_1
XSLICE_16\[1\].RAM16.SLICE\[1\].RAM8.WORD\[4\].W.BYTE\[1\].B.BIT\[7\].OBUF0 SLICE_16\[1\].RAM16.SLICE\[1\].RAM8.WORD\[4\].W.BYTE\[1\].B.Q_WIRE\[7\]
+ SLICE_16\[1\].RAM16.SLICE\[1\].RAM8.WORD\[4\].W.BYTE\[1\].B.SEL0_B VGND VGND VPWR
+ VPWR SLICE_16\[1\].RAM16.BYTE\[1\].FLOATBUF0\[15\].Z sky130_fd_sc_hd__ebufn_2
XSLICE_16\[1\].RAM16.SLICE\[0\].RAM8.WORD\[2\].W.BYTE\[3\].B.BIT\[1\].OBUF0 SLICE_16\[1\].RAM16.SLICE\[0\].RAM8.WORD\[2\].W.BYTE\[3\].B.Q_WIRE\[1\]
+ SLICE_16\[1\].RAM16.SLICE\[0\].RAM8.WORD\[2\].W.BYTE\[3\].B.SEL0_B VGND VGND VPWR
+ VPWR SLICE_16\[1\].RAM16.BYTE\[3\].FLOATBUF0\[25\].Z sky130_fd_sc_hd__ebufn_2
Xfill_42_4 VGND VGND VPWR VPWR sky130_fd_sc_hd__decap_12
Xfill_35_3 VGND VPWR sky130_fd_sc_hd__tapvpwrvgnd_1
Xfill_28_2 VGND VGND VPWR VPWR sky130_fd_sc_hd__decap_3
XDo0MUX.M\[3\].MUX\[1\] Do0MUX.A0\[25\] Do0MUX.A1\[25\] Do0MUX.SEL\[3\] VGND VGND
+ VPWR VPWR Do0[25] sky130_fd_sc_hd__mux2_1
XSLICE_16\[0\].RAM16.SLICE\[0\].RAM8.WORD\[4\].W.BYTE\[2\].B.BIT\[2\].OBUF0 SLICE_16\[0\].RAM16.SLICE\[0\].RAM8.WORD\[4\].W.BYTE\[2\].B.Q_WIRE\[2\]
+ SLICE_16\[0\].RAM16.SLICE\[0\].RAM8.WORD\[4\].W.BYTE\[2\].B.SEL0_B VGND VGND VPWR
+ VPWR SLICE_16\[0\].RAM16.BYTE\[2\].FLOATBUF0\[18\].Z sky130_fd_sc_hd__ebufn_2
XSLICE_16\[1\].RAM16.SLICE\[1\].RAM8.WORD\[6\].W.BYTE\[2\].B.BIT\[3\].genblk1.STORAGE
+ DIBUF\[19\].X SLICE_16\[1\].RAM16.SLICE\[1\].RAM8.WORD\[6\].W.BYTE\[2\].B.GCLK VGND
+ VGND VPWR VPWR SLICE_16\[1\].RAM16.SLICE\[1\].RAM8.WORD\[6\].W.BYTE\[2\].B.Q_WIRE\[3\]
+ sky130_fd_sc_hd__dlxtp_1
XSLICE_16\[1\].RAM16.SLICE\[1\].RAM8.WORD\[0\].W.BYTE\[3\].B.BIT\[4\].genblk1.STORAGE
+ DIBUF\[28\].X SLICE_16\[1\].RAM16.SLICE\[1\].RAM8.WORD\[0\].W.BYTE\[3\].B.GCLK VGND
+ VGND VPWR VPWR SLICE_16\[1\].RAM16.SLICE\[1\].RAM8.WORD\[0\].W.BYTE\[3\].B.Q_WIRE\[4\]
+ sky130_fd_sc_hd__dlxtp_1
XSLICE_16\[0\].RAM16.SLICE\[1\].RAM8.WORD\[5\].W.BYTE\[0\].B.genblk1.CG SLICE_16\[0\].RAM16.SLICE\[1\].RAM8.WORD\[5\].W.BYTE\[0\].B.CLK_B
+ SLICE_16\[0\].RAM16.SLICE\[1\].RAM8.WORD\[5\].W.BYTE\[0\].B.WE0_WIRE VGND VGND VPWR
+ VPWR SLICE_16\[0\].RAM16.SLICE\[1\].RAM8.WORD\[5\].W.BYTE\[0\].B.GCLK sky130_fd_sc_hd__dlclkp_1
Xtap_4_14 VGND VPWR sky130_fd_sc_hd__tapvpwrvgnd_1
Xtap_4_25 VGND VPWR sky130_fd_sc_hd__tapvpwrvgnd_1
Xfill_46_17 VGND VPWR sky130_fd_sc_hd__tapvpwrvgnd_1
XSLICE_16\[1\].RAM16.SLICE\[1\].RAM8.WORD\[4\].W.BYTE\[0\].B.BIT\[2\].genblk1.STORAGE
+ DIBUF\[2\].X SLICE_16\[1\].RAM16.SLICE\[1\].RAM8.WORD\[4\].W.BYTE\[0\].B.GCLK VGND
+ VGND VPWR VPWR SLICE_16\[1\].RAM16.SLICE\[1\].RAM8.WORD\[4\].W.BYTE\[0\].B.Q_WIRE\[2\]
+ sky130_fd_sc_hd__dlxtp_1
XSLICE_16\[0\].RAM16.BYTE\[2\].FLOATBUF0\[16\].__cell__ SLICE_16\[0\].RAM16.BYTE\[2\].FLOATBUF0\[16\].A
+ SLICE_16\[0\].RAM16.BYTE\[2\].FLOATBUF0\[16\].TE_B VGND VGND VPWR VPWR SLICE_16\[0\].RAM16.BYTE\[2\].FLOATBUF0\[16\].Z
+ sky130_fd_sc_hd__ebufn_2
Xfill_46_39 VGND VGND VPWR VPWR sky130_fd_sc_hd__decap_4
Xfill_46_28 VGND VPWR sky130_fd_sc_hd__tapvpwrvgnd_1
XSLICE_16\[1\].RAM16.SLICE\[1\].RAM8.WORD\[7\].W.BYTE\[3\].B.genblk1.CG SLICE_16\[1\].RAM16.SLICE\[1\].RAM8.WORD\[7\].W.BYTE\[3\].B.CLK_B
+ SLICE_16\[1\].RAM16.SLICE\[1\].RAM8.WORD\[7\].W.BYTE\[3\].B.WE0_WIRE VGND VGND VPWR
+ VPWR SLICE_16\[1\].RAM16.SLICE\[1\].RAM8.WORD\[7\].W.BYTE\[3\].B.GCLK sky130_fd_sc_hd__dlclkp_1
Xtap_23_32 VGND VPWR sky130_fd_sc_hd__tapvpwrvgnd_1
Xtap_23_21 VGND VPWR sky130_fd_sc_hd__tapvpwrvgnd_1
Xtap_23_10 VGND VPWR sky130_fd_sc_hd__tapvpwrvgnd_1
Xtap_0_6 VGND VPWR sky130_fd_sc_hd__tapvpwrvgnd_1
XSLICE_16\[0\].RAM16.SLICE\[1\].RAM8.WORD\[1\].W.BYTE\[3\].B.BIT\[0\].genblk1.STORAGE
+ DIBUF\[24\].X SLICE_16\[0\].RAM16.SLICE\[1\].RAM8.WORD\[1\].W.BYTE\[3\].B.GCLK VGND
+ VGND VPWR VPWR SLICE_16\[0\].RAM16.SLICE\[1\].RAM8.WORD\[1\].W.BYTE\[3\].B.Q_WIRE\[0\]
+ sky130_fd_sc_hd__dlxtp_1
XSLICE_16\[1\].RAM16.SLICE\[1\].RAM8.WORD\[7\].W.BYTE\[2\].B.BIT\[7\].OBUF0 SLICE_16\[1\].RAM16.SLICE\[1\].RAM8.WORD\[7\].W.BYTE\[2\].B.Q_WIRE\[7\]
+ SLICE_16\[1\].RAM16.SLICE\[1\].RAM8.WORD\[7\].W.BYTE\[2\].B.SEL0_B VGND VGND VPWR
+ VPWR SLICE_16\[1\].RAM16.BYTE\[2\].FLOATBUF0\[23\].Z sky130_fd_sc_hd__ebufn_2
XSLICE_16\[0\].RAM16.SLICE\[1\].RAM8.WORD\[5\].W.BYTE\[1\].B.SEL0INV SLICE_16\[0\].RAM16.SLICE\[1\].RAM8.WORD\[5\].W.BYTE\[0\].B.SEL0
+ VGND VGND VPWR VPWR SLICE_16\[0\].RAM16.SLICE\[1\].RAM8.WORD\[5\].W.BYTE\[1\].B.SEL0_B
+ sky130_fd_sc_hd__inv_1
XDo0MUX.M\[2\].MUX\[3\] Do0MUX.A0\[19\] Do0MUX.A1\[19\] Do0MUX.SEL\[2\] VGND VGND
+ VPWR VPWR Do0[19] sky130_fd_sc_hd__mux2_1
XDo0MUX.SEL0BUF\[3\] A0BUF\[4\].X VGND VGND VPWR VPWR Do0MUX.SEL\[3\] sky130_fd_sc_hd__clkbuf_2
Xfill_21_9 VGND VPWR sky130_fd_sc_hd__tapvpwrvgnd_1
XSLICE_16\[1\].RAM16.SLICE\[0\].RAM8.WORD\[2\].W.BYTE\[1\].B.BIT\[6\].OBUF0 SLICE_16\[1\].RAM16.SLICE\[0\].RAM8.WORD\[2\].W.BYTE\[1\].B.Q_WIRE\[6\]
+ SLICE_16\[1\].RAM16.SLICE\[0\].RAM8.WORD\[2\].W.BYTE\[1\].B.SEL0_B VGND VGND VPWR
+ VPWR SLICE_16\[1\].RAM16.BYTE\[1\].FLOATBUF0\[14\].Z sky130_fd_sc_hd__ebufn_2
Xfill_14_8 VGND VGND VPWR VPWR sky130_fd_sc_hd__decap_6
XSLICE_16\[0\].RAM16.SLICE\[0\].RAM8.WORD\[4\].W.BYTE\[2\].B.BIT\[5\].genblk1.STORAGE
+ DIBUF\[21\].X SLICE_16\[0\].RAM16.SLICE\[0\].RAM8.WORD\[4\].W.BYTE\[2\].B.GCLK VGND
+ VGND VPWR VPWR SLICE_16\[0\].RAM16.SLICE\[0\].RAM8.WORD\[4\].W.BYTE\[2\].B.Q_WIRE\[5\]
+ sky130_fd_sc_hd__dlxtp_1
XSLICE_16\[0\].RAM16.SLICE\[0\].RAM8.WORD\[7\].W.BYTE\[3\].B.BIT\[2\].OBUF0 SLICE_16\[0\].RAM16.SLICE\[0\].RAM8.WORD\[7\].W.BYTE\[3\].B.Q_WIRE\[2\]
+ SLICE_16\[0\].RAM16.SLICE\[0\].RAM8.WORD\[7\].W.BYTE\[3\].B.SEL0_B VGND VGND VPWR
+ VPWR SLICE_16\[0\].RAM16.BYTE\[3\].FLOATBUF0\[26\].Z sky130_fd_sc_hd__ebufn_2
XDo0MUX.M\[3\].DIODE_A0MUX\[30\] Do0MUX.A0\[30\] VGND VGND VPWR VPWR sky130_fd_sc_hd__diode_2
XSLICE_16\[0\].RAM16.SLICE\[0\].RAM8.WORD\[2\].W.BYTE\[0\].B.BIT\[4\].genblk1.STORAGE
+ DIBUF\[4\].X SLICE_16\[0\].RAM16.SLICE\[0\].RAM8.WORD\[2\].W.BYTE\[0\].B.GCLK VGND
+ VGND VPWR VPWR SLICE_16\[0\].RAM16.SLICE\[0\].RAM8.WORD\[2\].W.BYTE\[0\].B.Q_WIRE\[4\]
+ sky130_fd_sc_hd__dlxtp_1
XSLICE_16\[0\].RAM16.SLICE\[0\].RAM8.WORD\[1\].W.BYTE\[0\].B.SEL0INV SLICE_16\[0\].RAM16.SLICE\[0\].RAM8.WORD\[1\].W.BYTE\[0\].B.SEL0
+ VGND VGND VPWR VPWR SLICE_16\[0\].RAM16.SLICE\[0\].RAM8.WORD\[1\].W.BYTE\[0\].B.SEL0_B
+ sky130_fd_sc_hd__inv_1
Xfill_40_1 VGND VGND VPWR VPWR sky130_fd_sc_hd__decap_12
XSLICE_16\[0\].RAM16.SLICE\[0\].RAM8.WORD\[4\].W.BYTE\[0\].B.BIT\[7\].OBUF0 SLICE_16\[0\].RAM16.SLICE\[0\].RAM8.WORD\[4\].W.BYTE\[0\].B.Q_WIRE\[7\]
+ SLICE_16\[0\].RAM16.SLICE\[0\].RAM8.WORD\[4\].W.BYTE\[0\].B.SEL0_B VGND VGND VPWR
+ VPWR SLICE_16\[0\].RAM16.BYTE\[0\].FLOATBUF0\[7\].Z sky130_fd_sc_hd__ebufn_2
XDo0MUX.M\[1\].MUX\[5\] Do0MUX.A0\[13\] Do0MUX.A1\[13\] Do0MUX.SEL\[1\] VGND VGND
+ VPWR VPWR Do0[13] sky130_fd_sc_hd__mux2_1
XSLICE_16\[1\].RAM16.SLICE\[1\].RAM8.WORD\[6\].W.BYTE\[0\].B.BIT\[4\].OBUF0 SLICE_16\[1\].RAM16.SLICE\[1\].RAM8.WORD\[6\].W.BYTE\[0\].B.Q_WIRE\[4\]
+ SLICE_16\[1\].RAM16.SLICE\[1\].RAM8.WORD\[6\].W.BYTE\[0\].B.SEL0_B VGND VGND VPWR
+ VPWR SLICE_16\[1\].RAM16.BYTE\[0\].FLOATBUF0\[4\].Z sky130_fd_sc_hd__ebufn_2
Xfill_33_0 VGND VPWR sky130_fd_sc_hd__tapvpwrvgnd_1
XSLICE_16\[0\].RAM16.SLICE\[0\].RAM8.WORD\[0\].W.BYTE\[2\].B.CGAND SLICE_16\[0\].RAM16.SLICE\[0\].RAM8.WORD\[0\].W.BYTE\[0\].B.SEL0
+ SLICE_16\[0\].RAM16.SLICE\[0\].RAM8.WE0_buf\[2\] VGND VGND VPWR VPWR SLICE_16\[0\].RAM16.SLICE\[0\].RAM8.WORD\[0\].W.BYTE\[2\].B.WE0_WIRE
+ sky130_fd_sc_hd__and2_1
Xtap_18_10 VGND VPWR sky130_fd_sc_hd__tapvpwrvgnd_1
Xtap_34_31 VGND VPWR sky130_fd_sc_hd__tapvpwrvgnd_1
Xtap_34_20 VGND VPWR sky130_fd_sc_hd__tapvpwrvgnd_1
Xtap_18_21 VGND VPWR sky130_fd_sc_hd__tapvpwrvgnd_1
XSLICE_16\[1\].RAM16.SLICE\[1\].RAM8.WORD\[7\].W.BYTE\[1\].B.BIT\[2\].genblk1.STORAGE
+ DIBUF\[10\].X SLICE_16\[1\].RAM16.SLICE\[1\].RAM8.WORD\[7\].W.BYTE\[1\].B.GCLK VGND
+ VGND VPWR VPWR SLICE_16\[1\].RAM16.SLICE\[1\].RAM8.WORD\[7\].W.BYTE\[1\].B.Q_WIRE\[2\]
+ sky130_fd_sc_hd__dlxtp_1
XSLICE_16\[1\].RAM16.SLICE\[0\].RAM8.WORD\[5\].W.BYTE\[2\].B.BIT\[6\].OBUF0 SLICE_16\[1\].RAM16.SLICE\[0\].RAM8.WORD\[5\].W.BYTE\[2\].B.Q_WIRE\[6\]
+ SLICE_16\[1\].RAM16.SLICE\[0\].RAM8.WORD\[5\].W.BYTE\[2\].B.SEL0_B VGND VGND VPWR
+ VPWR SLICE_16\[1\].RAM16.BYTE\[2\].FLOATBUF0\[22\].Z sky130_fd_sc_hd__ebufn_2
XSLICE_16\[1\].RAM16.SLICE\[1\].RAM8.DEC0.AND7 SLICE_16\[1\].RAM16.SLICE\[1\].RAM8.DEC0.A_buf\[0\]
+ SLICE_16\[1\].RAM16.SLICE\[1\].RAM8.DEC0.A_buf\[1\] SLICE_16\[1\].RAM16.SLICE\[1\].RAM8.DEC0.A_buf\[2\]
+ SLICE_16\[1\].RAM16.SLICE\[1\].RAM8.DEC0.EN_buf VGND VGND VPWR VPWR SLICE_16\[1\].RAM16.SLICE\[1\].RAM8.DEC0.SEL\[7\]
+ sky130_fd_sc_hd__and4_2
XSLICE_16\[1\].RAM16.SLICE\[1\].RAM8.WORD\[1\].W.BYTE\[2\].B.BIT\[3\].genblk1.STORAGE
+ DIBUF\[19\].X SLICE_16\[1\].RAM16.SLICE\[1\].RAM8.WORD\[1\].W.BYTE\[2\].B.GCLK VGND
+ VGND VPWR VPWR SLICE_16\[1\].RAM16.SLICE\[1\].RAM8.WORD\[1\].W.BYTE\[2\].B.Q_WIRE\[3\]
+ sky130_fd_sc_hd__dlxtp_1
Xfill_22_96 VGND VPWR sky130_fd_sc_hd__tapvpwrvgnd_1
Xfill_22_85 VGND VGND VPWR VPWR sky130_fd_sc_hd__decap_12
Xfill_22_74 VGND VGND VPWR VPWR sky130_fd_sc_hd__decap_12
Xfill_22_63 VGND VPWR sky130_fd_sc_hd__tapvpwrvgnd_1
Xfill_22_52 VGND VGND VPWR VPWR sky130_fd_sc_hd__decap_12
Xfill_22_41 VGND VGND VPWR VPWR sky130_fd_sc_hd__decap_12
Xfill_22_30 VGND VPWR sky130_fd_sc_hd__tapvpwrvgnd_1
XDo0MUX.M\[0\].MUX\[7\] Do0MUX.A0\[7\] Do0MUX.A1\[7\] Do0MUX.SEL\[0\] VGND VGND VPWR
+ VPWR Do0[7] sky130_fd_sc_hd__mux2_1
XSLICE_16\[0\].RAM16.SLICE\[0\].RAM8.WORD\[7\].W.BYTE\[1\].B.BIT\[7\].OBUF0 SLICE_16\[0\].RAM16.SLICE\[0\].RAM8.WORD\[7\].W.BYTE\[1\].B.Q_WIRE\[7\]
+ SLICE_16\[0\].RAM16.SLICE\[0\].RAM8.WORD\[7\].W.BYTE\[1\].B.SEL0_B VGND VGND VPWR
+ VPWR SLICE_16\[0\].RAM16.BYTE\[1\].FLOATBUF0\[15\].Z sky130_fd_sc_hd__ebufn_2
Xfill_47_60 VGND VPWR sky130_fd_sc_hd__tapvpwrvgnd_1
Xfill_12_5 VGND VPWR sky130_fd_sc_hd__tapvpwrvgnd_1
XSLICE_16\[1\].RAM16.SLICE\[0\].RAM8.WORD\[4\].W.BYTE\[0\].B.BIT\[3\].OBUF0 SLICE_16\[1\].RAM16.SLICE\[0\].RAM8.WORD\[4\].W.BYTE\[0\].B.Q_WIRE\[3\]
+ SLICE_16\[1\].RAM16.SLICE\[0\].RAM8.WORD\[4\].W.BYTE\[0\].B.SEL0_B VGND VGND VPWR
+ VPWR SLICE_16\[1\].RAM16.BYTE\[0\].FLOATBUF0\[3\].Z sky130_fd_sc_hd__ebufn_2
XSLICE_16\[0\].RAM16.SLICE\[1\].RAM8.WORD\[1\].W.BYTE\[2\].B.BIT\[2\].OBUF0 SLICE_16\[0\].RAM16.SLICE\[1\].RAM8.WORD\[1\].W.BYTE\[2\].B.Q_WIRE\[2\]
+ SLICE_16\[0\].RAM16.SLICE\[1\].RAM8.WORD\[1\].W.BYTE\[2\].B.SEL0_B VGND VGND VPWR
+ VPWR SLICE_16\[0\].RAM16.BYTE\[2\].FLOATBUF0\[18\].Z sky130_fd_sc_hd__ebufn_2
XSLICE_16\[0\].RAM16.SLICE\[0\].RAM8.WORD\[1\].W.BYTE\[3\].B.genblk1.CG SLICE_16\[0\].RAM16.SLICE\[0\].RAM8.WORD\[1\].W.BYTE\[3\].B.CLK_B
+ SLICE_16\[0\].RAM16.SLICE\[0\].RAM8.WORD\[1\].W.BYTE\[3\].B.WE0_WIRE VGND VGND VPWR
+ VPWR SLICE_16\[0\].RAM16.SLICE\[0\].RAM8.WORD\[1\].W.BYTE\[3\].B.GCLK sky130_fd_sc_hd__dlclkp_1
Xtap_1_37 VGND VPWR sky130_fd_sc_hd__tapvpwrvgnd_1
Xtap_1_26 VGND VPWR sky130_fd_sc_hd__tapvpwrvgnd_1
Xtap_1_15 VGND VPWR sky130_fd_sc_hd__tapvpwrvgnd_1
XSLICE_16\[0\].RAM16.SLICE\[0\].RAM8.WORD\[7\].W.BYTE\[3\].B.BIT\[5\].genblk1.STORAGE
+ DIBUF\[29\].X SLICE_16\[0\].RAM16.SLICE\[0\].RAM8.WORD\[7\].W.BYTE\[3\].B.GCLK VGND
+ VGND VPWR VPWR SLICE_16\[0\].RAM16.SLICE\[0\].RAM8.WORD\[7\].W.BYTE\[3\].B.Q_WIRE\[5\]
+ sky130_fd_sc_hd__dlxtp_1
Xfill_43_29 VGND VGND VPWR VPWR sky130_fd_sc_hd__decap_12
Xfill_43_18 VGND VPWR sky130_fd_sc_hd__tapvpwrvgnd_1
XSLICE_16\[0\].RAM16.A0BUF\[3\].__cell__ A0BUF\[3\].X VGND VGND VPWR VPWR SLICE_16\[0\].RAM16.A0BUF\[3\].X
+ sky130_fd_sc_hd__clkbuf_2
XSLICE_16\[0\].RAM16.SLICE\[0\].RAM8.WORD\[5\].W.BYTE\[1\].B.BIT\[4\].genblk1.STORAGE
+ DIBUF\[12\].X SLICE_16\[0\].RAM16.SLICE\[0\].RAM8.WORD\[5\].W.BYTE\[1\].B.GCLK VGND
+ VGND VPWR VPWR SLICE_16\[0\].RAM16.SLICE\[0\].RAM8.WORD\[5\].W.BYTE\[1\].B.Q_WIRE\[4\]
+ sky130_fd_sc_hd__dlxtp_1
XSLICE_16\[0\].RAM16.SLICE\[1\].RAM8.WORD\[1\].W.BYTE\[1\].B.CGAND SLICE_16\[0\].RAM16.SLICE\[1\].RAM8.WORD\[1\].W.BYTE\[0\].B.SEL0
+ SLICE_16\[0\].RAM16.SLICE\[1\].RAM8.WE0_buf\[1\] VGND VGND VPWR VPWR SLICE_16\[0\].RAM16.SLICE\[1\].RAM8.WORD\[1\].W.BYTE\[1\].B.WE0_WIRE
+ sky130_fd_sc_hd__and2_1
Xtap_39_2 VGND VPWR sky130_fd_sc_hd__tapvpwrvgnd_1
Xtap_29_31 VGND VPWR sky130_fd_sc_hd__tapvpwrvgnd_1
Xtap_29_20 VGND VPWR sky130_fd_sc_hd__tapvpwrvgnd_1
XDo0MUX.M\[3\].DIODE_A1MUX\[28\] Do0MUX.A1\[28\] VGND VGND VPWR VPWR sky130_fd_sc_hd__diode_2
XSLICE_16\[1\].RAM16.SLICE\[1\].RAM8.WORD\[3\].W.BYTE\[1\].B.SEL0INV SLICE_16\[1\].RAM16.SLICE\[1\].RAM8.WORD\[3\].W.BYTE\[0\].B.SEL0
+ VGND VGND VPWR VPWR SLICE_16\[1\].RAM16.SLICE\[1\].RAM8.WORD\[3\].W.BYTE\[1\].B.SEL0_B
+ sky130_fd_sc_hd__inv_1
Xfill_17_63 VGND VGND VPWR VPWR sky130_fd_sc_hd__decap_8
Xfill_17_52 VGND VGND VPWR VPWR sky130_fd_sc_hd__decap_12
Xfill_17_41 VGND VGND VPWR VPWR sky130_fd_sc_hd__decap_12
Xfill_17_30 VGND VPWR sky130_fd_sc_hd__tapvpwrvgnd_1
XSLICE_16\[1\].RAM16.SLICE\[0\].RAM8.WORD\[7\].W.BYTE\[1\].B.BIT\[3\].OBUF0 SLICE_16\[1\].RAM16.SLICE\[0\].RAM8.WORD\[7\].W.BYTE\[1\].B.Q_WIRE\[3\]
+ SLICE_16\[1\].RAM16.SLICE\[0\].RAM8.WORD\[7\].W.BYTE\[1\].B.SEL0_B VGND VGND VPWR
+ VPWR SLICE_16\[1\].RAM16.BYTE\[1\].FLOATBUF0\[11\].Z sky130_fd_sc_hd__ebufn_2
XSLICE_16\[0\].RAM16.SLICE\[1\].RAM8.WORD\[4\].W.BYTE\[3\].B.BIT\[2\].OBUF0 SLICE_16\[0\].RAM16.SLICE\[1\].RAM8.WORD\[4\].W.BYTE\[3\].B.Q_WIRE\[2\]
+ SLICE_16\[0\].RAM16.SLICE\[1\].RAM8.WORD\[4\].W.BYTE\[3\].B.SEL0_B VGND VGND VPWR
+ VPWR SLICE_16\[0\].RAM16.BYTE\[3\].FLOATBUF0\[26\].Z sky130_fd_sc_hd__ebufn_2
XSLICE_16\[1\].RAM16.SLICE\[1\].RAM8.WORD\[4\].W.BYTE\[3\].B.BIT\[3\].genblk1.STORAGE
+ DIBUF\[27\].X SLICE_16\[1\].RAM16.SLICE\[1\].RAM8.WORD\[4\].W.BYTE\[3\].B.GCLK VGND
+ VGND VPWR VPWR SLICE_16\[1\].RAM16.SLICE\[1\].RAM8.WORD\[4\].W.BYTE\[3\].B.Q_WIRE\[3\]
+ sky130_fd_sc_hd__dlxtp_1
XSLICE_16\[1\].RAM16.SLICE\[0\].RAM8.WORD\[2\].W.BYTE\[3\].B.genblk1.CLKINV SLICE_16\[1\].RAM16.SLICE\[0\].RAM8.WORD\[2\].W.BYTE\[0\].B.CLK
+ VGND VGND VPWR VPWR SLICE_16\[1\].RAM16.SLICE\[0\].RAM8.WORD\[2\].W.BYTE\[3\].B.CLK_B
+ sky130_fd_sc_hd__inv_1
XSLICE_16\[1\].RAM16.SLICE\[1\].RAM8.WORD\[2\].W.BYTE\[1\].B.BIT\[2\].genblk1.STORAGE
+ DIBUF\[10\].X SLICE_16\[1\].RAM16.SLICE\[1\].RAM8.WORD\[2\].W.BYTE\[1\].B.GCLK VGND
+ VGND VPWR VPWR SLICE_16\[1\].RAM16.SLICE\[1\].RAM8.WORD\[2\].W.BYTE\[1\].B.Q_WIRE\[2\]
+ sky130_fd_sc_hd__dlxtp_1
Xfill_8_4 VGND VGND VPWR VPWR sky130_fd_sc_hd__decap_6
XSLICE_16\[0\].RAM16.SLICE\[1\].RAM8.WORD\[1\].W.BYTE\[0\].B.BIT\[7\].OBUF0 SLICE_16\[0\].RAM16.SLICE\[1\].RAM8.WORD\[1\].W.BYTE\[0\].B.Q_WIRE\[7\]
+ SLICE_16\[0\].RAM16.SLICE\[1\].RAM8.WORD\[1\].W.BYTE\[0\].B.SEL0_B VGND VGND VPWR
+ VPWR SLICE_16\[0\].RAM16.BYTE\[0\].FLOATBUF0\[7\].Z sky130_fd_sc_hd__ebufn_2
Xfill_10_2 VGND VPWR sky130_fd_sc_hd__tapvpwrvgnd_1
Xtap_32_9 VGND VPWR sky130_fd_sc_hd__tapvpwrvgnd_1
Xtap_25_8 VGND VPWR sky130_fd_sc_hd__tapvpwrvgnd_1
Xtap_18_7 VGND VPWR sky130_fd_sc_hd__tapvpwrvgnd_1
XSLICE_16\[1\].RAM16.SLICE\[0\].RAM8.WORD\[0\].W.CLKBUF SLICE_16\[1\].RAM16.SLICE\[0\].RAM8.CLKBUF.X
+ VGND VGND VPWR VPWR SLICE_16\[1\].RAM16.SLICE\[0\].RAM8.WORD\[0\].W.BYTE\[0\].B.CLK
+ sky130_fd_sc_hd__clkbuf_4
Xtap_15_33 VGND VPWR sky130_fd_sc_hd__tapvpwrvgnd_1
Xtap_15_22 VGND VPWR sky130_fd_sc_hd__tapvpwrvgnd_1
Xtap_15_11 VGND VPWR sky130_fd_sc_hd__tapvpwrvgnd_1
XDIBUF\[29\].__cell__ Di0[29] VGND VGND VPWR VPWR DIBUF\[29\].X sky130_fd_sc_hd__clkbuf_16
XSLICE_16\[0\].RAM16.SLICE\[1\].RAM8.WORD\[1\].W.BYTE\[2\].B.SEL0INV SLICE_16\[0\].RAM16.SLICE\[1\].RAM8.WORD\[1\].W.BYTE\[0\].B.SEL0
+ VGND VGND VPWR VPWR SLICE_16\[0\].RAM16.SLICE\[1\].RAM8.WORD\[1\].W.BYTE\[2\].B.SEL0_B
+ sky130_fd_sc_hd__inv_1
Xtap_31_32 VGND VPWR sky130_fd_sc_hd__tapvpwrvgnd_1
Xtap_31_21 VGND VPWR sky130_fd_sc_hd__tapvpwrvgnd_1
Xtap_31_10 VGND VPWR sky130_fd_sc_hd__tapvpwrvgnd_1
XSLICE_16\[1\].RAM16.SLICE\[0\].RAM8.WORD\[5\].W.BYTE\[0\].B.BIT\[7\].genblk1.STORAGE
+ DIBUF\[7\].X SLICE_16\[1\].RAM16.SLICE\[0\].RAM8.WORD\[5\].W.BYTE\[0\].B.GCLK VGND
+ VGND VPWR VPWR SLICE_16\[1\].RAM16.SLICE\[0\].RAM8.WORD\[5\].W.BYTE\[0\].B.Q_WIRE\[7\]
+ sky130_fd_sc_hd__dlxtp_1
XSLICE_16\[1\].RAM16.SLICE\[1\].RAM8.WORD\[2\].W.BYTE\[2\].B.BIT\[6\].OBUF0 SLICE_16\[1\].RAM16.SLICE\[1\].RAM8.WORD\[2\].W.BYTE\[2\].B.Q_WIRE\[6\]
+ SLICE_16\[1\].RAM16.SLICE\[1\].RAM8.WORD\[2\].W.BYTE\[2\].B.SEL0_B VGND VGND VPWR
+ VPWR SLICE_16\[1\].RAM16.BYTE\[2\].FLOATBUF0\[22\].Z sky130_fd_sc_hd__ebufn_2
XSLICE_16\[0\].RAM16.SLICE\[1\].RAM8.WORD\[6\].W.BYTE\[3\].B.genblk1.CG SLICE_16\[0\].RAM16.SLICE\[1\].RAM8.WORD\[6\].W.BYTE\[3\].B.CLK_B
+ SLICE_16\[0\].RAM16.SLICE\[1\].RAM8.WORD\[6\].W.BYTE\[3\].B.WE0_WIRE VGND VGND VPWR
+ VPWR SLICE_16\[0\].RAM16.SLICE\[1\].RAM8.WORD\[6\].W.BYTE\[3\].B.GCLK sky130_fd_sc_hd__dlclkp_1
XSLICE_16\[0\].RAM16.SLICE\[0\].RAM8.WORD\[2\].W.BYTE\[3\].B.BIT\[5\].genblk1.STORAGE
+ DIBUF\[29\].X SLICE_16\[0\].RAM16.SLICE\[0\].RAM8.WORD\[2\].W.BYTE\[3\].B.GCLK VGND
+ VGND VPWR VPWR SLICE_16\[0\].RAM16.SLICE\[0\].RAM8.WORD\[2\].W.BYTE\[3\].B.Q_WIRE\[5\]
+ sky130_fd_sc_hd__dlxtp_1
Xfill_44_72 VGND VPWR sky130_fd_sc_hd__tapvpwrvgnd_1
Xfill_44_61 VGND VGND VPWR VPWR sky130_fd_sc_hd__decap_12
Xfill_44_50 VGND VGND VPWR VPWR sky130_fd_sc_hd__decap_12
XSLICE_16\[1\].RAM16.SLICE\[0\].RAM8.WORD\[3\].W.BYTE\[2\].B.DIODE_CLK SLICE_16\[1\].RAM16.SLICE\[0\].RAM8.WORD\[3\].W.BYTE\[0\].B.CLK
+ VGND VGND VPWR VPWR sky130_fd_sc_hd__diode_2
XSLICE_16\[0\].RAM16.SLICE\[1\].RAM8.WORD\[4\].W.BYTE\[1\].B.BIT\[7\].OBUF0 SLICE_16\[0\].RAM16.SLICE\[1\].RAM8.WORD\[4\].W.BYTE\[1\].B.Q_WIRE\[7\]
+ SLICE_16\[0\].RAM16.SLICE\[1\].RAM8.WORD\[4\].W.BYTE\[1\].B.SEL0_B VGND VGND VPWR
+ VPWR SLICE_16\[0\].RAM16.BYTE\[1\].FLOATBUF0\[15\].Z sky130_fd_sc_hd__ebufn_2
XSLICE_16\[0\].RAM16.SLICE\[0\].RAM8.WORD\[0\].W.BYTE\[1\].B.BIT\[4\].genblk1.STORAGE
+ DIBUF\[12\].X SLICE_16\[0\].RAM16.SLICE\[0\].RAM8.WORD\[0\].W.BYTE\[1\].B.GCLK VGND
+ VGND VPWR VPWR SLICE_16\[0\].RAM16.SLICE\[0\].RAM8.WORD\[0\].W.BYTE\[1\].B.Q_WIRE\[4\]
+ sky130_fd_sc_hd__dlxtp_1
XSLICE_16\[0\].RAM16.SLICE\[0\].RAM8.WORD\[2\].W.BYTE\[3\].B.BIT\[1\].OBUF0 SLICE_16\[0\].RAM16.SLICE\[0\].RAM8.WORD\[2\].W.BYTE\[3\].B.Q_WIRE\[1\]
+ SLICE_16\[0\].RAM16.SLICE\[0\].RAM8.WORD\[2\].W.BYTE\[3\].B.SEL0_B VGND VGND VPWR
+ VPWR SLICE_16\[0\].RAM16.BYTE\[3\].FLOATBUF0\[25\].Z sky130_fd_sc_hd__ebufn_2
XSLICE_16\[0\].RAM16.SLICE\[0\].RAM8.WORD\[6\].W.BYTE\[0\].B.BIT\[3\].genblk1.STORAGE
+ DIBUF\[3\].X SLICE_16\[0\].RAM16.SLICE\[0\].RAM8.WORD\[6\].W.BYTE\[0\].B.GCLK VGND
+ VGND VPWR VPWR SLICE_16\[0\].RAM16.SLICE\[0\].RAM8.WORD\[6\].W.BYTE\[0\].B.Q_WIRE\[3\]
+ sky130_fd_sc_hd__dlxtp_1
Xfill_44_94 VGND VGND VPWR VPWR sky130_fd_sc_hd__decap_12
Xfill_44_83 VGND VGND VPWR VPWR sky130_fd_sc_hd__decap_12
Xfill_41_101 VGND VGND VPWR VPWR sky130_fd_sc_hd__decap_8
XSLICE_16\[0\].RAM16.SLICE\[0\].RAM8.WORD\[6\].W.BYTE\[1\].B.DIODE_CLK SLICE_16\[0\].RAM16.SLICE\[0\].RAM8.WORD\[6\].W.BYTE\[0\].B.CLK
+ VGND VGND VPWR VPWR sky130_fd_sc_hd__diode_2
XSLICE_16\[0\].RAM16.SLICE\[1\].RAM8.WORD\[0\].W.BYTE\[2\].B.DIODE_CLK SLICE_16\[0\].RAM16.SLICE\[1\].RAM8.WORD\[0\].W.BYTE\[0\].B.CLK
+ VGND VGND VPWR VPWR sky130_fd_sc_hd__diode_2
XSLICE_16\[1\].RAM16.Do0_REG.OUTREG_BYTE\[1\].DIODE\[5\] SLICE_16\[1\].RAM16.BYTE\[1\].FLOATBUF0\[13\].Z
+ VGND VGND VPWR VPWR sky130_fd_sc_hd__diode_2
XSLICE_16\[1\].RAM16.SLICE\[1\].RAM8.WORD\[3\].W.BYTE\[2\].B.genblk1.CG SLICE_16\[1\].RAM16.SLICE\[1\].RAM8.WORD\[3\].W.BYTE\[2\].B.CLK_B
+ SLICE_16\[1\].RAM16.SLICE\[1\].RAM8.WORD\[3\].W.BYTE\[2\].B.WE0_WIRE VGND VGND VPWR
+ VPWR SLICE_16\[1\].RAM16.SLICE\[1\].RAM8.WORD\[3\].W.BYTE\[2\].B.GCLK sky130_fd_sc_hd__dlclkp_1
XSLICE_16\[1\].RAM16.SLICE\[1\].RAM8.WORD\[1\].W.BYTE\[0\].B.BIT\[3\].OBUF0 SLICE_16\[1\].RAM16.SLICE\[1\].RAM8.WORD\[1\].W.BYTE\[0\].B.Q_WIRE\[3\]
+ SLICE_16\[1\].RAM16.SLICE\[1\].RAM8.WORD\[1\].W.BYTE\[0\].B.SEL0_B VGND VGND VPWR
+ VPWR SLICE_16\[1\].RAM16.BYTE\[0\].FLOATBUF0\[3\].Z sky130_fd_sc_hd__ebufn_2
Xtap_7_14 VGND VPWR sky130_fd_sc_hd__tapvpwrvgnd_1
Xtap_7_25 VGND VPWR sky130_fd_sc_hd__tapvpwrvgnd_1
Xtap_7_36 VGND VPWR sky130_fd_sc_hd__tapvpwrvgnd_1
Xfill_6_1 VGND VPWR sky130_fd_sc_hd__tapvpwrvgnd_1
Xfill_40_19 VGND VGND VPWR VPWR sky130_fd_sc_hd__decap_12
XSLICE_16\[1\].RAM16.SLICE\[1\].RAM8.WORD\[5\].W.BYTE\[3\].B.BIT\[6\].OBUF0 SLICE_16\[1\].RAM16.SLICE\[1\].RAM8.WORD\[5\].W.BYTE\[3\].B.Q_WIRE\[6\]
+ SLICE_16\[1\].RAM16.SLICE\[1\].RAM8.WORD\[5\].W.BYTE\[3\].B.SEL0_B VGND VGND VPWR
+ VPWR SLICE_16\[1\].RAM16.BYTE\[3\].FLOATBUF0\[30\].Z sky130_fd_sc_hd__ebufn_2
Xtap_30_6 VGND VPWR sky130_fd_sc_hd__tapvpwrvgnd_1
XSLICE_16\[1\].RAM16.SLICE\[1\].RAM8.WORD\[5\].W.BYTE\[2\].B.BIT\[2\].genblk1.STORAGE
+ DIBUF\[18\].X SLICE_16\[1\].RAM16.SLICE\[1\].RAM8.WORD\[5\].W.BYTE\[2\].B.GCLK VGND
+ VGND VPWR VPWR SLICE_16\[1\].RAM16.SLICE\[1\].RAM8.WORD\[5\].W.BYTE\[2\].B.Q_WIRE\[2\]
+ sky130_fd_sc_hd__dlxtp_1
Xtap_26_32 VGND VPWR sky130_fd_sc_hd__tapvpwrvgnd_1
Xtap_26_21 VGND VPWR sky130_fd_sc_hd__tapvpwrvgnd_1
Xtap_26_10 VGND VPWR sky130_fd_sc_hd__tapvpwrvgnd_1
Xtap_23_5 VGND VPWR sky130_fd_sc_hd__tapvpwrvgnd_1
Xtap_16_4 VGND VPWR sky130_fd_sc_hd__tapvpwrvgnd_1
XSLICE_16\[1\].RAM16.SLICE\[1\].RAM8.WORD\[3\].W.BYTE\[0\].B.BIT\[1\].genblk1.STORAGE
+ DIBUF\[1\].X SLICE_16\[1\].RAM16.SLICE\[1\].RAM8.WORD\[3\].W.BYTE\[0\].B.GCLK VGND
+ VGND VPWR VPWR SLICE_16\[1\].RAM16.SLICE\[1\].RAM8.WORD\[3\].W.BYTE\[0\].B.Q_WIRE\[1\]
+ sky130_fd_sc_hd__dlxtp_1
XSLICE_16\[1\].RAM16.SLICE\[0\].RAM8.WORD\[0\].W.BYTE\[2\].B.BIT\[5\].OBUF0 SLICE_16\[1\].RAM16.SLICE\[0\].RAM8.WORD\[0\].W.BYTE\[2\].B.Q_WIRE\[5\]
+ SLICE_16\[1\].RAM16.SLICE\[0\].RAM8.WORD\[0\].W.BYTE\[2\].B.SEL0_B VGND VGND VPWR
+ VPWR SLICE_16\[1\].RAM16.BYTE\[2\].FLOATBUF0\[21\].Z sky130_fd_sc_hd__ebufn_2
XSLICE_16\[0\].RAM16.SLICE\[1\].RAM8.WORD\[7\].W.BYTE\[2\].B.BIT\[7\].OBUF0 SLICE_16\[0\].RAM16.SLICE\[1\].RAM8.WORD\[7\].W.BYTE\[2\].B.Q_WIRE\[7\]
+ SLICE_16\[0\].RAM16.SLICE\[1\].RAM8.WORD\[7\].W.BYTE\[2\].B.SEL0_B VGND VGND VPWR
+ VPWR SLICE_16\[0\].RAM16.BYTE\[2\].FLOATBUF0\[23\].Z sky130_fd_sc_hd__ebufn_2
XSLICE_16\[0\].RAM16.DIODE_A0\[4\].__cell__ zero_ VGND VGND VPWR VPWR sky130_fd_sc_hd__diode_2
Xtap_9_3 VGND VPWR sky130_fd_sc_hd__tapvpwrvgnd_1
XSLICE_16\[0\].RAM16.Do0_REG.OUTREG_BYTE\[3\].DIODE\[2\] SLICE_16\[0\].RAM16.BYTE\[3\].FLOATBUF0\[26\].Z
+ VGND VGND VPWR VPWR sky130_fd_sc_hd__diode_2
XSLICE_16\[0\].RAM16.SLICE\[0\].RAM8.WORD\[2\].W.BYTE\[1\].B.BIT\[6\].OBUF0 SLICE_16\[0\].RAM16.SLICE\[0\].RAM8.WORD\[2\].W.BYTE\[1\].B.Q_WIRE\[6\]
+ SLICE_16\[0\].RAM16.SLICE\[0\].RAM8.WORD\[2\].W.BYTE\[1\].B.SEL0_B VGND VGND VPWR
+ VPWR SLICE_16\[0\].RAM16.BYTE\[1\].FLOATBUF0\[14\].Z sky130_fd_sc_hd__ebufn_2
Xfill_44_8 VGND VGND VPWR VPWR sky130_fd_sc_hd__decap_12
Xfill_39_61 VGND VGND VPWR VPWR sky130_fd_sc_hd__decap_12
Xfill_39_50 VGND VGND VPWR VPWR sky130_fd_sc_hd__decap_12
Xfill_37_7 VGND VGND VPWR VPWR sky130_fd_sc_hd__decap_6
XSLICE_16\[1\].RAM16.SLICE\[1\].RAM8.WORD\[4\].W.BYTE\[1\].B.BIT\[3\].OBUF0 SLICE_16\[1\].RAM16.SLICE\[1\].RAM8.WORD\[4\].W.BYTE\[1\].B.Q_WIRE\[3\]
+ SLICE_16\[1\].RAM16.SLICE\[1\].RAM8.WORD\[4\].W.BYTE\[1\].B.SEL0_B VGND VGND VPWR
+ VPWR SLICE_16\[1\].RAM16.BYTE\[1\].FLOATBUF0\[11\].Z sky130_fd_sc_hd__ebufn_2
XSLICE_16\[1\].RAM16.SLICE\[0\].RAM8.WORD\[0\].W.BYTE\[0\].B.BIT\[7\].genblk1.STORAGE
+ DIBUF\[7\].X SLICE_16\[1\].RAM16.SLICE\[0\].RAM8.WORD\[0\].W.BYTE\[0\].B.GCLK VGND
+ VGND VPWR VPWR SLICE_16\[1\].RAM16.SLICE\[0\].RAM8.WORD\[0\].W.BYTE\[0\].B.Q_WIRE\[7\]
+ sky130_fd_sc_hd__dlxtp_1
XDIBUF\[2\].__cell__ Di0[2] VGND VGND VPWR VPWR DIBUF\[2\].X sky130_fd_sc_hd__clkbuf_16
XSLICE_16\[0\].RAM16.SLICE\[1\].RAM8.WORD\[6\].W.BYTE\[0\].B.BIT\[4\].OBUF0 SLICE_16\[0\].RAM16.SLICE\[1\].RAM8.WORD\[6\].W.BYTE\[0\].B.Q_WIRE\[4\]
+ SLICE_16\[0\].RAM16.SLICE\[1\].RAM8.WORD\[6\].W.BYTE\[0\].B.SEL0_B VGND VGND VPWR
+ VPWR SLICE_16\[0\].RAM16.BYTE\[0\].FLOATBUF0\[4\].Z sky130_fd_sc_hd__ebufn_2
XSLICE_16\[0\].RAM16.SLICE\[0\].RAM8.WORD\[1\].W.BYTE\[0\].B.BIT\[3\].genblk1.STORAGE
+ DIBUF\[3\].X SLICE_16\[0\].RAM16.SLICE\[0\].RAM8.WORD\[1\].W.BYTE\[0\].B.GCLK VGND
+ VGND VPWR VPWR SLICE_16\[0\].RAM16.SLICE\[0\].RAM8.WORD\[1\].W.BYTE\[0\].B.Q_WIRE\[3\]
+ sky130_fd_sc_hd__dlxtp_1
XSLICE_16\[0\].RAM16.SLICE\[0\].RAM8.WORD\[3\].W.BYTE\[2\].B.BIT\[4\].genblk1.STORAGE
+ DIBUF\[20\].X SLICE_16\[0\].RAM16.SLICE\[0\].RAM8.WORD\[3\].W.BYTE\[2\].B.GCLK VGND
+ VGND VPWR VPWR SLICE_16\[0\].RAM16.SLICE\[0\].RAM8.WORD\[3\].W.BYTE\[2\].B.Q_WIRE\[4\]
+ sky130_fd_sc_hd__dlxtp_1
XSLICE_16\[1\].RAM16.BYTE\[3\].FLOATBUF0\[26\].__cell__ SLICE_16\[1\].RAM16.BYTE\[3\].FLOATBUF0\[24\].A
+ SLICE_16\[1\].RAM16.BYTE\[3\].FLOATBUF0\[24\].TE_B VGND VGND VPWR VPWR SLICE_16\[1\].RAM16.BYTE\[3\].FLOATBUF0\[26\].Z
+ sky130_fd_sc_hd__ebufn_2
XSLICE_16\[1\].RAM16.Do0_REG.OUTREG_BYTE\[0\].Do_FF\[6\] SLICE_16\[1\].RAM16.Do0_REG.CLKBUF\[0\]
+ SLICE_16\[1\].RAM16.BYTE\[0\].FLOATBUF0\[6\].Z VGND VGND VPWR VPWR Do0MUX.A1\[6\]
+ sky130_fd_sc_hd__dfxtp_1
XSLICE_16\[1\].RAM16.SLICE\[0\].RAM8.WORD\[3\].W.BYTE\[3\].B.BIT\[5\].OBUF0 SLICE_16\[1\].RAM16.SLICE\[0\].RAM8.WORD\[3\].W.BYTE\[3\].B.Q_WIRE\[5\]
+ SLICE_16\[1\].RAM16.SLICE\[0\].RAM8.WORD\[3\].W.BYTE\[3\].B.SEL0_B VGND VGND VPWR
+ VPWR SLICE_16\[1\].RAM16.BYTE\[3\].FLOATBUF0\[29\].Z sky130_fd_sc_hd__ebufn_2
XSLICE_16\[0\].RAM16.SLICE\[1\].RAM8.WORD\[5\].W.BYTE\[0\].B.SEL0INV SLICE_16\[0\].RAM16.SLICE\[1\].RAM8.WORD\[5\].W.BYTE\[0\].B.SEL0
+ VGND VGND VPWR VPWR SLICE_16\[0\].RAM16.SLICE\[1\].RAM8.WORD\[5\].W.BYTE\[0\].B.SEL0_B
+ sky130_fd_sc_hd__inv_1
Xtap_12_34 VGND VPWR sky130_fd_sc_hd__tapvpwrvgnd_1
Xtap_12_23 VGND VPWR sky130_fd_sc_hd__tapvpwrvgnd_1
Xtap_12_12 VGND VPWR sky130_fd_sc_hd__tapvpwrvgnd_1
XSLICE_16\[0\].RAM16.SLICE\[0\].RAM8.WORD\[5\].W.BYTE\[2\].B.BIT\[6\].OBUF0 SLICE_16\[0\].RAM16.SLICE\[0\].RAM8.WORD\[5\].W.BYTE\[2\].B.Q_WIRE\[6\]
+ SLICE_16\[0\].RAM16.SLICE\[0\].RAM8.WORD\[5\].W.BYTE\[2\].B.SEL0_B VGND VGND VPWR
+ VPWR SLICE_16\[0\].RAM16.BYTE\[2\].FLOATBUF0\[22\].Z sky130_fd_sc_hd__ebufn_2
XSLICE_16\[1\].RAM16.SLICE\[1\].RAM8.WORD\[7\].W.BYTE\[2\].B.BIT\[3\].OBUF0 SLICE_16\[1\].RAM16.SLICE\[1\].RAM8.WORD\[7\].W.BYTE\[2\].B.Q_WIRE\[3\]
+ SLICE_16\[1\].RAM16.SLICE\[1\].RAM8.WORD\[7\].W.BYTE\[2\].B.SEL0_B VGND VGND VPWR
+ VPWR SLICE_16\[1\].RAM16.BYTE\[2\].FLOATBUF0\[19\].Z sky130_fd_sc_hd__ebufn_2
Xtap_37_31 VGND VPWR sky130_fd_sc_hd__tapvpwrvgnd_1
Xtap_37_20 VGND VPWR sky130_fd_sc_hd__tapvpwrvgnd_1
XSLICE_16\[1\].RAM16.SLICE\[1\].RAM8.WORD\[5\].W.BYTE\[2\].B.DIODE_CLK SLICE_16\[1\].RAM16.SLICE\[1\].RAM8.WORD\[5\].W.BYTE\[0\].B.CLK
+ VGND VGND VPWR VPWR sky130_fd_sc_hd__diode_2
Xtap_14_1 VGND VPWR sky130_fd_sc_hd__tapvpwrvgnd_1
Xtap_7_0 VGND VPWR sky130_fd_sc_hd__tapvpwrvgnd_1
XSLICE_16\[0\].RAM16.Do0_REG.OUTREG_BYTE\[2\].Do_FF\[3\] SLICE_16\[0\].RAM16.Do0_REG.CLKBUF\[2\]
+ SLICE_16\[0\].RAM16.BYTE\[2\].FLOATBUF0\[19\].Z VGND VGND VPWR VPWR Do0MUX.A0\[19\]
+ sky130_fd_sc_hd__dfxtp_1
Xfill_41_95 VGND VGND VPWR VPWR sky130_fd_sc_hd__decap_12
Xfill_41_84 VGND VPWR sky130_fd_sc_hd__tapvpwrvgnd_1
Xfill_41_73 VGND VGND VPWR VPWR sky130_fd_sc_hd__decap_12
Xfill_41_62 VGND VGND VPWR VPWR sky130_fd_sc_hd__decap_12
Xfill_41_51 VGND VPWR sky130_fd_sc_hd__tapvpwrvgnd_1
Xfill_41_40 VGND VGND VPWR VPWR sky130_fd_sc_hd__decap_12
XSLICE_16\[1\].RAM16.SLICE\[0\].RAM8.WORD\[7\].W.BYTE\[1\].B.CGAND SLICE_16\[1\].RAM16.SLICE\[0\].RAM8.WORD\[7\].W.BYTE\[0\].B.SEL0
+ SLICE_16\[1\].RAM16.SLICE\[0\].RAM8.WE0_buf\[1\] VGND VGND VPWR VPWR SLICE_16\[1\].RAM16.SLICE\[0\].RAM8.WORD\[7\].W.BYTE\[1\].B.WE0_WIRE
+ sky130_fd_sc_hd__and2_1
XSLICE_16\[1\].RAM16.SLICE\[1\].RAM8.WORD\[6\].W.BYTE\[1\].B.BIT\[1\].genblk1.STORAGE
+ DIBUF\[9\].X SLICE_16\[1\].RAM16.SLICE\[1\].RAM8.WORD\[6\].W.BYTE\[1\].B.GCLK VGND
+ VGND VPWR VPWR SLICE_16\[1\].RAM16.SLICE\[1\].RAM8.WORD\[6\].W.BYTE\[1\].B.Q_WIRE\[1\]
+ sky130_fd_sc_hd__dlxtp_1
XSLICE_16\[1\].RAM16.SLICE\[1\].RAM8.WORD\[0\].W.BYTE\[2\].B.BIT\[2\].genblk1.STORAGE
+ DIBUF\[18\].X SLICE_16\[1\].RAM16.SLICE\[1\].RAM8.WORD\[0\].W.BYTE\[2\].B.GCLK VGND
+ VGND VPWR VPWR SLICE_16\[1\].RAM16.SLICE\[1\].RAM8.WORD\[0\].W.BYTE\[2\].B.Q_WIRE\[2\]
+ sky130_fd_sc_hd__dlxtp_1
XSLICE_16\[1\].RAM16.SLICE\[0\].RAM8.WORD\[2\].W.BYTE\[1\].B.BIT\[2\].OBUF0 SLICE_16\[1\].RAM16.SLICE\[0\].RAM8.WORD\[2\].W.BYTE\[1\].B.Q_WIRE\[2\]
+ SLICE_16\[1\].RAM16.SLICE\[0\].RAM8.WORD\[2\].W.BYTE\[1\].B.SEL0_B VGND VGND VPWR
+ VPWR SLICE_16\[1\].RAM16.BYTE\[1\].FLOATBUF0\[10\].Z sky130_fd_sc_hd__ebufn_2
Xfill_42_5 VGND VGND VPWR VPWR sky130_fd_sc_hd__decap_12
Xfill_35_4 VGND VGND VPWR VPWR sky130_fd_sc_hd__fill_2
Xfill_28_3 VGND VPWR sky130_fd_sc_hd__tapvpwrvgnd_1
XSLICE_16\[0\].RAM16.SLICE\[0\].RAM8.WORD\[4\].W.BYTE\[0\].B.BIT\[3\].OBUF0 SLICE_16\[0\].RAM16.SLICE\[0\].RAM8.WORD\[4\].W.BYTE\[0\].B.Q_WIRE\[3\]
+ SLICE_16\[0\].RAM16.SLICE\[0\].RAM8.WORD\[4\].W.BYTE\[0\].B.SEL0_B VGND VGND VPWR
+ VPWR SLICE_16\[0\].RAM16.BYTE\[0\].FLOATBUF0\[3\].Z sky130_fd_sc_hd__ebufn_2
XSLICE_16\[1\].RAM16.SLICE\[1\].RAM8.WORD\[6\].W.BYTE\[0\].B.BIT\[0\].OBUF0 SLICE_16\[1\].RAM16.SLICE\[1\].RAM8.WORD\[6\].W.BYTE\[0\].B.Q_WIRE\[0\]
+ SLICE_16\[1\].RAM16.SLICE\[1\].RAM8.WORD\[6\].W.BYTE\[0\].B.SEL0_B VGND VGND VPWR
+ VPWR SLICE_16\[1\].RAM16.BYTE\[0\].FLOATBUF0\[0\].Z sky130_fd_sc_hd__ebufn_2
Xtap_4_15 VGND VPWR sky130_fd_sc_hd__tapvpwrvgnd_1
Xtap_4_26 VGND VPWR sky130_fd_sc_hd__tapvpwrvgnd_1
Xfill_46_29 VGND VPWR sky130_fd_sc_hd__tapvpwrvgnd_1
Xfill_46_18 VGND VGND VPWR VPWR sky130_fd_sc_hd__decap_4
XSLICE_16\[1\].RAM16.SLICE\[0\].RAM8.WORD\[3\].W.BYTE\[1\].B.BIT\[7\].genblk1.STORAGE
+ DIBUF\[15\].X SLICE_16\[1\].RAM16.SLICE\[0\].RAM8.WORD\[3\].W.BYTE\[1\].B.GCLK VGND
+ VGND VPWR VPWR SLICE_16\[1\].RAM16.SLICE\[0\].RAM8.WORD\[3\].W.BYTE\[1\].B.Q_WIRE\[7\]
+ sky130_fd_sc_hd__dlxtp_1
Xtap_0_7 VGND VPWR sky130_fd_sc_hd__tapvpwrvgnd_1
Xtap_23_33 VGND VPWR sky130_fd_sc_hd__tapvpwrvgnd_1
Xtap_23_22 VGND VPWR sky130_fd_sc_hd__tapvpwrvgnd_1
Xtap_23_11 VGND VPWR sky130_fd_sc_hd__tapvpwrvgnd_1
XSLICE_16\[0\].RAM16.SLICE\[0\].RAM8.WORD\[6\].W.BYTE\[3\].B.BIT\[4\].genblk1.STORAGE
+ DIBUF\[28\].X SLICE_16\[0\].RAM16.SLICE\[0\].RAM8.WORD\[6\].W.BYTE\[3\].B.GCLK VGND
+ VGND VPWR VPWR SLICE_16\[0\].RAM16.SLICE\[0\].RAM8.WORD\[6\].W.BYTE\[3\].B.Q_WIRE\[4\]
+ sky130_fd_sc_hd__dlxtp_1
XSLICE_16\[1\].RAM16.SLICE\[0\].RAM8.WORD\[5\].W.BYTE\[2\].B.BIT\[2\].OBUF0 SLICE_16\[1\].RAM16.SLICE\[0\].RAM8.WORD\[5\].W.BYTE\[2\].B.Q_WIRE\[2\]
+ SLICE_16\[1\].RAM16.SLICE\[0\].RAM8.WORD\[5\].W.BYTE\[2\].B.SEL0_B VGND VGND VPWR
+ VPWR SLICE_16\[1\].RAM16.BYTE\[2\].FLOATBUF0\[18\].Z sky130_fd_sc_hd__ebufn_2
XSLICE_16\[0\].RAM16.SLICE\[0\].RAM8.WORD\[4\].W.BYTE\[1\].B.BIT\[3\].genblk1.STORAGE
+ DIBUF\[11\].X SLICE_16\[0\].RAM16.SLICE\[0\].RAM8.WORD\[4\].W.BYTE\[1\].B.GCLK VGND
+ VGND VPWR VPWR SLICE_16\[0\].RAM16.SLICE\[0\].RAM8.WORD\[4\].W.BYTE\[1\].B.Q_WIRE\[3\]
+ sky130_fd_sc_hd__dlxtp_1
XSLICE_16\[0\].RAM16.SLICE\[0\].RAM8.WORD\[7\].W.BYTE\[1\].B.BIT\[3\].OBUF0 SLICE_16\[0\].RAM16.SLICE\[0\].RAM8.WORD\[7\].W.BYTE\[1\].B.Q_WIRE\[3\]
+ SLICE_16\[0\].RAM16.SLICE\[0\].RAM8.WORD\[7\].W.BYTE\[1\].B.SEL0_B VGND VGND VPWR
+ VPWR SLICE_16\[0\].RAM16.BYTE\[1\].FLOATBUF0\[11\].Z sky130_fd_sc_hd__ebufn_2
XSLICE_16\[0\].RAM16.SLICE\[1\].RAM8.WORD\[5\].W.CLKBUF SLICE_16\[0\].RAM16.SLICE\[1\].RAM8.CLKBUF.X
+ VGND VGND VPWR VPWR SLICE_16\[0\].RAM16.SLICE\[1\].RAM8.WORD\[5\].W.BYTE\[0\].B.CLK
+ sky130_fd_sc_hd__clkbuf_4
XSLICE_16\[0\].RAM16.SLICE\[0\].RAM8.WORD\[2\].W.BYTE\[3\].B.genblk1.CLKINV SLICE_16\[0\].RAM16.SLICE\[0\].RAM8.WORD\[2\].W.BYTE\[0\].B.CLK
+ VGND VGND VPWR VPWR SLICE_16\[0\].RAM16.SLICE\[0\].RAM8.WORD\[2\].W.BYTE\[3\].B.CLK_B
+ sky130_fd_sc_hd__inv_1
Xfill_40_2 VGND VGND VPWR VPWR sky130_fd_sc_hd__decap_12
Xfill_33_1 VGND VPWR sky130_fd_sc_hd__tapvpwrvgnd_1
Xfill_26_0 VGND VPWR sky130_fd_sc_hd__tapvpwrvgnd_1
XSLICE_16\[1\].RAM16.SLICE\[1\].RAM8.WORD\[7\].W.BYTE\[0\].B.BIT\[0\].genblk1.STORAGE
+ DIBUF\[0\].X SLICE_16\[1\].RAM16.SLICE\[1\].RAM8.WORD\[7\].W.BYTE\[0\].B.GCLK VGND
+ VGND VPWR VPWR SLICE_16\[1\].RAM16.SLICE\[1\].RAM8.WORD\[7\].W.BYTE\[0\].B.Q_WIRE\[0\]
+ sky130_fd_sc_hd__dlxtp_1
XSLICE_16\[1\].RAM16.SLICE\[1\].RAM8.WORD\[3\].W.BYTE\[3\].B.BIT\[2\].genblk1.STORAGE
+ DIBUF\[26\].X SLICE_16\[1\].RAM16.SLICE\[1\].RAM8.WORD\[3\].W.BYTE\[3\].B.GCLK VGND
+ VGND VPWR VPWR SLICE_16\[1\].RAM16.SLICE\[1\].RAM8.WORD\[3\].W.BYTE\[3\].B.Q_WIRE\[2\]
+ sky130_fd_sc_hd__dlxtp_1
XSLICE_16\[1\].RAM16.SLICE\[1\].RAM8.WORD\[1\].W.BYTE\[1\].B.BIT\[1\].genblk1.STORAGE
+ DIBUF\[9\].X SLICE_16\[1\].RAM16.SLICE\[1\].RAM8.WORD\[1\].W.BYTE\[1\].B.GCLK VGND
+ VGND VPWR VPWR SLICE_16\[1\].RAM16.SLICE\[1\].RAM8.WORD\[1\].W.BYTE\[1\].B.Q_WIRE\[1\]
+ sky130_fd_sc_hd__dlxtp_1
XSLICE_16\[1\].RAM16.SLICE\[1\].RAM8.WORD\[0\].W.BYTE\[3\].B.BIT\[5\].OBUF0 SLICE_16\[1\].RAM16.SLICE\[1\].RAM8.WORD\[0\].W.BYTE\[3\].B.Q_WIRE\[5\]
+ SLICE_16\[1\].RAM16.SLICE\[1\].RAM8.WORD\[0\].W.BYTE\[3\].B.SEL0_B VGND VGND VPWR
+ VPWR SLICE_16\[1\].RAM16.BYTE\[3\].FLOATBUF0\[29\].Z sky130_fd_sc_hd__ebufn_2
Xtap_18_22 VGND VPWR sky130_fd_sc_hd__tapvpwrvgnd_1
Xtap_18_11 VGND VPWR sky130_fd_sc_hd__tapvpwrvgnd_1
XSLICE_16\[0\].RAM16.SLICE\[1\].RAM8.WORD\[2\].W.BYTE\[2\].B.genblk1.CG SLICE_16\[0\].RAM16.SLICE\[1\].RAM8.WORD\[2\].W.BYTE\[2\].B.CLK_B
+ SLICE_16\[0\].RAM16.SLICE\[1\].RAM8.WORD\[2\].W.BYTE\[2\].B.WE0_WIRE VGND VGND VPWR
+ VPWR SLICE_16\[0\].RAM16.SLICE\[1\].RAM8.WORD\[2\].W.BYTE\[2\].B.GCLK sky130_fd_sc_hd__dlclkp_1
Xtap_34_32 VGND VPWR sky130_fd_sc_hd__tapvpwrvgnd_1
Xtap_34_21 VGND VPWR sky130_fd_sc_hd__tapvpwrvgnd_1
Xtap_34_10 VGND VPWR sky130_fd_sc_hd__tapvpwrvgnd_1
XSLICE_16\[1\].RAM16.SLICE\[1\].RAM8.WORD\[3\].W.BYTE\[0\].B.SEL0INV SLICE_16\[1\].RAM16.SLICE\[1\].RAM8.WORD\[3\].W.BYTE\[0\].B.SEL0
+ VGND VGND VPWR VPWR SLICE_16\[1\].RAM16.SLICE\[1\].RAM8.WORD\[3\].W.BYTE\[0\].B.SEL0_B
+ sky130_fd_sc_hd__inv_1
XSLICE_16\[1\].RAM16.SLICE\[0\].RAM8.WORD\[5\].W.BYTE\[0\].B.BIT\[7\].OBUF0 SLICE_16\[1\].RAM16.SLICE\[0\].RAM8.WORD\[5\].W.BYTE\[0\].B.Q_WIRE\[7\]
+ SLICE_16\[1\].RAM16.SLICE\[0\].RAM8.WORD\[5\].W.BYTE\[0\].B.SEL0_B VGND VGND VPWR
+ VPWR SLICE_16\[1\].RAM16.BYTE\[0\].FLOATBUF0\[7\].Z sky130_fd_sc_hd__ebufn_2
XDo0MUX.M\[1\].DIODE_A1MUX\[13\] Do0MUX.A1\[13\] VGND VGND VPWR VPWR sky130_fd_sc_hd__diode_2
XSLICE_16\[0\].RAM16.SLICE\[1\].RAM8.WORD\[2\].W.BYTE\[2\].B.BIT\[6\].OBUF0 SLICE_16\[0\].RAM16.SLICE\[1\].RAM8.WORD\[2\].W.BYTE\[2\].B.Q_WIRE\[6\]
+ SLICE_16\[0\].RAM16.SLICE\[1\].RAM8.WORD\[2\].W.BYTE\[2\].B.SEL0_B VGND VGND VPWR
+ VPWR SLICE_16\[0\].RAM16.BYTE\[2\].FLOATBUF0\[22\].Z sky130_fd_sc_hd__ebufn_2
XSLICE_16\[1\].RAM16.SLICE\[0\].RAM8.WORD\[6\].W.BYTE\[2\].B.BIT\[7\].genblk1.STORAGE
+ DIBUF\[23\].X SLICE_16\[1\].RAM16.SLICE\[0\].RAM8.WORD\[6\].W.BYTE\[2\].B.GCLK VGND
+ VGND VPWR VPWR SLICE_16\[1\].RAM16.SLICE\[0\].RAM8.WORD\[6\].W.BYTE\[2\].B.Q_WIRE\[7\]
+ sky130_fd_sc_hd__dlxtp_1
XSLICE_16\[1\].RAM16.SLICE\[0\].RAM8.WORD\[4\].W.BYTE\[0\].B.BIT\[6\].genblk1.STORAGE
+ DIBUF\[6\].X SLICE_16\[1\].RAM16.SLICE\[0\].RAM8.WORD\[4\].W.BYTE\[0\].B.GCLK VGND
+ VGND VPWR VPWR SLICE_16\[1\].RAM16.SLICE\[0\].RAM8.WORD\[4\].W.BYTE\[0\].B.Q_WIRE\[6\]
+ sky130_fd_sc_hd__dlxtp_1
Xfill_22_97 VGND VGND VPWR VPWR sky130_fd_sc_hd__decap_12
Xfill_22_86 VGND VGND VPWR VPWR sky130_fd_sc_hd__decap_12
Xfill_22_75 VGND VPWR sky130_fd_sc_hd__tapvpwrvgnd_1
Xfill_22_64 VGND VGND VPWR VPWR sky130_fd_sc_hd__decap_12
Xfill_22_53 VGND VGND VPWR VPWR sky130_fd_sc_hd__decap_12
Xfill_22_42 VGND VPWR sky130_fd_sc_hd__tapvpwrvgnd_1
Xfill_22_31 VGND VGND VPWR VPWR sky130_fd_sc_hd__decap_12
Xfill_22_20 VGND VGND VPWR VPWR sky130_fd_sc_hd__decap_12
Xfill_47_50 VGND VGND VPWR VPWR sky130_fd_sc_hd__decap_12
XSLICE_16\[0\].RAM16.SLICE\[1\].RAM8.WORD\[6\].W.BYTE\[0\].B.BIT\[7\].genblk1.STORAGE
+ DIBUF\[7\].X SLICE_16\[0\].RAM16.SLICE\[1\].RAM8.WORD\[6\].W.BYTE\[0\].B.GCLK VGND
+ VGND VPWR VPWR SLICE_16\[0\].RAM16.SLICE\[1\].RAM8.WORD\[6\].W.BYTE\[0\].B.Q_WIRE\[7\]
+ sky130_fd_sc_hd__dlxtp_1
Xfill_47_61 VGND VGND VPWR VPWR sky130_fd_sc_hd__decap_12
Xfill_12_6 VGND VGND VPWR VPWR sky130_fd_sc_hd__fill_2
XSLICE_16\[0\].RAM16.SLICE\[0\].RAM8.WORD\[1\].W.BYTE\[3\].B.BIT\[4\].genblk1.STORAGE
+ DIBUF\[28\].X SLICE_16\[0\].RAM16.SLICE\[0\].RAM8.WORD\[1\].W.BYTE\[3\].B.GCLK VGND
+ VGND VPWR VPWR SLICE_16\[0\].RAM16.SLICE\[0\].RAM8.WORD\[1\].W.BYTE\[3\].B.Q_WIRE\[4\]
+ sky130_fd_sc_hd__dlxtp_1
XSLICE_16\[0\].RAM16.SLICE\[0\].RAM8.WORD\[7\].W.BYTE\[2\].B.BIT\[3\].genblk1.STORAGE
+ DIBUF\[19\].X SLICE_16\[0\].RAM16.SLICE\[0\].RAM8.WORD\[7\].W.BYTE\[2\].B.GCLK VGND
+ VGND VPWR VPWR SLICE_16\[0\].RAM16.SLICE\[0\].RAM8.WORD\[7\].W.BYTE\[2\].B.Q_WIRE\[3\]
+ sky130_fd_sc_hd__dlxtp_1
XSLICE_16\[0\].RAM16.SLICE\[0\].RAM8.WORD\[5\].W.BYTE\[0\].B.BIT\[2\].genblk1.STORAGE
+ DIBUF\[2\].X SLICE_16\[0\].RAM16.SLICE\[0\].RAM8.WORD\[5\].W.BYTE\[0\].B.GCLK VGND
+ VGND VPWR VPWR SLICE_16\[0\].RAM16.SLICE\[0\].RAM8.WORD\[5\].W.BYTE\[0\].B.Q_WIRE\[2\]
+ sky130_fd_sc_hd__dlxtp_1
XDo0MUX.M\[2\].DIODE_A1MUX\[17\] Do0MUX.A1\[17\] VGND VGND VPWR VPWR sky130_fd_sc_hd__diode_2
Xtap_1_27 VGND VPWR sky130_fd_sc_hd__tapvpwrvgnd_1
Xtap_1_16 VGND VPWR sky130_fd_sc_hd__tapvpwrvgnd_1
XSLICE_16\[0\].RAM16.SLICE\[1\].RAM8.WORD\[1\].W.BYTE\[0\].B.BIT\[3\].OBUF0 SLICE_16\[0\].RAM16.SLICE\[1\].RAM8.WORD\[1\].W.BYTE\[0\].B.Q_WIRE\[3\]
+ SLICE_16\[0\].RAM16.SLICE\[1\].RAM8.WORD\[1\].W.BYTE\[0\].B.SEL0_B VGND VGND VPWR
+ VPWR SLICE_16\[0\].RAM16.BYTE\[0\].FLOATBUF0\[3\].Z sky130_fd_sc_hd__ebufn_2
XSLICE_16\[0\].RAM16.SLICE\[1\].RAM8.WORD\[1\].W.BYTE\[1\].B.SEL0INV SLICE_16\[0\].RAM16.SLICE\[1\].RAM8.WORD\[1\].W.BYTE\[0\].B.SEL0
+ VGND VGND VPWR VPWR SLICE_16\[0\].RAM16.SLICE\[1\].RAM8.WORD\[1\].W.BYTE\[1\].B.SEL0_B
+ sky130_fd_sc_hd__inv_1
XSLICE_16\[0\].RAM16.SLICE\[1\].RAM8.WORD\[5\].W.BYTE\[3\].B.BIT\[6\].OBUF0 SLICE_16\[0\].RAM16.SLICE\[1\].RAM8.WORD\[5\].W.BYTE\[3\].B.Q_WIRE\[6\]
+ SLICE_16\[0\].RAM16.SLICE\[1\].RAM8.WORD\[5\].W.BYTE\[3\].B.SEL0_B VGND VGND VPWR
+ VPWR SLICE_16\[0\].RAM16.BYTE\[3\].FLOATBUF0\[30\].Z sky130_fd_sc_hd__ebufn_2
XDIBUF\[19\].__cell__ Di0[19] VGND VGND VPWR VPWR DIBUF\[19\].X sky130_fd_sc_hd__clkbuf_16
Xfill_43_19 VGND VGND VPWR VPWR sky130_fd_sc_hd__decap_12
Xtap_39_3 VGND VPWR sky130_fd_sc_hd__tapvpwrvgnd_1
Xtap_29_21 VGND VPWR sky130_fd_sc_hd__tapvpwrvgnd_1
Xtap_29_10 VGND VPWR sky130_fd_sc_hd__tapvpwrvgnd_1
Xtap_29_32 VGND VPWR sky130_fd_sc_hd__tapvpwrvgnd_1
XSLICE_16\[1\].RAM16.SLICE\[0\].RAM8.WORD\[6\].W.BYTE\[0\].B.genblk1.CG SLICE_16\[1\].RAM16.SLICE\[0\].RAM8.WORD\[6\].W.BYTE\[0\].B.CLK_B
+ SLICE_16\[1\].RAM16.SLICE\[0\].RAM8.WORD\[6\].W.BYTE\[0\].B.WE0_WIRE VGND VGND VPWR
+ VPWR SLICE_16\[1\].RAM16.SLICE\[0\].RAM8.WORD\[6\].W.BYTE\[0\].B.GCLK sky130_fd_sc_hd__dlclkp_1
XSLICE_16\[1\].RAM16.SLICE\[0\].RAM8.WORD\[3\].W.BYTE\[0\].B.CGAND SLICE_16\[1\].RAM16.SLICE\[0\].RAM8.WORD\[3\].W.BYTE\[0\].B.SEL0
+ SLICE_16\[1\].RAM16.SLICE\[0\].RAM8.WE0_buf\[0\] VGND VGND VPWR VPWR SLICE_16\[1\].RAM16.SLICE\[0\].RAM8.WORD\[3\].W.BYTE\[0\].B.WE0_WIRE
+ sky130_fd_sc_hd__and2_1
XSLICE_16\[0\].RAM16.SLICE\[0\].RAM8.WORD\[0\].W.BYTE\[2\].B.BIT\[5\].OBUF0 SLICE_16\[0\].RAM16.SLICE\[0\].RAM8.WORD\[0\].W.BYTE\[2\].B.Q_WIRE\[5\]
+ SLICE_16\[0\].RAM16.SLICE\[0\].RAM8.WORD\[0\].W.BYTE\[2\].B.SEL0_B VGND VGND VPWR
+ VPWR SLICE_16\[0\].RAM16.BYTE\[2\].FLOATBUF0\[21\].Z sky130_fd_sc_hd__ebufn_2
XSLICE_16\[1\].RAM16.SLICE\[1\].RAM8.WORD\[4\].W.BYTE\[2\].B.BIT\[1\].genblk1.STORAGE
+ DIBUF\[17\].X SLICE_16\[1\].RAM16.SLICE\[1\].RAM8.WORD\[4\].W.BYTE\[2\].B.GCLK VGND
+ VGND VPWR VPWR SLICE_16\[1\].RAM16.SLICE\[1\].RAM8.WORD\[4\].W.BYTE\[2\].B.Q_WIRE\[1\]
+ sky130_fd_sc_hd__dlxtp_1
XSLICE_16\[1\].RAM16.SLICE\[1\].RAM8.WORD\[2\].W.BYTE\[2\].B.BIT\[2\].OBUF0 SLICE_16\[1\].RAM16.SLICE\[1\].RAM8.WORD\[2\].W.BYTE\[2\].B.Q_WIRE\[2\]
+ SLICE_16\[1\].RAM16.SLICE\[1\].RAM8.WORD\[2\].W.BYTE\[2\].B.SEL0_B VGND VGND VPWR
+ VPWR SLICE_16\[1\].RAM16.BYTE\[2\].FLOATBUF0\[18\].Z sky130_fd_sc_hd__ebufn_2
Xfill_17_64 VGND VPWR sky130_fd_sc_hd__tapvpwrvgnd_1
Xfill_17_53 VGND VGND VPWR VPWR sky130_fd_sc_hd__decap_12
Xfill_17_42 VGND VPWR sky130_fd_sc_hd__tapvpwrvgnd_1
Xfill_17_31 VGND VGND VPWR VPWR sky130_fd_sc_hd__decap_12
Xfill_17_20 VGND VGND VPWR VPWR sky130_fd_sc_hd__decap_12
XSLICE_16\[1\].RAM16.SLICE\[1\].RAM8.WORD\[2\].W.BYTE\[0\].B.BIT\[0\].genblk1.STORAGE
+ DIBUF\[0\].X SLICE_16\[1\].RAM16.SLICE\[1\].RAM8.WORD\[2\].W.BYTE\[0\].B.GCLK VGND
+ VGND VPWR VPWR SLICE_16\[1\].RAM16.SLICE\[1\].RAM8.WORD\[2\].W.BYTE\[0\].B.Q_WIRE\[0\]
+ sky130_fd_sc_hd__dlxtp_1
XSLICE_16\[0\].RAM16.SLICE\[1\].RAM8.WORD\[4\].W.BYTE\[1\].B.BIT\[3\].OBUF0 SLICE_16\[0\].RAM16.SLICE\[1\].RAM8.WORD\[4\].W.BYTE\[1\].B.Q_WIRE\[3\]
+ SLICE_16\[0\].RAM16.SLICE\[1\].RAM8.WORD\[4\].W.BYTE\[1\].B.SEL0_B VGND VGND VPWR
+ VPWR SLICE_16\[0\].RAM16.BYTE\[1\].FLOATBUF0\[11\].Z sky130_fd_sc_hd__ebufn_2
XSLICE_16\[1\].RAM16.SLICE\[0\].RAM8.WORD\[7\].W.BYTE\[1\].B.BIT\[6\].genblk1.STORAGE
+ DIBUF\[14\].X SLICE_16\[1\].RAM16.SLICE\[0\].RAM8.WORD\[7\].W.BYTE\[1\].B.GCLK VGND
+ VGND VPWR VPWR SLICE_16\[1\].RAM16.SLICE\[0\].RAM8.WORD\[7\].W.BYTE\[1\].B.Q_WIRE\[6\]
+ sky130_fd_sc_hd__dlxtp_1
XSLICE_16\[1\].RAM16.SLICE\[0\].RAM8.WORD\[1\].W.BYTE\[2\].B.BIT\[7\].genblk1.STORAGE
+ DIBUF\[23\].X SLICE_16\[1\].RAM16.SLICE\[0\].RAM8.WORD\[1\].W.BYTE\[2\].B.GCLK VGND
+ VGND VPWR VPWR SLICE_16\[1\].RAM16.SLICE\[0\].RAM8.WORD\[1\].W.BYTE\[2\].B.Q_WIRE\[7\]
+ sky130_fd_sc_hd__dlxtp_1
Xfill_8_5 VGND VPWR sky130_fd_sc_hd__tapvpwrvgnd_1
Xfill_10_3 VGND VPWR sky130_fd_sc_hd__tapvpwrvgnd_1
XSLICE_16\[0\].RAM16.SLICE\[0\].RAM8.WORD\[3\].W.BYTE\[3\].B.BIT\[5\].OBUF0 SLICE_16\[0\].RAM16.SLICE\[0\].RAM8.WORD\[3\].W.BYTE\[3\].B.Q_WIRE\[5\]
+ SLICE_16\[0\].RAM16.SLICE\[0\].RAM8.WORD\[3\].W.BYTE\[3\].B.SEL0_B VGND VGND VPWR
+ VPWR SLICE_16\[0\].RAM16.BYTE\[3\].FLOATBUF0\[29\].Z sky130_fd_sc_hd__ebufn_2
Xtap_25_9 VGND VPWR sky130_fd_sc_hd__tapvpwrvgnd_1
Xtap_18_8 VGND VPWR sky130_fd_sc_hd__tapvpwrvgnd_1
XSLICE_16\[0\].RAM16.SLICE\[0\].RAM8.WORD\[5\].W.BYTE\[2\].B.CGAND SLICE_16\[0\].RAM16.SLICE\[0\].RAM8.WORD\[5\].W.BYTE\[0\].B.SEL0
+ SLICE_16\[0\].RAM16.SLICE\[0\].RAM8.WE0_buf\[2\] VGND VGND VPWR VPWR SLICE_16\[0\].RAM16.SLICE\[0\].RAM8.WORD\[5\].W.BYTE\[2\].B.WE0_WIRE
+ sky130_fd_sc_hd__and2_1
XSLICE_16\[0\].RAM16.SLICE\[1\].RAM8.WORD\[1\].W.BYTE\[0\].B.BIT\[7\].genblk1.STORAGE
+ DIBUF\[7\].X SLICE_16\[0\].RAM16.SLICE\[1\].RAM8.WORD\[1\].W.BYTE\[0\].B.GCLK VGND
+ VGND VPWR VPWR SLICE_16\[0\].RAM16.SLICE\[1\].RAM8.WORD\[1\].W.BYTE\[0\].B.Q_WIRE\[7\]
+ sky130_fd_sc_hd__dlxtp_1
XSLICE_16\[1\].RAM16.SLICE\[1\].RAM8.WORD\[5\].W.BYTE\[3\].B.BIT\[2\].OBUF0 SLICE_16\[1\].RAM16.SLICE\[1\].RAM8.WORD\[5\].W.BYTE\[3\].B.Q_WIRE\[2\]
+ SLICE_16\[1\].RAM16.SLICE\[1\].RAM8.WORD\[5\].W.BYTE\[3\].B.SEL0_B VGND VGND VPWR
+ VPWR SLICE_16\[1\].RAM16.BYTE\[3\].FLOATBUF0\[26\].Z sky130_fd_sc_hd__ebufn_2
Xtap_15_34 VGND VPWR sky130_fd_sc_hd__tapvpwrvgnd_1
Xtap_15_23 VGND VPWR sky130_fd_sc_hd__tapvpwrvgnd_1
Xtap_15_12 VGND VPWR sky130_fd_sc_hd__tapvpwrvgnd_1
XSLICE_16\[0\].RAM16.SLICE\[0\].RAM8.WORD\[2\].W.BYTE\[2\].B.BIT\[3\].genblk1.STORAGE
+ DIBUF\[19\].X SLICE_16\[0\].RAM16.SLICE\[0\].RAM8.WORD\[2\].W.BYTE\[2\].B.GCLK VGND
+ VGND VPWR VPWR SLICE_16\[0\].RAM16.SLICE\[0\].RAM8.WORD\[2\].W.BYTE\[2\].B.Q_WIRE\[3\]
+ sky130_fd_sc_hd__dlxtp_1
Xtap_31_33 VGND VPWR sky130_fd_sc_hd__tapvpwrvgnd_1
Xtap_31_22 VGND VPWR sky130_fd_sc_hd__tapvpwrvgnd_1
Xtap_31_11 VGND VPWR sky130_fd_sc_hd__tapvpwrvgnd_1
XSLICE_16\[0\].RAM16.SLICE\[0\].RAM8.WORD\[0\].W.BYTE\[0\].B.BIT\[2\].genblk1.STORAGE
+ DIBUF\[2\].X SLICE_16\[0\].RAM16.SLICE\[0\].RAM8.WORD\[0\].W.BYTE\[0\].B.GCLK VGND
+ VGND VPWR VPWR SLICE_16\[0\].RAM16.SLICE\[0\].RAM8.WORD\[0\].W.BYTE\[0\].B.Q_WIRE\[2\]
+ sky130_fd_sc_hd__dlxtp_1
Xtap_37_0 VGND VPWR sky130_fd_sc_hd__tapvpwrvgnd_1
XSLICE_16\[1\].RAM16.SLICE\[1\].RAM8.WORD\[2\].W.BYTE\[0\].B.BIT\[7\].OBUF0 SLICE_16\[1\].RAM16.SLICE\[1\].RAM8.WORD\[2\].W.BYTE\[0\].B.Q_WIRE\[7\]
+ SLICE_16\[1\].RAM16.SLICE\[1\].RAM8.WORD\[2\].W.BYTE\[0\].B.SEL0_B VGND VGND VPWR
+ VPWR SLICE_16\[1\].RAM16.BYTE\[0\].FLOATBUF0\[7\].Z sky130_fd_sc_hd__ebufn_2
XSLICE_16\[1\].RAM16.SLICE\[0\].RAM8.WORD\[0\].W.BYTE\[2\].B.BIT\[1\].OBUF0 SLICE_16\[1\].RAM16.SLICE\[0\].RAM8.WORD\[0\].W.BYTE\[2\].B.Q_WIRE\[1\]
+ SLICE_16\[1\].RAM16.SLICE\[0\].RAM8.WORD\[0\].W.BYTE\[2\].B.SEL0_B VGND VGND VPWR
+ VPWR SLICE_16\[1\].RAM16.BYTE\[2\].FLOATBUF0\[17\].Z sky130_fd_sc_hd__ebufn_2
XSLICE_16\[0\].RAM16.SLICE\[1\].RAM8.WORD\[7\].W.BYTE\[2\].B.BIT\[3\].OBUF0 SLICE_16\[0\].RAM16.SLICE\[1\].RAM8.WORD\[7\].W.BYTE\[2\].B.Q_WIRE\[3\]
+ SLICE_16\[0\].RAM16.SLICE\[1\].RAM8.WORD\[7\].W.BYTE\[2\].B.SEL0_B VGND VGND VPWR
+ VPWR SLICE_16\[0\].RAM16.BYTE\[2\].FLOATBUF0\[19\].Z sky130_fd_sc_hd__ebufn_2
Xfill_44_95 VGND VGND VPWR VPWR sky130_fd_sc_hd__decap_12
Xfill_44_84 VGND VPWR sky130_fd_sc_hd__tapvpwrvgnd_1
Xfill_44_73 VGND VGND VPWR VPWR sky130_fd_sc_hd__decap_12
Xfill_44_62 VGND VGND VPWR VPWR sky130_fd_sc_hd__decap_12
Xfill_44_51 VGND VPWR sky130_fd_sc_hd__tapvpwrvgnd_1
Xfill_44_40 VGND VGND VPWR VPWR sky130_fd_sc_hd__decap_12
XSLICE_16\[0\].RAM16.SLICE\[1\].RAM8.WEBUF\[2\].__cell__ SLICE_16\[0\].RAM16.SLICE\[0\].RAM8.WE0\[2\]
+ VGND VGND VPWR VPWR SLICE_16\[0\].RAM16.SLICE\[1\].RAM8.WE0_buf\[2\] sky130_fd_sc_hd__clkbuf_2
XSLICE_16\[0\].RAM16.SLICE\[0\].RAM8.WORD\[2\].W.BYTE\[1\].B.BIT\[2\].OBUF0 SLICE_16\[0\].RAM16.SLICE\[0\].RAM8.WORD\[2\].W.BYTE\[1\].B.Q_WIRE\[2\]
+ SLICE_16\[0\].RAM16.SLICE\[0\].RAM8.WORD\[2\].W.BYTE\[1\].B.SEL0_B VGND VGND VPWR
+ VPWR SLICE_16\[0\].RAM16.BYTE\[1\].FLOATBUF0\[10\].Z sky130_fd_sc_hd__ebufn_2
Xfill_41_102 VGND VGND VPWR VPWR sky130_fd_sc_hd__decap_3
XSLICE_16\[1\].RAM16.SLICE\[1\].RAM8.WORD\[7\].W.BYTE\[3\].B.BIT\[1\].genblk1.STORAGE
+ DIBUF\[25\].X SLICE_16\[1\].RAM16.SLICE\[1\].RAM8.WORD\[7\].W.BYTE\[3\].B.GCLK VGND
+ VGND VPWR VPWR SLICE_16\[1\].RAM16.SLICE\[1\].RAM8.WORD\[7\].W.BYTE\[3\].B.Q_WIRE\[1\]
+ sky130_fd_sc_hd__dlxtp_1
XSLICE_16\[0\].RAM16.WEBUF\[1\].__cell__ SLICE_16\[0\].RAM16.WE0\[1\] VGND VGND VPWR
+ VPWR SLICE_16\[0\].RAM16.SLICE\[0\].RAM8.WE0\[1\] sky130_fd_sc_hd__clkbuf_2
XSLICE_16\[1\].RAM16.SLICE\[1\].RAM8.WORD\[5\].W.BYTE\[1\].B.BIT\[0\].genblk1.STORAGE
+ DIBUF\[8\].X SLICE_16\[1\].RAM16.SLICE\[1\].RAM8.WORD\[5\].W.BYTE\[1\].B.GCLK VGND
+ VGND VPWR VPWR SLICE_16\[1\].RAM16.SLICE\[1\].RAM8.WORD\[5\].W.BYTE\[1\].B.Q_WIRE\[0\]
+ sky130_fd_sc_hd__dlxtp_1
Xfill_6_2 VGND VGND VPWR VPWR sky130_fd_sc_hd__decap_3
XSLICE_16\[0\].RAM16.SLICE\[1\].RAM8.WORD\[6\].W.BYTE\[0\].B.BIT\[0\].OBUF0 SLICE_16\[0\].RAM16.SLICE\[1\].RAM8.WORD\[6\].W.BYTE\[0\].B.Q_WIRE\[0\]
+ SLICE_16\[0\].RAM16.SLICE\[1\].RAM8.WORD\[6\].W.BYTE\[0\].B.SEL0_B VGND VGND VPWR
+ VPWR SLICE_16\[0\].RAM16.BYTE\[0\].FLOATBUF0\[0\].Z sky130_fd_sc_hd__ebufn_2
Xtap_7_15 VGND VPWR sky130_fd_sc_hd__tapvpwrvgnd_1
Xtap_7_26 VGND VPWR sky130_fd_sc_hd__tapvpwrvgnd_1
XSLICE_16\[1\].RAM16.SLICE\[1\].RAM8.WORD\[5\].W.BYTE\[1\].B.BIT\[7\].OBUF0 SLICE_16\[1\].RAM16.SLICE\[1\].RAM8.WORD\[5\].W.BYTE\[1\].B.Q_WIRE\[7\]
+ SLICE_16\[1\].RAM16.SLICE\[1\].RAM8.WORD\[5\].W.BYTE\[1\].B.SEL0_B VGND VGND VPWR
+ VPWR SLICE_16\[1\].RAM16.BYTE\[1\].FLOATBUF0\[15\].Z sky130_fd_sc_hd__ebufn_2
XSLICE_16\[1\].RAM16.FBUFENBUF0\[0\].__cell__ DEC0.SEL\[1\] VGND VGND VPWR VPWR SLICE_16\[1\].RAM16.BYTE\[0\].FLOATBUF0\[0\].TE_B
+ sky130_fd_sc_hd__clkbuf_2
Xtap_30_7 VGND VPWR sky130_fd_sc_hd__tapvpwrvgnd_1
XSLICE_16\[1\].RAM16.SLICE\[0\].RAM8.WORD\[3\].W.BYTE\[3\].B.BIT\[1\].OBUF0 SLICE_16\[1\].RAM16.SLICE\[0\].RAM8.WORD\[3\].W.BYTE\[3\].B.Q_WIRE\[1\]
+ SLICE_16\[1\].RAM16.SLICE\[0\].RAM8.WORD\[3\].W.BYTE\[3\].B.SEL0_B VGND VGND VPWR
+ VPWR SLICE_16\[1\].RAM16.BYTE\[3\].FLOATBUF0\[25\].Z sky130_fd_sc_hd__ebufn_2
Xtap_23_6 VGND VPWR sky130_fd_sc_hd__tapvpwrvgnd_1
Xtap_26_33 VGND VPWR sky130_fd_sc_hd__tapvpwrvgnd_1
XSLICE_16\[1\].RAM16.SLICE\[0\].RAM8.WORD\[4\].W.BYTE\[3\].B.BIT\[7\].genblk1.STORAGE
+ DIBUF\[31\].X SLICE_16\[1\].RAM16.SLICE\[0\].RAM8.WORD\[4\].W.BYTE\[3\].B.GCLK VGND
+ VGND VPWR VPWR SLICE_16\[1\].RAM16.SLICE\[0\].RAM8.WORD\[4\].W.BYTE\[3\].B.Q_WIRE\[7\]
+ sky130_fd_sc_hd__dlxtp_1
Xtap_26_22 VGND VPWR sky130_fd_sc_hd__tapvpwrvgnd_1
Xtap_26_11 VGND VPWR sky130_fd_sc_hd__tapvpwrvgnd_1
Xtap_16_5 VGND VPWR sky130_fd_sc_hd__tapvpwrvgnd_1
Xtap_9_4 VGND VPWR sky130_fd_sc_hd__tapvpwrvgnd_1
XSLICE_16\[1\].RAM16.SLICE\[0\].RAM8.WORD\[2\].W.BYTE\[1\].B.BIT\[6\].genblk1.STORAGE
+ DIBUF\[14\].X SLICE_16\[1\].RAM16.SLICE\[0\].RAM8.WORD\[2\].W.BYTE\[1\].B.GCLK VGND
+ VGND VPWR VPWR SLICE_16\[1\].RAM16.SLICE\[0\].RAM8.WORD\[2\].W.BYTE\[1\].B.Q_WIRE\[6\]
+ sky130_fd_sc_hd__dlxtp_1
XSLICE_16\[1\].RAM16.SLICE\[0\].RAM8.WORD\[0\].W.BYTE\[0\].B.BIT\[6\].OBUF0 SLICE_16\[1\].RAM16.SLICE\[0\].RAM8.WORD\[0\].W.BYTE\[0\].B.Q_WIRE\[6\]
+ SLICE_16\[1\].RAM16.SLICE\[0\].RAM8.WORD\[0\].W.BYTE\[0\].B.SEL0_B VGND VGND VPWR
+ VPWR SLICE_16\[1\].RAM16.BYTE\[0\].FLOATBUF0\[6\].Z sky130_fd_sc_hd__ebufn_2
XSLICE_16\[0\].RAM16.SLICE\[1\].RAM8.WORD\[6\].W.BYTE\[1\].B.CGAND SLICE_16\[0\].RAM16.SLICE\[1\].RAM8.WORD\[6\].W.BYTE\[0\].B.SEL0
+ SLICE_16\[0\].RAM16.SLICE\[1\].RAM8.WE0_buf\[1\] VGND VGND VPWR VPWR SLICE_16\[0\].RAM16.SLICE\[1\].RAM8.WORD\[6\].W.BYTE\[1\].B.WE0_WIRE
+ sky130_fd_sc_hd__and2_1
XSLICE_16\[0\].RAM16.SLICE\[0\].RAM8.WORD\[5\].W.BYTE\[2\].B.BIT\[2\].OBUF0 SLICE_16\[0\].RAM16.SLICE\[0\].RAM8.WORD\[5\].W.BYTE\[2\].B.Q_WIRE\[2\]
+ SLICE_16\[0\].RAM16.SLICE\[0\].RAM8.WORD\[5\].W.BYTE\[2\].B.SEL0_B VGND VGND VPWR
+ VPWR SLICE_16\[0\].RAM16.BYTE\[2\].FLOATBUF0\[18\].Z sky130_fd_sc_hd__ebufn_2
XDo0MUX.M\[0\].DIODE_A0MUX\[1\] Do0MUX.A0\[1\] VGND VGND VPWR VPWR sky130_fd_sc_hd__diode_2
XSLICE_16\[0\].RAM16.SLICE\[1\].RAM8.WORD\[4\].W.BYTE\[1\].B.BIT\[7\].genblk1.STORAGE
+ DIBUF\[15\].X SLICE_16\[0\].RAM16.SLICE\[1\].RAM8.WORD\[4\].W.BYTE\[1\].B.GCLK VGND
+ VGND VPWR VPWR SLICE_16\[0\].RAM16.SLICE\[1\].RAM8.WORD\[4\].W.BYTE\[1\].B.Q_WIRE\[7\]
+ sky130_fd_sc_hd__dlxtp_1
Xfill_39_51 VGND VPWR sky130_fd_sc_hd__tapvpwrvgnd_1
Xfill_39_40 VGND VGND VPWR VPWR sky130_fd_sc_hd__decap_12
XSLICE_16\[0\].RAM16.SLICE\[0\].RAM8.WORD\[3\].W.BYTE\[1\].B.BIT\[2\].genblk1.STORAGE
+ DIBUF\[10\].X SLICE_16\[0\].RAM16.SLICE\[0\].RAM8.WORD\[3\].W.BYTE\[1\].B.GCLK VGND
+ VGND VPWR VPWR SLICE_16\[0\].RAM16.SLICE\[0\].RAM8.WORD\[3\].W.BYTE\[1\].B.Q_WIRE\[2\]
+ sky130_fd_sc_hd__dlxtp_1
XSLICE_16\[0\].RAM16.SLICE\[0\].RAM8.WORD\[5\].W.BYTE\[3\].B.BIT\[3\].genblk1.STORAGE
+ DIBUF\[27\].X SLICE_16\[0\].RAM16.SLICE\[0\].RAM8.WORD\[5\].W.BYTE\[3\].B.GCLK VGND
+ VGND VPWR VPWR SLICE_16\[0\].RAM16.SLICE\[0\].RAM8.WORD\[5\].W.BYTE\[3\].B.Q_WIRE\[3\]
+ sky130_fd_sc_hd__dlxtp_1
Xfill_44_9 VGND VPWR sky130_fd_sc_hd__tapvpwrvgnd_1
Xfill_39_62 VGND VGND VPWR VPWR sky130_fd_sc_hd__decap_12
XSLICE_16\[0\].RAM16.SLICE\[0\].RAM8.WORD\[0\].W.BYTE\[3\].B.DIODE_CLK SLICE_16\[0\].RAM16.SLICE\[0\].RAM8.WORD\[0\].W.BYTE\[0\].B.CLK
+ VGND VGND VPWR VPWR sky130_fd_sc_hd__diode_2
XSLICE_16\[1\].RAM16.SLICE\[0\].RAM8.WORD\[2\].W.BYTE\[0\].B.DIODE_CLK SLICE_16\[1\].RAM16.SLICE\[0\].RAM8.WORD\[2\].W.BYTE\[0\].B.CLK
+ VGND VGND VPWR VPWR sky130_fd_sc_hd__diode_2
XSLICE_16\[1\].RAM16.SLICE\[0\].RAM8.WORD\[3\].W.BYTE\[1\].B.BIT\[6\].OBUF0 SLICE_16\[1\].RAM16.SLICE\[0\].RAM8.WORD\[3\].W.BYTE\[1\].B.Q_WIRE\[6\]
+ SLICE_16\[1\].RAM16.SLICE\[0\].RAM8.WORD\[3\].W.BYTE\[1\].B.SEL0_B VGND VGND VPWR
+ VPWR SLICE_16\[1\].RAM16.BYTE\[1\].FLOATBUF0\[14\].Z sky130_fd_sc_hd__ebufn_2
Xtap_12_13 VGND VPWR sky130_fd_sc_hd__tapvpwrvgnd_1
XSLICE_16\[0\].RAM16.SLICE\[1\].RAM8.WORD\[0\].W.BYTE\[3\].B.BIT\[5\].OBUF0 SLICE_16\[0\].RAM16.SLICE\[1\].RAM8.WORD\[0\].W.BYTE\[3\].B.Q_WIRE\[5\]
+ SLICE_16\[0\].RAM16.SLICE\[1\].RAM8.WORD\[0\].W.BYTE\[3\].B.SEL0_B VGND VGND VPWR
+ VPWR SLICE_16\[0\].RAM16.BYTE\[3\].FLOATBUF0\[29\].Z sky130_fd_sc_hd__ebufn_2
Xtap_12_35 VGND VPWR sky130_fd_sc_hd__tapvpwrvgnd_1
Xtap_12_24 VGND VPWR sky130_fd_sc_hd__tapvpwrvgnd_1
XSLICE_16\[0\].RAM16.EN0BUF.__cell__ DEC0.SEL\[0\] VGND VGND VPWR VPWR SLICE_16\[0\].RAM16.DEC0.EN
+ sky130_fd_sc_hd__clkbuf_2
XSLICE_16\[1\].RAM16.BYTE\[2\].FLOATBUF0\[18\].__cell__ SLICE_16\[1\].RAM16.BYTE\[2\].FLOATBUF0\[16\].A
+ SLICE_16\[1\].RAM16.BYTE\[2\].FLOATBUF0\[16\].TE_B VGND VGND VPWR VPWR SLICE_16\[1\].RAM16.BYTE\[2\].FLOATBUF0\[18\].Z
+ sky130_fd_sc_hd__ebufn_2
Xtap_37_32 VGND VPWR sky130_fd_sc_hd__tapvpwrvgnd_1
Xtap_37_21 VGND VPWR sky130_fd_sc_hd__tapvpwrvgnd_1
Xtap_37_10 VGND VPWR sky130_fd_sc_hd__tapvpwrvgnd_1
XSLICE_16\[1\].RAM16.SLICE\[1\].RAM8.WORD\[2\].W.BYTE\[3\].B.BIT\[1\].genblk1.STORAGE
+ DIBUF\[25\].X SLICE_16\[1\].RAM16.SLICE\[1\].RAM8.WORD\[2\].W.BYTE\[3\].B.GCLK VGND
+ VGND VPWR VPWR SLICE_16\[1\].RAM16.SLICE\[1\].RAM8.WORD\[2\].W.BYTE\[3\].B.Q_WIRE\[1\]
+ sky130_fd_sc_hd__dlxtp_1
XSLICE_16\[0\].RAM16.Do0_REG.OUTREG_BYTE\[3\].Do_FF\[7\] SLICE_16\[0\].RAM16.Do0_REG.CLKBUF\[3\]
+ SLICE_16\[0\].RAM16.BYTE\[3\].FLOATBUF0\[31\].Z VGND VGND VPWR VPWR Do0MUX.A0\[31\]
+ sky130_fd_sc_hd__dfxtp_1
Xtap_14_2 VGND VPWR sky130_fd_sc_hd__tapvpwrvgnd_1
XSLICE_16\[0\].RAM16.SLICE\[0\].RAM8.WORD\[5\].W.BYTE\[0\].B.BIT\[7\].OBUF0 SLICE_16\[0\].RAM16.SLICE\[0\].RAM8.WORD\[5\].W.BYTE\[0\].B.Q_WIRE\[7\]
+ SLICE_16\[0\].RAM16.SLICE\[0\].RAM8.WORD\[5\].W.BYTE\[0\].B.SEL0_B VGND VGND VPWR
+ VPWR SLICE_16\[0\].RAM16.BYTE\[0\].FLOATBUF0\[7\].Z sky130_fd_sc_hd__ebufn_2
XSLICE_16\[1\].RAM16.SLICE\[1\].RAM8.WORD\[7\].W.BYTE\[0\].B.BIT\[4\].OBUF0 SLICE_16\[1\].RAM16.SLICE\[1\].RAM8.WORD\[7\].W.BYTE\[0\].B.Q_WIRE\[4\]
+ SLICE_16\[1\].RAM16.SLICE\[1\].RAM8.WORD\[7\].W.BYTE\[0\].B.SEL0_B VGND VGND VPWR
+ VPWR SLICE_16\[1\].RAM16.BYTE\[0\].FLOATBUF0\[4\].Z sky130_fd_sc_hd__ebufn_2
XSLICE_16\[1\].RAM16.SLICE\[1\].RAM8.WORD\[0\].W.BYTE\[1\].B.BIT\[0\].genblk1.STORAGE
+ DIBUF\[8\].X SLICE_16\[1\].RAM16.SLICE\[1\].RAM8.WORD\[0\].W.BYTE\[1\].B.GCLK VGND
+ VGND VPWR VPWR SLICE_16\[1\].RAM16.SLICE\[1\].RAM8.WORD\[0\].W.BYTE\[1\].B.Q_WIRE\[0\]
+ sky130_fd_sc_hd__dlxtp_1
Xtap_7_1 VGND VPWR sky130_fd_sc_hd__tapvpwrvgnd_1
XSLICE_16\[0\].RAM16.SLICE\[0\].RAM8.WORD\[5\].W.BYTE\[0\].B.genblk1.CG SLICE_16\[0\].RAM16.SLICE\[0\].RAM8.WORD\[5\].W.BYTE\[0\].B.CLK_B
+ SLICE_16\[0\].RAM16.SLICE\[0\].RAM8.WORD\[5\].W.BYTE\[0\].B.WE0_WIRE VGND VGND VPWR
+ VPWR SLICE_16\[0\].RAM16.SLICE\[0\].RAM8.WORD\[5\].W.BYTE\[0\].B.GCLK sky130_fd_sc_hd__dlclkp_1
Xfill_41_96 VGND VPWR sky130_fd_sc_hd__tapvpwrvgnd_1
Xfill_41_85 VGND VGND VPWR VPWR sky130_fd_sc_hd__decap_12
Xfill_41_74 VGND VGND VPWR VPWR sky130_fd_sc_hd__decap_12
Xfill_41_63 VGND VPWR sky130_fd_sc_hd__tapvpwrvgnd_1
Xfill_41_52 VGND VGND VPWR VPWR sky130_fd_sc_hd__decap_12
Xfill_41_41 VGND VGND VPWR VPWR sky130_fd_sc_hd__decap_12
Xfill_41_30 VGND VPWR sky130_fd_sc_hd__tapvpwrvgnd_1
Xfill_42_6 VGND VPWR sky130_fd_sc_hd__tapvpwrvgnd_1
XSLICE_16\[1\].RAM16.SLICE\[0\].RAM8.WORD\[7\].W.BYTE\[3\].B.genblk1.CG SLICE_16\[1\].RAM16.SLICE\[0\].RAM8.WORD\[7\].W.BYTE\[3\].B.CLK_B
+ SLICE_16\[1\].RAM16.SLICE\[0\].RAM8.WORD\[7\].W.BYTE\[3\].B.WE0_WIRE VGND VGND VPWR
+ VPWR SLICE_16\[1\].RAM16.SLICE\[0\].RAM8.WORD\[7\].W.BYTE\[3\].B.GCLK sky130_fd_sc_hd__dlclkp_1
XSLICE_16\[1\].RAM16.SLICE\[0\].RAM8.WORD\[5\].W.BYTE\[2\].B.BIT\[6\].genblk1.STORAGE
+ DIBUF\[22\].X SLICE_16\[1\].RAM16.SLICE\[0\].RAM8.WORD\[5\].W.BYTE\[2\].B.GCLK VGND
+ VGND VPWR VPWR SLICE_16\[1\].RAM16.SLICE\[0\].RAM8.WORD\[5\].W.BYTE\[2\].B.Q_WIRE\[6\]
+ sky130_fd_sc_hd__dlxtp_1
Xfill_35_5 VGND VPWR sky130_fd_sc_hd__tapvpwrvgnd_1
XSLICE_16\[1\].RAM16.SLICE\[0\].RAM8.WORD\[6\].W.BYTE\[2\].B.BIT\[6\].OBUF0 SLICE_16\[1\].RAM16.SLICE\[0\].RAM8.WORD\[6\].W.BYTE\[2\].B.Q_WIRE\[6\]
+ SLICE_16\[1\].RAM16.SLICE\[0\].RAM8.WORD\[6\].W.BYTE\[2\].B.SEL0_B VGND VGND VPWR
+ VPWR SLICE_16\[1\].RAM16.BYTE\[2\].FLOATBUF0\[22\].Z sky130_fd_sc_hd__ebufn_2
Xfill_28_4 VGND VGND VPWR VPWR sky130_fd_sc_hd__decap_6
XSLICE_16\[1\].RAM16.SLICE\[0\].RAM8.WORD\[3\].W.BYTE\[0\].B.BIT\[5\].genblk1.STORAGE
+ DIBUF\[5\].X SLICE_16\[1\].RAM16.SLICE\[0\].RAM8.WORD\[3\].W.BYTE\[0\].B.GCLK VGND
+ VGND VPWR VPWR SLICE_16\[1\].RAM16.SLICE\[0\].RAM8.WORD\[3\].W.BYTE\[0\].B.Q_WIRE\[5\]
+ sky130_fd_sc_hd__dlxtp_1
XSLICE_16\[0\].RAM16.SLICE\[1\].RAM8.WORD\[7\].W.BYTE\[2\].B.BIT\[7\].genblk1.STORAGE
+ DIBUF\[23\].X SLICE_16\[0\].RAM16.SLICE\[1\].RAM8.WORD\[7\].W.BYTE\[2\].B.GCLK VGND
+ VGND VPWR VPWR SLICE_16\[0\].RAM16.SLICE\[1\].RAM8.WORD\[7\].W.BYTE\[2\].B.Q_WIRE\[7\]
+ sky130_fd_sc_hd__dlxtp_1
XSLICE_16\[0\].RAM16.SLICE\[1\].RAM8.WORD\[5\].W.BYTE\[0\].B.BIT\[6\].genblk1.STORAGE
+ DIBUF\[6\].X SLICE_16\[0\].RAM16.SLICE\[1\].RAM8.WORD\[5\].W.BYTE\[0\].B.GCLK VGND
+ VGND VPWR VPWR SLICE_16\[0\].RAM16.SLICE\[1\].RAM8.WORD\[5\].W.BYTE\[0\].B.Q_WIRE\[6\]
+ sky130_fd_sc_hd__dlxtp_1
XSLICE_16\[0\].RAM16.SLICE\[0\].RAM8.WORD\[1\].W.BYTE\[1\].B.CGAND SLICE_16\[0\].RAM16.SLICE\[0\].RAM8.WORD\[1\].W.BYTE\[0\].B.SEL0
+ SLICE_16\[0\].RAM16.SLICE\[0\].RAM8.WE0_buf\[1\] VGND VGND VPWR VPWR SLICE_16\[0\].RAM16.SLICE\[0\].RAM8.WORD\[1\].W.BYTE\[1\].B.WE0_WIRE
+ sky130_fd_sc_hd__and2_1
XSLICE_16\[0\].RAM16.SLICE\[0\].RAM8.WORD\[0\].W.BYTE\[3\].B.BIT\[3\].genblk1.STORAGE
+ DIBUF\[27\].X SLICE_16\[0\].RAM16.SLICE\[0\].RAM8.WORD\[0\].W.BYTE\[3\].B.GCLK VGND
+ VGND VPWR VPWR SLICE_16\[0\].RAM16.SLICE\[0\].RAM8.WORD\[0\].W.BYTE\[3\].B.Q_WIRE\[3\]
+ sky130_fd_sc_hd__dlxtp_1
XSLICE_16\[0\].RAM16.SLICE\[0\].RAM8.WORD\[6\].W.BYTE\[2\].B.BIT\[2\].genblk1.STORAGE
+ DIBUF\[18\].X SLICE_16\[0\].RAM16.SLICE\[0\].RAM8.WORD\[6\].W.BYTE\[2\].B.GCLK VGND
+ VGND VPWR VPWR SLICE_16\[0\].RAM16.SLICE\[0\].RAM8.WORD\[6\].W.BYTE\[2\].B.Q_WIRE\[2\]
+ sky130_fd_sc_hd__dlxtp_1
Xtap_4_16 VGND VPWR sky130_fd_sc_hd__tapvpwrvgnd_1
Xtap_4_27 VGND VPWR sky130_fd_sc_hd__tapvpwrvgnd_1
XSLICE_16\[0\].RAM16.SLICE\[0\].RAM8.WORD\[4\].W.BYTE\[0\].B.BIT\[1\].genblk1.STORAGE
+ DIBUF\[1\].X SLICE_16\[0\].RAM16.SLICE\[0\].RAM8.WORD\[4\].W.BYTE\[0\].B.GCLK VGND
+ VGND VPWR VPWR SLICE_16\[0\].RAM16.SLICE\[0\].RAM8.WORD\[4\].W.BYTE\[0\].B.Q_WIRE\[1\]
+ sky130_fd_sc_hd__dlxtp_1
Xfill_46_19 VGND VPWR sky130_fd_sc_hd__tapvpwrvgnd_1
XSLICE_16\[1\].RAM16.SLICE\[1\].RAM8.WORD\[0\].W.BYTE\[3\].B.BIT\[1\].OBUF0 SLICE_16\[1\].RAM16.SLICE\[1\].RAM8.WORD\[0\].W.BYTE\[3\].B.Q_WIRE\[1\]
+ SLICE_16\[1\].RAM16.SLICE\[1\].RAM8.WORD\[0\].W.BYTE\[3\].B.SEL0_B VGND VGND VPWR
+ VPWR SLICE_16\[1\].RAM16.BYTE\[3\].FLOATBUF0\[25\].Z sky130_fd_sc_hd__ebufn_2
Xtap_0_8 VGND VPWR sky130_fd_sc_hd__tapvpwrvgnd_1
XSLICE_16\[1\].RAM16.SLICE\[0\].RAM8.WORD\[5\].W.BYTE\[3\].B.DIODE_CLK SLICE_16\[1\].RAM16.SLICE\[0\].RAM8.WORD\[5\].W.BYTE\[0\].B.CLK
+ VGND VGND VPWR VPWR sky130_fd_sc_hd__diode_2
Xtap_23_34 VGND VPWR sky130_fd_sc_hd__tapvpwrvgnd_1
Xtap_23_23 VGND VPWR sky130_fd_sc_hd__tapvpwrvgnd_1
Xtap_23_12 VGND VPWR sky130_fd_sc_hd__tapvpwrvgnd_1
XSLICE_16\[1\].RAM16.SLICE\[0\].RAM8.WORD\[5\].W.BYTE\[0\].B.BIT\[3\].OBUF0 SLICE_16\[1\].RAM16.SLICE\[0\].RAM8.WORD\[5\].W.BYTE\[0\].B.Q_WIRE\[3\]
+ SLICE_16\[1\].RAM16.SLICE\[0\].RAM8.WORD\[5\].W.BYTE\[0\].B.SEL0_B VGND VGND VPWR
+ VPWR SLICE_16\[1\].RAM16.BYTE\[0\].FLOATBUF0\[3\].Z sky130_fd_sc_hd__ebufn_2
XSLICE_16\[0\].RAM16.SLICE\[1\].RAM8.WORD\[2\].W.BYTE\[2\].B.BIT\[2\].OBUF0 SLICE_16\[0\].RAM16.SLICE\[1\].RAM8.WORD\[2\].W.BYTE\[2\].B.Q_WIRE\[2\]
+ SLICE_16\[0\].RAM16.SLICE\[1\].RAM8.WORD\[2\].W.BYTE\[2\].B.SEL0_B VGND VGND VPWR
+ VPWR SLICE_16\[0\].RAM16.BYTE\[2\].FLOATBUF0\[18\].Z sky130_fd_sc_hd__ebufn_2
XSLICE_16\[1\].RAM16.SLICE\[0\].RAM8.WORD\[0\].W.BYTE\[2\].B.genblk1.CLKINV SLICE_16\[1\].RAM16.SLICE\[0\].RAM8.WORD\[0\].W.BYTE\[0\].B.CLK
+ VGND VGND VPWR VPWR SLICE_16\[1\].RAM16.SLICE\[0\].RAM8.WORD\[0\].W.BYTE\[2\].B.CLK_B
+ sky130_fd_sc_hd__inv_1
XSLICE_16\[1\].RAM16.Do0_REG.OUTREG_BYTE\[3\].DIODE\[2\] SLICE_16\[1\].RAM16.BYTE\[3\].FLOATBUF0\[26\].Z
+ VGND VGND VPWR VPWR sky130_fd_sc_hd__diode_2
XSLICE_16\[1\].RAM16.TIE0\[1\].__cell__ VGND VGND VPWR VPWR SLICE_16\[1\].RAM16.TIE0\[1\].__cell__/HI
+ SLICE_16\[1\].RAM16.BYTE\[1\].FLOATBUF0\[10\].A sky130_fd_sc_hd__conb_1
XSLICE_16\[1\].RAM16.SLICE\[1\].RAM8.WORD\[3\].W.BYTE\[2\].B.BIT\[0\].genblk1.STORAGE
+ DIBUF\[16\].X SLICE_16\[1\].RAM16.SLICE\[1\].RAM8.WORD\[3\].W.BYTE\[2\].B.GCLK VGND
+ VGND VPWR VPWR SLICE_16\[1\].RAM16.SLICE\[1\].RAM8.WORD\[3\].W.BYTE\[2\].B.Q_WIRE\[0\]
+ sky130_fd_sc_hd__dlxtp_1
XSLICE_16\[0\].RAM16.SLICE\[1\].RAM8.WORD\[2\].W.BYTE\[3\].B.DIODE_CLK SLICE_16\[0\].RAM16.SLICE\[1\].RAM8.WORD\[2\].W.BYTE\[0\].B.CLK
+ VGND VGND VPWR VPWR sky130_fd_sc_hd__diode_2
XSLICE_16\[1\].RAM16.SLICE\[1\].RAM8.WORD\[4\].W.BYTE\[0\].B.DIODE_CLK SLICE_16\[1\].RAM16.SLICE\[1\].RAM8.WORD\[4\].W.BYTE\[0\].B.CLK
+ VGND VGND VPWR VPWR sky130_fd_sc_hd__diode_2
XSLICE_16\[0\].RAM16.SLICE\[1\].RAM8.WORD\[1\].W.BYTE\[0\].B.SEL0INV SLICE_16\[0\].RAM16.SLICE\[1\].RAM8.WORD\[1\].W.BYTE\[0\].B.SEL0
+ VGND VGND VPWR VPWR SLICE_16\[0\].RAM16.SLICE\[1\].RAM8.WORD\[1\].W.BYTE\[0\].B.SEL0_B
+ sky130_fd_sc_hd__inv_1
Xfill_40_3 VGND VPWR sky130_fd_sc_hd__tapvpwrvgnd_1
Xfill_33_2 VGND VPWR sky130_fd_sc_hd__tapvpwrvgnd_1
Xfill_26_1 VGND VPWR sky130_fd_sc_hd__tapvpwrvgnd_1
Xfill_19_0 VGND VPWR sky130_fd_sc_hd__tapvpwrvgnd_1
XSLICE_16\[1\].RAM16.SLICE\[1\].RAM8.WORD\[0\].W.BYTE\[1\].B.BIT\[6\].OBUF0 SLICE_16\[1\].RAM16.SLICE\[1\].RAM8.WORD\[0\].W.BYTE\[1\].B.Q_WIRE\[6\]
+ SLICE_16\[1\].RAM16.SLICE\[1\].RAM8.WORD\[0\].W.BYTE\[1\].B.SEL0_B VGND VGND VPWR
+ VPWR SLICE_16\[1\].RAM16.BYTE\[1\].FLOATBUF0\[14\].Z sky130_fd_sc_hd__ebufn_2
XSLICE_16\[0\].RAM16.SLICE\[1\].RAM8.WORD\[5\].W.BYTE\[3\].B.BIT\[2\].OBUF0 SLICE_16\[0\].RAM16.SLICE\[1\].RAM8.WORD\[5\].W.BYTE\[3\].B.Q_WIRE\[2\]
+ SLICE_16\[0\].RAM16.SLICE\[1\].RAM8.WORD\[5\].W.BYTE\[3\].B.SEL0_B VGND VGND VPWR
+ VPWR SLICE_16\[0\].RAM16.BYTE\[3\].FLOATBUF0\[26\].Z sky130_fd_sc_hd__ebufn_2
XSLICE_16\[0\].RAM16.SLICE\[1\].RAM8.WORD\[2\].W.BYTE\[0\].B.CGAND SLICE_16\[0\].RAM16.SLICE\[1\].RAM8.WORD\[2\].W.BYTE\[0\].B.SEL0
+ SLICE_16\[0\].RAM16.SLICE\[1\].RAM8.WE0_buf\[0\] VGND VGND VPWR VPWR SLICE_16\[0\].RAM16.SLICE\[1\].RAM8.WORD\[2\].W.BYTE\[0\].B.WE0_WIRE
+ sky130_fd_sc_hd__and2_1
XSLICE_16\[1\].RAM16.SLICE\[0\].RAM8.WORD\[6\].W.BYTE\[1\].B.BIT\[5\].genblk1.STORAGE
+ DIBUF\[13\].X SLICE_16\[1\].RAM16.SLICE\[0\].RAM8.WORD\[6\].W.BYTE\[1\].B.GCLK VGND
+ VGND VPWR VPWR SLICE_16\[1\].RAM16.SLICE\[0\].RAM8.WORD\[6\].W.BYTE\[1\].B.Q_WIRE\[5\]
+ sky130_fd_sc_hd__dlxtp_1
XSLICE_16\[1\].RAM16.SLICE\[0\].RAM8.WORD\[3\].W.BYTE\[3\].B.genblk1.CLKINV SLICE_16\[1\].RAM16.SLICE\[0\].RAM8.WORD\[3\].W.BYTE\[0\].B.CLK
+ VGND VGND VPWR VPWR SLICE_16\[1\].RAM16.SLICE\[0\].RAM8.WORD\[3\].W.BYTE\[3\].B.CLK_B
+ sky130_fd_sc_hd__inv_1
XSLICE_16\[1\].RAM16.SLICE\[0\].RAM8.WORD\[0\].W.BYTE\[2\].B.BIT\[6\].genblk1.STORAGE
+ DIBUF\[22\].X SLICE_16\[1\].RAM16.SLICE\[0\].RAM8.WORD\[0\].W.BYTE\[2\].B.GCLK VGND
+ VGND VPWR VPWR SLICE_16\[1\].RAM16.SLICE\[0\].RAM8.WORD\[0\].W.BYTE\[2\].B.Q_WIRE\[6\]
+ sky130_fd_sc_hd__dlxtp_1
Xtap_18_23 VGND VPWR sky130_fd_sc_hd__tapvpwrvgnd_1
Xtap_18_12 VGND VPWR sky130_fd_sc_hd__tapvpwrvgnd_1
Xtap_34_33 VGND VPWR sky130_fd_sc_hd__tapvpwrvgnd_1
Xtap_34_22 VGND VPWR sky130_fd_sc_hd__tapvpwrvgnd_1
Xtap_34_11 VGND VPWR sky130_fd_sc_hd__tapvpwrvgnd_1
XSLICE_16\[0\].RAM16.SLICE\[1\].RAM8.WORD\[0\].W.BYTE\[0\].B.BIT\[6\].genblk1.STORAGE
+ DIBUF\[6\].X SLICE_16\[0\].RAM16.SLICE\[1\].RAM8.WORD\[0\].W.BYTE\[0\].B.GCLK VGND
+ VGND VPWR VPWR SLICE_16\[0\].RAM16.SLICE\[1\].RAM8.WORD\[0\].W.BYTE\[0\].B.Q_WIRE\[6\]
+ sky130_fd_sc_hd__dlxtp_1
XSLICE_16\[0\].RAM16.SLICE\[1\].RAM8.WORD\[2\].W.BYTE\[2\].B.BIT\[7\].genblk1.STORAGE
+ DIBUF\[23\].X SLICE_16\[0\].RAM16.SLICE\[1\].RAM8.WORD\[2\].W.BYTE\[2\].B.GCLK VGND
+ VGND VPWR VPWR SLICE_16\[0\].RAM16.SLICE\[1\].RAM8.WORD\[2\].W.BYTE\[2\].B.Q_WIRE\[7\]
+ sky130_fd_sc_hd__dlxtp_1
Xfill_22_43 VGND VGND VPWR VPWR sky130_fd_sc_hd__decap_12
Xfill_22_32 VGND VGND VPWR VPWR sky130_fd_sc_hd__decap_12
Xfill_22_21 VGND VPWR sky130_fd_sc_hd__tapvpwrvgnd_1
Xfill_22_10 VGND VGND VPWR VPWR sky130_fd_sc_hd__decap_12
XSLICE_16\[0\].RAM16.SLICE\[0\].RAM8.WORD\[1\].W.BYTE\[2\].B.BIT\[2\].genblk1.STORAGE
+ DIBUF\[18\].X SLICE_16\[0\].RAM16.SLICE\[0\].RAM8.WORD\[1\].W.BYTE\[2\].B.GCLK VGND
+ VGND VPWR VPWR SLICE_16\[0\].RAM16.SLICE\[0\].RAM8.WORD\[1\].W.BYTE\[2\].B.Q_WIRE\[2\]
+ sky130_fd_sc_hd__dlxtp_1
XSLICE_16\[0\].RAM16.SLICE\[0\].RAM8.WORD\[0\].W.BYTE\[2\].B.BIT\[1\].OBUF0 SLICE_16\[0\].RAM16.SLICE\[0\].RAM8.WORD\[0\].W.BYTE\[2\].B.Q_WIRE\[1\]
+ SLICE_16\[0\].RAM16.SLICE\[0\].RAM8.WORD\[0\].W.BYTE\[2\].B.SEL0_B VGND VGND VPWR
+ VPWR SLICE_16\[0\].RAM16.BYTE\[2\].FLOATBUF0\[17\].Z sky130_fd_sc_hd__ebufn_2
XSLICE_16\[0\].RAM16.SLICE\[0\].RAM8.WORD\[7\].W.BYTE\[1\].B.BIT\[1\].genblk1.STORAGE
+ DIBUF\[9\].X SLICE_16\[0\].RAM16.SLICE\[0\].RAM8.WORD\[7\].W.BYTE\[1\].B.GCLK VGND
+ VGND VPWR VPWR SLICE_16\[0\].RAM16.SLICE\[0\].RAM8.WORD\[7\].W.BYTE\[1\].B.Q_WIRE\[1\]
+ sky130_fd_sc_hd__dlxtp_1
XSLICE_16\[0\].RAM16.SLICE\[1\].RAM8.WORD\[2\].W.BYTE\[0\].B.BIT\[7\].OBUF0 SLICE_16\[0\].RAM16.SLICE\[1\].RAM8.WORD\[2\].W.BYTE\[0\].B.Q_WIRE\[7\]
+ SLICE_16\[0\].RAM16.SLICE\[1\].RAM8.WORD\[2\].W.BYTE\[0\].B.SEL0_B VGND VGND VPWR
+ VPWR SLICE_16\[0\].RAM16.BYTE\[0\].FLOATBUF0\[7\].Z sky130_fd_sc_hd__ebufn_2
Xfill_22_98 VGND VGND VPWR VPWR sky130_fd_sc_hd__decap_12
Xfill_22_87 VGND VPWR sky130_fd_sc_hd__tapvpwrvgnd_1
Xfill_22_76 VGND VGND VPWR VPWR sky130_fd_sc_hd__decap_12
Xfill_22_65 VGND VGND VPWR VPWR sky130_fd_sc_hd__decap_12
Xfill_22_54 VGND VPWR sky130_fd_sc_hd__tapvpwrvgnd_1
Xfill_47_62 VGND VGND VPWR VPWR sky130_fd_sc_hd__decap_12
Xfill_47_51 VGND VPWR sky130_fd_sc_hd__tapvpwrvgnd_1
Xfill_47_40 VGND VGND VPWR VPWR sky130_fd_sc_hd__decap_12
XSLICE_16\[1\].RAM16.Do0_REG.OUTREG_BYTE\[2\].Do_FF\[3\] SLICE_16\[1\].RAM16.Do0_REG.CLKBUF\[2\]
+ SLICE_16\[1\].RAM16.BYTE\[2\].FLOATBUF0\[19\].Z VGND VGND VPWR VPWR Do0MUX.A1\[19\]
+ sky130_fd_sc_hd__dfxtp_1
XSLICE_16\[1\].RAM16.SLICE\[1\].RAM8.WORD\[3\].W.BYTE\[2\].B.BIT\[6\].OBUF0 SLICE_16\[1\].RAM16.SLICE\[1\].RAM8.WORD\[3\].W.BYTE\[2\].B.Q_WIRE\[6\]
+ SLICE_16\[1\].RAM16.SLICE\[1\].RAM8.WORD\[3\].W.BYTE\[2\].B.SEL0_B VGND VGND VPWR
+ VPWR SLICE_16\[1\].RAM16.BYTE\[2\].FLOATBUF0\[22\].Z sky130_fd_sc_hd__ebufn_2
XSLICE_16\[0\].RAM16.TIE0\[3\].__cell__ VGND VGND VPWR VPWR SLICE_16\[0\].RAM16.TIE0\[3\].__cell__/HI
+ SLICE_16\[0\].RAM16.BYTE\[3\].FLOATBUF0\[24\].A sky130_fd_sc_hd__conb_1
Xtap_1_28 VGND VPWR sky130_fd_sc_hd__tapvpwrvgnd_1
Xtap_1_17 VGND VPWR sky130_fd_sc_hd__tapvpwrvgnd_1
XSLICE_16\[1\].RAM16.SLICE\[1\].RAM8.WORD\[7\].W.BYTE\[3\].B.DIODE_CLK SLICE_16\[1\].RAM16.SLICE\[1\].RAM8.WORD\[7\].W.BYTE\[0\].B.CLK
+ VGND VGND VPWR VPWR sky130_fd_sc_hd__diode_2
XSLICE_16\[1\].RAM16.SLICE\[1\].RAM8.WORD\[6\].W.BYTE\[3\].B.BIT\[0\].genblk1.STORAGE
+ DIBUF\[24\].X SLICE_16\[1\].RAM16.SLICE\[1\].RAM8.WORD\[6\].W.BYTE\[3\].B.GCLK VGND
+ VGND VPWR VPWR SLICE_16\[1\].RAM16.SLICE\[1\].RAM8.WORD\[6\].W.BYTE\[3\].B.Q_WIRE\[0\]
+ sky130_fd_sc_hd__dlxtp_1
XSLICE_16\[0\].RAM16.SLICE\[1\].RAM8.WORD\[5\].W.BYTE\[1\].B.BIT\[7\].OBUF0 SLICE_16\[0\].RAM16.SLICE\[1\].RAM8.WORD\[5\].W.BYTE\[1\].B.Q_WIRE\[7\]
+ SLICE_16\[0\].RAM16.SLICE\[1\].RAM8.WORD\[5\].W.BYTE\[1\].B.SEL0_B VGND VGND VPWR
+ VPWR SLICE_16\[0\].RAM16.BYTE\[1\].FLOATBUF0\[15\].Z sky130_fd_sc_hd__ebufn_2
XSLICE_16\[0\].RAM16.SLICE\[0\].RAM8.WORD\[3\].W.BYTE\[3\].B.BIT\[1\].OBUF0 SLICE_16\[0\].RAM16.SLICE\[0\].RAM8.WORD\[3\].W.BYTE\[3\].B.Q_WIRE\[1\]
+ SLICE_16\[0\].RAM16.SLICE\[0\].RAM8.WORD\[3\].W.BYTE\[3\].B.SEL0_B VGND VGND VPWR
+ VPWR SLICE_16\[0\].RAM16.BYTE\[3\].FLOATBUF0\[25\].Z sky130_fd_sc_hd__ebufn_2
Xtap_39_4 VGND VPWR sky130_fd_sc_hd__tapvpwrvgnd_1
Xtap_29_33 VGND VPWR sky130_fd_sc_hd__tapvpwrvgnd_1
Xtap_29_22 VGND VPWR sky130_fd_sc_hd__tapvpwrvgnd_1
Xtap_29_11 VGND VPWR sky130_fd_sc_hd__tapvpwrvgnd_1
XSLICE_16\[0\].RAM16.SLICE\[0\].RAM8.WORD\[0\].W.BYTE\[0\].B.BIT\[6\].OBUF0 SLICE_16\[0\].RAM16.SLICE\[0\].RAM8.WORD\[0\].W.BYTE\[0\].B.Q_WIRE\[6\]
+ SLICE_16\[0\].RAM16.SLICE\[0\].RAM8.WORD\[0\].W.BYTE\[0\].B.SEL0_B VGND VGND VPWR
+ VPWR SLICE_16\[0\].RAM16.BYTE\[0\].FLOATBUF0\[6\].Z sky130_fd_sc_hd__ebufn_2
XSLICE_16\[1\].RAM16.SLICE\[1\].RAM8.WORD\[2\].W.BYTE\[0\].B.BIT\[3\].OBUF0 SLICE_16\[1\].RAM16.SLICE\[1\].RAM8.WORD\[2\].W.BYTE\[0\].B.Q_WIRE\[3\]
+ SLICE_16\[1\].RAM16.SLICE\[1\].RAM8.WORD\[2\].W.BYTE\[0\].B.SEL0_B VGND VGND VPWR
+ VPWR SLICE_16\[1\].RAM16.BYTE\[0\].FLOATBUF0\[3\].Z sky130_fd_sc_hd__ebufn_2
XSLICE_16\[1\].RAM16.SLICE\[0\].RAM8.WORD\[3\].W.BYTE\[3\].B.BIT\[6\].genblk1.STORAGE
+ DIBUF\[30\].X SLICE_16\[1\].RAM16.SLICE\[0\].RAM8.WORD\[3\].W.BYTE\[3\].B.GCLK VGND
+ VGND VPWR VPWR SLICE_16\[1\].RAM16.SLICE\[0\].RAM8.WORD\[3\].W.BYTE\[3\].B.Q_WIRE\[6\]
+ sky130_fd_sc_hd__dlxtp_1
Xfill_17_65 VGND VGND VPWR VPWR sky130_fd_sc_hd__fill_2
Xfill_17_54 VGND VPWR sky130_fd_sc_hd__tapvpwrvgnd_1
Xfill_17_43 VGND VGND VPWR VPWR sky130_fd_sc_hd__decap_12
Xfill_17_32 VGND VGND VPWR VPWR sky130_fd_sc_hd__decap_12
Xfill_17_21 VGND VPWR sky130_fd_sc_hd__tapvpwrvgnd_1
Xfill_17_10 VGND VGND VPWR VPWR sky130_fd_sc_hd__decap_12
XSLICE_16\[1\].RAM16.SLICE\[1\].RAM8.WORD\[6\].W.BYTE\[3\].B.BIT\[6\].OBUF0 SLICE_16\[1\].RAM16.SLICE\[1\].RAM8.WORD\[6\].W.BYTE\[3\].B.Q_WIRE\[6\]
+ SLICE_16\[1\].RAM16.SLICE\[1\].RAM8.WORD\[6\].W.BYTE\[3\].B.SEL0_B VGND VGND VPWR
+ VPWR SLICE_16\[1\].RAM16.BYTE\[3\].FLOATBUF0\[30\].Z sky130_fd_sc_hd__ebufn_2
XSLICE_16\[1\].RAM16.SLICE\[0\].RAM8.WORD\[7\].W.BYTE\[0\].B.BIT\[4\].genblk1.STORAGE
+ DIBUF\[4\].X SLICE_16\[1\].RAM16.SLICE\[0\].RAM8.WORD\[7\].W.BYTE\[0\].B.GCLK VGND
+ VGND VPWR VPWR SLICE_16\[1\].RAM16.SLICE\[0\].RAM8.WORD\[7\].W.BYTE\[0\].B.Q_WIRE\[4\]
+ sky130_fd_sc_hd__dlxtp_1
XSLICE_16\[1\].RAM16.SLICE\[0\].RAM8.WORD\[1\].W.BYTE\[1\].B.BIT\[5\].genblk1.STORAGE
+ DIBUF\[13\].X SLICE_16\[1\].RAM16.SLICE\[0\].RAM8.WORD\[1\].W.BYTE\[1\].B.GCLK VGND
+ VGND VPWR VPWR SLICE_16\[1\].RAM16.SLICE\[0\].RAM8.WORD\[1\].W.BYTE\[1\].B.Q_WIRE\[5\]
+ sky130_fd_sc_hd__dlxtp_1
XSLICE_16\[0\].RAM16.SLICE\[1\].RAM8.WORD\[5\].W.BYTE\[3\].B.BIT\[7\].genblk1.STORAGE
+ DIBUF\[31\].X SLICE_16\[0\].RAM16.SLICE\[1\].RAM8.WORD\[5\].W.BYTE\[3\].B.GCLK VGND
+ VGND VPWR VPWR SLICE_16\[0\].RAM16.SLICE\[1\].RAM8.WORD\[5\].W.BYTE\[3\].B.Q_WIRE\[7\]
+ sky130_fd_sc_hd__dlxtp_1
XSLICE_16\[0\].RAM16.SLICE\[1\].RAM8.WORD\[3\].W.BYTE\[1\].B.BIT\[6\].genblk1.STORAGE
+ DIBUF\[14\].X SLICE_16\[0\].RAM16.SLICE\[1\].RAM8.WORD\[3\].W.BYTE\[1\].B.GCLK VGND
+ VGND VPWR VPWR SLICE_16\[0\].RAM16.SLICE\[1\].RAM8.WORD\[3\].W.BYTE\[1\].B.Q_WIRE\[6\]
+ sky130_fd_sc_hd__dlxtp_1
XSLICE_16\[1\].RAM16.DIODE_A0\[4\].__cell__ zero_ VGND VGND VPWR VPWR sky130_fd_sc_hd__diode_2
XSLICE_16\[1\].RAM16.SLICE\[0\].RAM8.WORD\[1\].W.BYTE\[2\].B.BIT\[5\].OBUF0 SLICE_16\[1\].RAM16.SLICE\[0\].RAM8.WORD\[1\].W.BYTE\[2\].B.Q_WIRE\[5\]
+ SLICE_16\[1\].RAM16.SLICE\[0\].RAM8.WORD\[1\].W.BYTE\[2\].B.SEL0_B VGND VGND VPWR
+ VPWR SLICE_16\[1\].RAM16.BYTE\[2\].FLOATBUF0\[21\].Z sky130_fd_sc_hd__ebufn_2
XSLICE_16\[0\].RAM16.SLICE\[0\].RAM8.WORD\[4\].W.BYTE\[3\].B.BIT\[2\].genblk1.STORAGE
+ DIBUF\[26\].X SLICE_16\[0\].RAM16.SLICE\[0\].RAM8.WORD\[4\].W.BYTE\[3\].B.GCLK VGND
+ VGND VPWR VPWR SLICE_16\[0\].RAM16.SLICE\[0\].RAM8.WORD\[4\].W.BYTE\[3\].B.Q_WIRE\[2\]
+ sky130_fd_sc_hd__dlxtp_1
Xfill_8_6 VGND VPWR sky130_fd_sc_hd__tapvpwrvgnd_1
Xfill_44_100 VGND VGND VPWR VPWR sky130_fd_sc_hd__decap_12
XSLICE_16\[0\].RAM16.SLICE\[0\].RAM8.WORD\[2\].W.BYTE\[1\].B.BIT\[1\].genblk1.STORAGE
+ DIBUF\[9\].X SLICE_16\[0\].RAM16.SLICE\[0\].RAM8.WORD\[2\].W.BYTE\[1\].B.GCLK VGND
+ VGND VPWR VPWR SLICE_16\[0\].RAM16.SLICE\[0\].RAM8.WORD\[2\].W.BYTE\[1\].B.Q_WIRE\[1\]
+ sky130_fd_sc_hd__dlxtp_1
XSLICE_16\[0\].RAM16.SLICE\[0\].RAM8.WORD\[6\].W.BYTE\[3\].B.genblk1.CG SLICE_16\[0\].RAM16.SLICE\[0\].RAM8.WORD\[6\].W.BYTE\[3\].B.CLK_B
+ SLICE_16\[0\].RAM16.SLICE\[0\].RAM8.WORD\[6\].W.BYTE\[3\].B.WE0_WIRE VGND VGND VPWR
+ VPWR SLICE_16\[0\].RAM16.SLICE\[0\].RAM8.WORD\[6\].W.BYTE\[3\].B.GCLK sky130_fd_sc_hd__dlclkp_1
Xfill_10_4 VGND VGND VPWR VPWR sky130_fd_sc_hd__fill_2
XSLICE_16\[0\].RAM16.Do0_REG.OUTREG_BYTE\[1\].DIODE\[3\] SLICE_16\[0\].RAM16.BYTE\[1\].FLOATBUF0\[11\].Z
+ VGND VGND VPWR VPWR sky130_fd_sc_hd__diode_2
XSLICE_16\[0\].RAM16.SLICE\[0\].RAM8.WORD\[3\].W.BYTE\[1\].B.BIT\[6\].OBUF0 SLICE_16\[0\].RAM16.SLICE\[0\].RAM8.WORD\[3\].W.BYTE\[1\].B.Q_WIRE\[6\]
+ SLICE_16\[0\].RAM16.SLICE\[0\].RAM8.WORD\[3\].W.BYTE\[1\].B.SEL0_B VGND VGND VPWR
+ VPWR SLICE_16\[0\].RAM16.BYTE\[1\].FLOATBUF0\[14\].Z sky130_fd_sc_hd__ebufn_2
Xtap_18_9 VGND VPWR sky130_fd_sc_hd__tapvpwrvgnd_1
XSLICE_16\[1\].RAM16.SLICE\[1\].RAM8.WORD\[5\].W.BYTE\[1\].B.BIT\[3\].OBUF0 SLICE_16\[1\].RAM16.SLICE\[1\].RAM8.WORD\[5\].W.BYTE\[1\].B.Q_WIRE\[3\]
+ SLICE_16\[1\].RAM16.SLICE\[1\].RAM8.WORD\[5\].W.BYTE\[1\].B.SEL0_B VGND VGND VPWR
+ VPWR SLICE_16\[1\].RAM16.BYTE\[1\].FLOATBUF0\[11\].Z sky130_fd_sc_hd__ebufn_2
XSLICE_16\[1\].RAM16.SLICE\[1\].RAM8.WORD\[0\].W.BYTE\[3\].B.genblk1.CLKINV SLICE_16\[1\].RAM16.SLICE\[1\].RAM8.WORD\[0\].W.BYTE\[0\].B.CLK
+ VGND VGND VPWR VPWR SLICE_16\[1\].RAM16.SLICE\[1\].RAM8.WORD\[0\].W.BYTE\[3\].B.CLK_B
+ sky130_fd_sc_hd__inv_1
Xtap_15_35 VGND VPWR sky130_fd_sc_hd__tapvpwrvgnd_1
Xtap_15_24 VGND VPWR sky130_fd_sc_hd__tapvpwrvgnd_1
Xtap_15_13 VGND VPWR sky130_fd_sc_hd__tapvpwrvgnd_1
Xtap_31_34 VGND VPWR sky130_fd_sc_hd__tapvpwrvgnd_1
Xtap_31_23 VGND VPWR sky130_fd_sc_hd__tapvpwrvgnd_1
Xtap_31_12 VGND VPWR sky130_fd_sc_hd__tapvpwrvgnd_1
XDo0MUX.M\[0\].DIODE_A1MUX\[6\] Do0MUX.A1\[6\] VGND VGND VPWR VPWR sky130_fd_sc_hd__diode_2
Xtap_37_1 VGND VPWR sky130_fd_sc_hd__tapvpwrvgnd_1
XSLICE_16\[1\].RAM16.SLICE\[0\].RAM8.WORD\[0\].W.BYTE\[0\].B.BIT\[2\].OBUF0 SLICE_16\[1\].RAM16.SLICE\[0\].RAM8.WORD\[0\].W.BYTE\[0\].B.Q_WIRE\[2\]
+ SLICE_16\[1\].RAM16.SLICE\[0\].RAM8.WORD\[0\].W.BYTE\[0\].B.SEL0_B VGND VGND VPWR
+ VPWR SLICE_16\[1\].RAM16.BYTE\[0\].FLOATBUF0\[2\].Z sky130_fd_sc_hd__ebufn_2
XSLICE_16\[0\].RAM16.SLICE\[1\].RAM8.WORD\[7\].W.BYTE\[0\].B.BIT\[4\].OBUF0 SLICE_16\[0\].RAM16.SLICE\[1\].RAM8.WORD\[7\].W.BYTE\[0\].B.Q_WIRE\[4\]
+ SLICE_16\[0\].RAM16.SLICE\[1\].RAM8.WORD\[7\].W.BYTE\[0\].B.SEL0_B VGND VGND VPWR
+ VPWR SLICE_16\[0\].RAM16.BYTE\[0\].FLOATBUF0\[4\].Z sky130_fd_sc_hd__ebufn_2
XSLICE_16\[1\].RAM16.SLICE\[1\].RAM8.WORD\[1\].W.BYTE\[3\].B.BIT\[0\].genblk1.STORAGE
+ DIBUF\[24\].X SLICE_16\[1\].RAM16.SLICE\[1\].RAM8.WORD\[1\].W.BYTE\[3\].B.GCLK VGND
+ VGND VPWR VPWR SLICE_16\[1\].RAM16.SLICE\[1\].RAM8.WORD\[1\].W.BYTE\[3\].B.Q_WIRE\[0\]
+ sky130_fd_sc_hd__dlxtp_1
XSLICE_16\[1\].RAM16.SLICE\[0\].RAM8.WORD\[4\].W.BYTE\[3\].B.BIT\[5\].OBUF0 SLICE_16\[1\].RAM16.SLICE\[0\].RAM8.WORD\[4\].W.BYTE\[3\].B.Q_WIRE\[5\]
+ SLICE_16\[1\].RAM16.SLICE\[0\].RAM8.WORD\[4\].W.BYTE\[3\].B.SEL0_B VGND VGND VPWR
+ VPWR SLICE_16\[1\].RAM16.BYTE\[3\].FLOATBUF0\[29\].Z sky130_fd_sc_hd__ebufn_2
XSLICE_16\[1\].RAM16.SLICE\[0\].RAM8.WORD\[3\].W.BYTE\[2\].B.genblk1.CG SLICE_16\[1\].RAM16.SLICE\[0\].RAM8.WORD\[3\].W.BYTE\[2\].B.CLK_B
+ SLICE_16\[1\].RAM16.SLICE\[0\].RAM8.WORD\[3\].W.BYTE\[2\].B.WE0_WIRE VGND VGND VPWR
+ VPWR SLICE_16\[1\].RAM16.SLICE\[0\].RAM8.WORD\[3\].W.BYTE\[2\].B.GCLK sky130_fd_sc_hd__dlclkp_1
Xfill_44_96 VGND VPWR sky130_fd_sc_hd__tapvpwrvgnd_1
Xfill_44_85 VGND VGND VPWR VPWR sky130_fd_sc_hd__decap_12
Xfill_44_74 VGND VGND VPWR VPWR sky130_fd_sc_hd__decap_12
Xfill_44_63 VGND VPWR sky130_fd_sc_hd__tapvpwrvgnd_1
Xfill_44_52 VGND VGND VPWR VPWR sky130_fd_sc_hd__decap_12
Xfill_44_41 VGND VGND VPWR VPWR sky130_fd_sc_hd__decap_12
Xfill_44_30 VGND VPWR sky130_fd_sc_hd__tapvpwrvgnd_1
Xfill_41_103 VGND VPWR sky130_fd_sc_hd__tapvpwrvgnd_1
XSLICE_16\[1\].RAM16.SLICE\[1\].RAM8.WORD\[4\].W.BYTE\[3\].B.CGAND SLICE_16\[1\].RAM16.SLICE\[1\].RAM8.WORD\[4\].W.BYTE\[0\].B.SEL0
+ SLICE_16\[1\].RAM16.SLICE\[1\].RAM8.WE0_buf\[3\] VGND VGND VPWR VPWR SLICE_16\[1\].RAM16.SLICE\[1\].RAM8.WORD\[4\].W.BYTE\[3\].B.WE0_WIRE
+ sky130_fd_sc_hd__and2_1
XSLICE_16\[0\].RAM16.SLICE\[0\].RAM8.WORD\[6\].W.BYTE\[2\].B.BIT\[6\].OBUF0 SLICE_16\[0\].RAM16.SLICE\[0\].RAM8.WORD\[6\].W.BYTE\[2\].B.Q_WIRE\[6\]
+ SLICE_16\[0\].RAM16.SLICE\[0\].RAM8.WORD\[6\].W.BYTE\[2\].B.SEL0_B VGND VGND VPWR
+ VPWR SLICE_16\[0\].RAM16.BYTE\[2\].FLOATBUF0\[22\].Z sky130_fd_sc_hd__ebufn_2
XSLICE_16\[1\].RAM16.SLICE\[0\].RAM8.WORD\[4\].W.BYTE\[2\].B.BIT\[5\].genblk1.STORAGE
+ DIBUF\[21\].X SLICE_16\[1\].RAM16.SLICE\[0\].RAM8.WORD\[4\].W.BYTE\[2\].B.GCLK VGND
+ VGND VPWR VPWR SLICE_16\[1\].RAM16.SLICE\[0\].RAM8.WORD\[4\].W.BYTE\[2\].B.Q_WIRE\[5\]
+ sky130_fd_sc_hd__dlxtp_1
Xfill_6_3 VGND VPWR sky130_fd_sc_hd__tapvpwrvgnd_1
XSLICE_16\[1\].RAM16.SLICE\[0\].RAM8.WORD\[2\].W.BYTE\[0\].B.BIT\[4\].genblk1.STORAGE
+ DIBUF\[4\].X SLICE_16\[1\].RAM16.SLICE\[0\].RAM8.WORD\[2\].W.BYTE\[0\].B.GCLK VGND
+ VGND VPWR VPWR SLICE_16\[1\].RAM16.SLICE\[0\].RAM8.WORD\[2\].W.BYTE\[0\].B.Q_WIRE\[4\]
+ sky130_fd_sc_hd__dlxtp_1
XSLICE_16\[0\].RAM16.Do0_REG.OUTREG_BYTE\[0\].Do_FF\[4\] SLICE_16\[0\].RAM16.Do0_REG.CLKBUF\[0\]
+ SLICE_16\[0\].RAM16.BYTE\[0\].FLOATBUF0\[4\].Z VGND VGND VPWR VPWR Do0MUX.A0\[4\]
+ sky130_fd_sc_hd__dfxtp_1
XSLICE_16\[0\].RAM16.SLICE\[1\].RAM8.WORD\[6\].W.BYTE\[2\].B.BIT\[6\].genblk1.STORAGE
+ DIBUF\[22\].X SLICE_16\[0\].RAM16.SLICE\[1\].RAM8.WORD\[6\].W.BYTE\[2\].B.GCLK VGND
+ VGND VPWR VPWR SLICE_16\[0\].RAM16.SLICE\[1\].RAM8.WORD\[6\].W.BYTE\[2\].B.Q_WIRE\[6\]
+ sky130_fd_sc_hd__dlxtp_1
Xtap_7_16 VGND VPWR sky130_fd_sc_hd__tapvpwrvgnd_1
Xtap_7_27 VGND VPWR sky130_fd_sc_hd__tapvpwrvgnd_1
XSLICE_16\[0\].RAM16.SLICE\[1\].RAM8.WORD\[0\].W.BYTE\[3\].B.BIT\[7\].genblk1.STORAGE
+ DIBUF\[31\].X SLICE_16\[0\].RAM16.SLICE\[1\].RAM8.WORD\[0\].W.BYTE\[3\].B.GCLK VGND
+ VGND VPWR VPWR SLICE_16\[0\].RAM16.SLICE\[1\].RAM8.WORD\[0\].W.BYTE\[3\].B.Q_WIRE\[7\]
+ sky130_fd_sc_hd__dlxtp_1
Xtap_30_8 VGND VPWR sky130_fd_sc_hd__tapvpwrvgnd_1
XSLICE_16\[1\].RAM16.SLICE\[0\].RAM8.WORD\[3\].W.BYTE\[1\].B.BIT\[2\].OBUF0 SLICE_16\[1\].RAM16.SLICE\[0\].RAM8.WORD\[3\].W.BYTE\[1\].B.Q_WIRE\[2\]
+ SLICE_16\[1\].RAM16.SLICE\[0\].RAM8.WORD\[3\].W.BYTE\[1\].B.SEL0_B VGND VGND VPWR
+ VPWR SLICE_16\[1\].RAM16.BYTE\[1\].FLOATBUF0\[10\].Z sky130_fd_sc_hd__ebufn_2
Xtap_23_7 VGND VPWR sky130_fd_sc_hd__tapvpwrvgnd_1
XSLICE_16\[0\].RAM16.SLICE\[1\].RAM8.WORD\[4\].W.BYTE\[0\].B.BIT\[5\].genblk1.STORAGE
+ DIBUF\[5\].X SLICE_16\[0\].RAM16.SLICE\[1\].RAM8.WORD\[4\].W.BYTE\[0\].B.GCLK VGND
+ VGND VPWR VPWR SLICE_16\[0\].RAM16.SLICE\[1\].RAM8.WORD\[4\].W.BYTE\[0\].B.Q_WIRE\[5\]
+ sky130_fd_sc_hd__dlxtp_1
XSLICE_16\[0\].RAM16.SLICE\[0\].RAM8.WORD\[5\].W.BYTE\[2\].B.BIT\[1\].genblk1.STORAGE
+ DIBUF\[17\].X SLICE_16\[0\].RAM16.SLICE\[0\].RAM8.WORD\[5\].W.BYTE\[2\].B.GCLK VGND
+ VGND VPWR VPWR SLICE_16\[0\].RAM16.SLICE\[0\].RAM8.WORD\[5\].W.BYTE\[2\].B.Q_WIRE\[1\]
+ sky130_fd_sc_hd__dlxtp_1
XSLICE_16\[0\].RAM16.SLICE\[1\].RAM8.WORD\[0\].W.BYTE\[3\].B.BIT\[1\].OBUF0 SLICE_16\[0\].RAM16.SLICE\[1\].RAM8.WORD\[0\].W.BYTE\[3\].B.Q_WIRE\[1\]
+ SLICE_16\[0\].RAM16.SLICE\[1\].RAM8.WORD\[0\].W.BYTE\[3\].B.SEL0_B VGND VGND VPWR
+ VPWR SLICE_16\[0\].RAM16.BYTE\[3\].FLOATBUF0\[25\].Z sky130_fd_sc_hd__ebufn_2
Xtap_26_34 VGND VPWR sky130_fd_sc_hd__tapvpwrvgnd_1
Xtap_26_23 VGND VPWR sky130_fd_sc_hd__tapvpwrvgnd_1
Xtap_26_12 VGND VPWR sky130_fd_sc_hd__tapvpwrvgnd_1
Xtap_16_6 VGND VPWR sky130_fd_sc_hd__tapvpwrvgnd_1
XSLICE_16\[0\].RAM16.SLICE\[0\].RAM8.WORD\[3\].W.BYTE\[0\].B.BIT\[0\].genblk1.STORAGE
+ DIBUF\[0\].X SLICE_16\[0\].RAM16.SLICE\[0\].RAM8.WORD\[3\].W.BYTE\[0\].B.GCLK VGND
+ VGND VPWR VPWR SLICE_16\[0\].RAM16.SLICE\[0\].RAM8.WORD\[3\].W.BYTE\[0\].B.Q_WIRE\[0\]
+ sky130_fd_sc_hd__dlxtp_1
Xtap_9_5 VGND VPWR sky130_fd_sc_hd__tapvpwrvgnd_1
XSLICE_16\[0\].RAM16.SLICE\[0\].RAM8.WORD\[5\].W.BYTE\[0\].B.BIT\[3\].OBUF0 SLICE_16\[0\].RAM16.SLICE\[0\].RAM8.WORD\[5\].W.BYTE\[0\].B.Q_WIRE\[3\]
+ SLICE_16\[0\].RAM16.SLICE\[0\].RAM8.WORD\[5\].W.BYTE\[0\].B.SEL0_B VGND VGND VPWR
+ VPWR SLICE_16\[0\].RAM16.BYTE\[0\].FLOATBUF0\[3\].Z sky130_fd_sc_hd__ebufn_2
XSLICE_16\[1\].RAM16.SLICE\[1\].RAM8.WORD\[7\].W.BYTE\[0\].B.BIT\[0\].OBUF0 SLICE_16\[1\].RAM16.SLICE\[1\].RAM8.WORD\[7\].W.BYTE\[0\].B.Q_WIRE\[0\]
+ SLICE_16\[1\].RAM16.SLICE\[1\].RAM8.WORD\[7\].W.BYTE\[0\].B.SEL0_B VGND VGND VPWR
+ VPWR SLICE_16\[1\].RAM16.BYTE\[0\].FLOATBUF0\[0\].Z sky130_fd_sc_hd__ebufn_2
XSLICE_16\[0\].RAM16.SLICE\[0\].RAM8.WORD\[0\].W.BYTE\[2\].B.genblk1.CLKINV SLICE_16\[0\].RAM16.SLICE\[0\].RAM8.WORD\[0\].W.BYTE\[0\].B.CLK
+ VGND VGND VPWR VPWR SLICE_16\[0\].RAM16.SLICE\[0\].RAM8.WORD\[0\].W.BYTE\[2\].B.CLK_B
+ sky130_fd_sc_hd__inv_1
Xfill_39_63 VGND VGND VPWR VPWR sky130_fd_sc_hd__decap_8
Xfill_39_52 VGND VGND VPWR VPWR sky130_fd_sc_hd__decap_12
Xfill_39_41 VGND VGND VPWR VPWR sky130_fd_sc_hd__decap_12
Xfill_39_30 VGND VPWR sky130_fd_sc_hd__tapvpwrvgnd_1
XSLICE_16\[1\].RAM16.SLICE\[0\].RAM8.WORD\[6\].W.BYTE\[2\].B.BIT\[2\].OBUF0 SLICE_16\[1\].RAM16.SLICE\[0\].RAM8.WORD\[6\].W.BYTE\[2\].B.Q_WIRE\[2\]
+ SLICE_16\[1\].RAM16.SLICE\[0\].RAM8.WORD\[6\].W.BYTE\[2\].B.SEL0_B VGND VGND VPWR
+ VPWR SLICE_16\[1\].RAM16.BYTE\[2\].FLOATBUF0\[18\].Z sky130_fd_sc_hd__ebufn_2
Xtap_12_25 VGND VPWR sky130_fd_sc_hd__tapvpwrvgnd_1
Xtap_12_14 VGND VPWR sky130_fd_sc_hd__tapvpwrvgnd_1
Xfill_4_0 VGND VPWR sky130_fd_sc_hd__tapvpwrvgnd_1
XSLICE_16\[0\].RAM16.SLICE\[1\].RAM8.WORD\[0\].W.BYTE\[1\].B.BIT\[6\].OBUF0 SLICE_16\[0\].RAM16.SLICE\[1\].RAM8.WORD\[0\].W.BYTE\[1\].B.Q_WIRE\[6\]
+ SLICE_16\[0\].RAM16.SLICE\[1\].RAM8.WORD\[0\].W.BYTE\[1\].B.SEL0_B VGND VGND VPWR
+ VPWR SLICE_16\[0\].RAM16.BYTE\[1\].FLOATBUF0\[14\].Z sky130_fd_sc_hd__ebufn_2
XSLICE_16\[0\].RAM16.SLICE\[0\].RAM8.WORD\[3\].W.BYTE\[3\].B.genblk1.CLKINV SLICE_16\[0\].RAM16.SLICE\[0\].RAM8.WORD\[3\].W.BYTE\[0\].B.CLK
+ VGND VGND VPWR VPWR SLICE_16\[0\].RAM16.SLICE\[0\].RAM8.WORD\[3\].W.BYTE\[3\].B.CLK_B
+ sky130_fd_sc_hd__inv_1
Xtap_37_33 VGND VPWR sky130_fd_sc_hd__tapvpwrvgnd_1
Xtap_37_22 VGND VPWR sky130_fd_sc_hd__tapvpwrvgnd_1
Xtap_37_11 VGND VPWR sky130_fd_sc_hd__tapvpwrvgnd_1
XSLICE_16\[1\].RAM16.SLICE\[0\].RAM8.WORD\[7\].W.BYTE\[3\].B.BIT\[5\].genblk1.STORAGE
+ DIBUF\[29\].X SLICE_16\[1\].RAM16.SLICE\[0\].RAM8.WORD\[7\].W.BYTE\[3\].B.GCLK VGND
+ VGND VPWR VPWR SLICE_16\[1\].RAM16.SLICE\[0\].RAM8.WORD\[7\].W.BYTE\[3\].B.Q_WIRE\[5\]
+ sky130_fd_sc_hd__dlxtp_1
Xtap_14_3 VGND VPWR sky130_fd_sc_hd__tapvpwrvgnd_1
XSLICE_16\[1\].RAM16.SLICE\[0\].RAM8.WORD\[5\].W.BYTE\[1\].B.BIT\[4\].genblk1.STORAGE
+ DIBUF\[12\].X SLICE_16\[1\].RAM16.SLICE\[0\].RAM8.WORD\[5\].W.BYTE\[1\].B.GCLK VGND
+ VGND VPWR VPWR SLICE_16\[1\].RAM16.SLICE\[0\].RAM8.WORD\[5\].W.BYTE\[1\].B.Q_WIRE\[4\]
+ sky130_fd_sc_hd__dlxtp_1
Xtap_7_2 VGND VPWR sky130_fd_sc_hd__tapvpwrvgnd_1
Xfill_41_42 VGND VPWR sky130_fd_sc_hd__tapvpwrvgnd_1
Xfill_41_31 VGND VGND VPWR VPWR sky130_fd_sc_hd__decap_12
Xfill_41_20 VGND VGND VPWR VPWR sky130_fd_sc_hd__decap_12
XSLICE_16\[1\].RAM16.SLICE\[1\].RAM8.WORD\[1\].W.BYTE\[3\].B.BIT\[5\].OBUF0 SLICE_16\[1\].RAM16.SLICE\[1\].RAM8.WORD\[1\].W.BYTE\[3\].B.Q_WIRE\[5\]
+ SLICE_16\[1\].RAM16.SLICE\[1\].RAM8.WORD\[1\].W.BYTE\[3\].B.SEL0_B VGND VGND VPWR
+ VPWR SLICE_16\[1\].RAM16.BYTE\[3\].FLOATBUF0\[29\].Z sky130_fd_sc_hd__ebufn_2
XSLICE_16\[0\].RAM16.SLICE\[1\].RAM8.WORD\[7\].W.BYTE\[1\].B.BIT\[5\].genblk1.STORAGE
+ DIBUF\[13\].X SLICE_16\[0\].RAM16.SLICE\[1\].RAM8.WORD\[7\].W.BYTE\[1\].B.GCLK VGND
+ VGND VPWR VPWR SLICE_16\[0\].RAM16.SLICE\[1\].RAM8.WORD\[7\].W.BYTE\[1\].B.Q_WIRE\[5\]
+ sky130_fd_sc_hd__dlxtp_1
XSLICE_16\[0\].RAM16.SLICE\[1\].RAM8.WORD\[1\].W.BYTE\[2\].B.BIT\[6\].genblk1.STORAGE
+ DIBUF\[22\].X SLICE_16\[0\].RAM16.SLICE\[1\].RAM8.WORD\[1\].W.BYTE\[2\].B.GCLK VGND
+ VGND VPWR VPWR SLICE_16\[0\].RAM16.SLICE\[1\].RAM8.WORD\[1\].W.BYTE\[2\].B.Q_WIRE\[6\]
+ sky130_fd_sc_hd__dlxtp_1
Xfill_41_97 VGND VGND VPWR VPWR sky130_fd_sc_hd__decap_12
Xfill_41_86 VGND VGND VPWR VPWR sky130_fd_sc_hd__decap_12
Xfill_41_75 VGND VPWR sky130_fd_sc_hd__tapvpwrvgnd_1
Xfill_41_64 VGND VGND VPWR VPWR sky130_fd_sc_hd__decap_12
Xfill_41_53 VGND VGND VPWR VPWR sky130_fd_sc_hd__decap_12
XSLICE_16\[0\].RAM16.SLICE\[0\].RAM8.WORD\[0\].W.BYTE\[2\].B.BIT\[1\].genblk1.STORAGE
+ DIBUF\[17\].X SLICE_16\[0\].RAM16.SLICE\[0\].RAM8.WORD\[0\].W.BYTE\[2\].B.GCLK VGND
+ VGND VPWR VPWR SLICE_16\[0\].RAM16.SLICE\[0\].RAM8.WORD\[0\].W.BYTE\[2\].B.Q_WIRE\[1\]
+ sky130_fd_sc_hd__dlxtp_1
XSLICE_16\[0\].RAM16.SLICE\[0\].RAM8.WORD\[6\].W.BYTE\[1\].B.BIT\[0\].genblk1.STORAGE
+ DIBUF\[8\].X SLICE_16\[0\].RAM16.SLICE\[0\].RAM8.WORD\[6\].W.BYTE\[1\].B.GCLK VGND
+ VGND VPWR VPWR SLICE_16\[0\].RAM16.SLICE\[0\].RAM8.WORD\[6\].W.BYTE\[1\].B.Q_WIRE\[0\]
+ sky130_fd_sc_hd__dlxtp_1
Xfill_42_7 VGND VGND VPWR VPWR sky130_fd_sc_hd__decap_12
Xfill_35_6 VGND VGND VPWR VPWR sky130_fd_sc_hd__decap_6
XSLICE_16\[1\].RAM16.SLICE\[1\].RAM8.WEBUF\[2\].__cell__ SLICE_16\[1\].RAM16.SLICE\[0\].RAM8.WE0\[2\]
+ VGND VGND VPWR VPWR SLICE_16\[1\].RAM16.SLICE\[1\].RAM8.WE0_buf\[2\] sky130_fd_sc_hd__clkbuf_2
XSLICE_16\[1\].RAM16.SLICE\[0\].RAM8.WORD\[6\].W.BYTE\[0\].B.BIT\[7\].OBUF0 SLICE_16\[1\].RAM16.SLICE\[0\].RAM8.WORD\[6\].W.BYTE\[0\].B.Q_WIRE\[7\]
+ SLICE_16\[1\].RAM16.SLICE\[0\].RAM8.WORD\[6\].W.BYTE\[0\].B.SEL0_B VGND VGND VPWR
+ VPWR SLICE_16\[1\].RAM16.BYTE\[0\].FLOATBUF0\[7\].Z sky130_fd_sc_hd__ebufn_2
Xfill_28_5 VGND VPWR sky130_fd_sc_hd__tapvpwrvgnd_1
XSLICE_16\[0\].RAM16.SLICE\[1\].RAM8.WORD\[3\].W.BYTE\[2\].B.BIT\[6\].OBUF0 SLICE_16\[0\].RAM16.SLICE\[1\].RAM8.WORD\[3\].W.BYTE\[2\].B.Q_WIRE\[6\]
+ SLICE_16\[0\].RAM16.SLICE\[1\].RAM8.WORD\[3\].W.BYTE\[2\].B.SEL0_B VGND VGND VPWR
+ VPWR SLICE_16\[0\].RAM16.BYTE\[2\].FLOATBUF0\[22\].Z sky130_fd_sc_hd__ebufn_2
XSLICE_16\[1\].RAM16.SLICE\[1\].RAM8.WORD\[7\].W.CLKBUF SLICE_16\[1\].RAM16.SLICE\[1\].RAM8.CLKBUF.X
+ VGND VGND VPWR VPWR SLICE_16\[1\].RAM16.SLICE\[1\].RAM8.WORD\[7\].W.BYTE\[0\].B.CLK
+ sky130_fd_sc_hd__clkbuf_4
Xtap_4_17 VGND VPWR sky130_fd_sc_hd__tapvpwrvgnd_1
Xtap_4_28 VGND VPWR sky130_fd_sc_hd__tapvpwrvgnd_1
XSLICE_16\[1\].RAM16.SLICE\[1\].RAM8.WORD\[0\].W.BYTE\[1\].B.BIT\[2\].OBUF0 SLICE_16\[1\].RAM16.SLICE\[1\].RAM8.WORD\[0\].W.BYTE\[1\].B.Q_WIRE\[2\]
+ SLICE_16\[1\].RAM16.SLICE\[1\].RAM8.WORD\[0\].W.BYTE\[1\].B.SEL0_B VGND VGND VPWR
+ VPWR SLICE_16\[1\].RAM16.BYTE\[1\].FLOATBUF0\[10\].Z sky130_fd_sc_hd__ebufn_2
Xtap_23_13 VGND VPWR sky130_fd_sc_hd__tapvpwrvgnd_1
Xtap_0_9 VGND VPWR sky130_fd_sc_hd__tapvpwrvgnd_1
Xtap_23_35 VGND VPWR sky130_fd_sc_hd__tapvpwrvgnd_1
Xtap_23_24 VGND VPWR sky130_fd_sc_hd__tapvpwrvgnd_1
XSLICE_16\[1\].RAM16.SLICE\[1\].RAM8.WORD\[0\].W.BYTE\[2\].B.CGAND SLICE_16\[1\].RAM16.SLICE\[1\].RAM8.WORD\[0\].W.BYTE\[0\].B.SEL0
+ SLICE_16\[1\].RAM16.SLICE\[1\].RAM8.WE0_buf\[2\] VGND VGND VPWR VPWR SLICE_16\[1\].RAM16.SLICE\[1\].RAM8.WORD\[0\].W.BYTE\[2\].B.WE0_WIRE
+ sky130_fd_sc_hd__and2_1
XSLICE_16\[0\].RAM16.SLICE\[1\].RAM8.WORD\[2\].W.BYTE\[0\].B.BIT\[3\].OBUF0 SLICE_16\[0\].RAM16.SLICE\[1\].RAM8.WORD\[2\].W.BYTE\[0\].B.Q_WIRE\[3\]
+ SLICE_16\[0\].RAM16.SLICE\[1\].RAM8.WORD\[2\].W.BYTE\[0\].B.SEL0_B VGND VGND VPWR
+ VPWR SLICE_16\[0\].RAM16.BYTE\[0\].FLOATBUF0\[3\].Z sky130_fd_sc_hd__ebufn_2
XSLICE_16\[0\].RAM16.SLICE\[1\].RAM8.WORD\[6\].W.BYTE\[3\].B.BIT\[6\].OBUF0 SLICE_16\[0\].RAM16.SLICE\[1\].RAM8.WORD\[6\].W.BYTE\[3\].B.Q_WIRE\[6\]
+ SLICE_16\[0\].RAM16.SLICE\[1\].RAM8.WORD\[6\].W.BYTE\[3\].B.SEL0_B VGND VGND VPWR
+ VPWR SLICE_16\[0\].RAM16.BYTE\[3\].FLOATBUF0\[30\].Z sky130_fd_sc_hd__ebufn_2
Xtap_12_0 VGND VPWR sky130_fd_sc_hd__tapvpwrvgnd_1
XSLICE_16\[0\].RAM16.SLICE\[0\].RAM8.WORD\[2\].W.BYTE\[2\].B.genblk1.CG SLICE_16\[0\].RAM16.SLICE\[0\].RAM8.WORD\[2\].W.BYTE\[2\].B.CLK_B
+ SLICE_16\[0\].RAM16.SLICE\[0\].RAM8.WORD\[2\].W.BYTE\[2\].B.WE0_WIRE VGND VGND VPWR
+ VPWR SLICE_16\[0\].RAM16.SLICE\[0\].RAM8.WORD\[2\].W.BYTE\[2\].B.GCLK sky130_fd_sc_hd__dlclkp_1
XSLICE_16\[1\].RAM16.SLICE\[0\].RAM8.WORD\[6\].W.BYTE\[0\].B.BIT\[3\].genblk1.STORAGE
+ DIBUF\[3\].X SLICE_16\[1\].RAM16.SLICE\[0\].RAM8.WORD\[6\].W.BYTE\[0\].B.GCLK VGND
+ VGND VPWR VPWR SLICE_16\[1\].RAM16.SLICE\[0\].RAM8.WORD\[6\].W.BYTE\[0\].B.Q_WIRE\[3\]
+ sky130_fd_sc_hd__dlxtp_1
XSLICE_16\[1\].RAM16.SLICE\[0\].RAM8.WORD\[2\].W.BYTE\[3\].B.BIT\[5\].genblk1.STORAGE
+ DIBUF\[29\].X SLICE_16\[1\].RAM16.SLICE\[0\].RAM8.WORD\[2\].W.BYTE\[3\].B.GCLK VGND
+ VGND VPWR VPWR SLICE_16\[1\].RAM16.SLICE\[0\].RAM8.WORD\[2\].W.BYTE\[3\].B.Q_WIRE\[5\]
+ sky130_fd_sc_hd__dlxtp_1
XSLICE_16\[0\].RAM16.SLICE\[0\].RAM8.WORD\[1\].W.BYTE\[2\].B.BIT\[5\].OBUF0 SLICE_16\[0\].RAM16.SLICE\[0\].RAM8.WORD\[1\].W.BYTE\[2\].B.Q_WIRE\[5\]
+ SLICE_16\[0\].RAM16.SLICE\[0\].RAM8.WORD\[1\].W.BYTE\[2\].B.SEL0_B VGND VGND VPWR
+ VPWR SLICE_16\[0\].RAM16.BYTE\[2\].FLOATBUF0\[21\].Z sky130_fd_sc_hd__ebufn_2
Xfill_40_4 VGND VGND VPWR VPWR sky130_fd_sc_hd__decap_12
Xfill_33_3 VGND VGND VPWR VPWR sky130_fd_sc_hd__fill_2
XSLICE_16\[1\].RAM16.SLICE\[1\].RAM8.WORD\[3\].W.BYTE\[2\].B.BIT\[2\].OBUF0 SLICE_16\[1\].RAM16.SLICE\[1\].RAM8.WORD\[3\].W.BYTE\[2\].B.Q_WIRE\[2\]
+ SLICE_16\[1\].RAM16.SLICE\[1\].RAM8.WORD\[3\].W.BYTE\[2\].B.SEL0_B VGND VGND VPWR
+ VPWR SLICE_16\[1\].RAM16.BYTE\[2\].FLOATBUF0\[18\].Z sky130_fd_sc_hd__ebufn_2
Xfill_26_2 VGND VGND VPWR VPWR sky130_fd_sc_hd__fill_2
XSLICE_16\[1\].RAM16.SLICE\[0\].RAM8.WORD\[0\].W.BYTE\[1\].B.BIT\[4\].genblk1.STORAGE
+ DIBUF\[12\].X SLICE_16\[1\].RAM16.SLICE\[0\].RAM8.WORD\[0\].W.BYTE\[1\].B.GCLK VGND
+ VGND VPWR VPWR SLICE_16\[1\].RAM16.SLICE\[0\].RAM8.WORD\[0\].W.BYTE\[1\].B.Q_WIRE\[4\]
+ sky130_fd_sc_hd__dlxtp_1
XSLICE_16\[0\].RAM16.SLICE\[1\].RAM8.WORD\[4\].W.BYTE\[3\].B.BIT\[6\].genblk1.STORAGE
+ DIBUF\[30\].X SLICE_16\[0\].RAM16.SLICE\[1\].RAM8.WORD\[4\].W.BYTE\[3\].B.GCLK VGND
+ VGND VPWR VPWR SLICE_16\[0\].RAM16.SLICE\[1\].RAM8.WORD\[4\].W.BYTE\[3\].B.Q_WIRE\[6\]
+ sky130_fd_sc_hd__dlxtp_1
XSLICE_16\[0\].RAM16.SLICE\[1\].RAM8.WORD\[2\].W.BYTE\[1\].B.BIT\[5\].genblk1.STORAGE
+ DIBUF\[13\].X SLICE_16\[0\].RAM16.SLICE\[1\].RAM8.WORD\[2\].W.BYTE\[1\].B.GCLK VGND
+ VGND VPWR VPWR SLICE_16\[0\].RAM16.SLICE\[1\].RAM8.WORD\[2\].W.BYTE\[1\].B.Q_WIRE\[5\]
+ sky130_fd_sc_hd__dlxtp_1
Xfill_19_1 VGND VGND VPWR VPWR sky130_fd_sc_hd__decap_12
XSLICE_16\[0\].RAM16.SLICE\[0\].RAM8.WORD\[3\].W.BYTE\[3\].B.BIT\[1\].genblk1.STORAGE
+ DIBUF\[25\].X SLICE_16\[0\].RAM16.SLICE\[0\].RAM8.WORD\[3\].W.BYTE\[3\].B.GCLK VGND
+ VGND VPWR VPWR SLICE_16\[0\].RAM16.SLICE\[0\].RAM8.WORD\[3\].W.BYTE\[3\].B.Q_WIRE\[1\]
+ sky130_fd_sc_hd__dlxtp_1
XSLICE_16\[0\].RAM16.SLICE\[1\].RAM8.WORD\[5\].W.BYTE\[1\].B.BIT\[3\].OBUF0 SLICE_16\[0\].RAM16.SLICE\[1\].RAM8.WORD\[5\].W.BYTE\[1\].B.Q_WIRE\[3\]
+ SLICE_16\[0\].RAM16.SLICE\[1\].RAM8.WORD\[5\].W.BYTE\[1\].B.SEL0_B VGND VGND VPWR
+ VPWR SLICE_16\[0\].RAM16.BYTE\[1\].FLOATBUF0\[11\].Z sky130_fd_sc_hd__ebufn_2
XSLICE_16\[0\].RAM16.SLICE\[0\].RAM8.WORD\[1\].W.BYTE\[1\].B.BIT\[0\].genblk1.STORAGE
+ DIBUF\[8\].X SLICE_16\[0\].RAM16.SLICE\[0\].RAM8.WORD\[1\].W.BYTE\[1\].B.GCLK VGND
+ VGND VPWR VPWR SLICE_16\[0\].RAM16.SLICE\[0\].RAM8.WORD\[1\].W.BYTE\[1\].B.Q_WIRE\[0\]
+ sky130_fd_sc_hd__dlxtp_1
Xtap_18_24 VGND VPWR sky130_fd_sc_hd__tapvpwrvgnd_1
Xtap_18_13 VGND VPWR sky130_fd_sc_hd__tapvpwrvgnd_1
XSLICE_16\[0\].RAM16.SLICE\[1\].RAM8.WORD\[0\].W.BYTE\[3\].B.genblk1.CLKINV SLICE_16\[0\].RAM16.SLICE\[1\].RAM8.WORD\[0\].W.BYTE\[0\].B.CLK
+ VGND VGND VPWR VPWR SLICE_16\[0\].RAM16.SLICE\[1\].RAM8.WORD\[0\].W.BYTE\[3\].B.CLK_B
+ sky130_fd_sc_hd__inv_1
Xtap_34_34 VGND VPWR sky130_fd_sc_hd__tapvpwrvgnd_1
Xtap_34_23 VGND VPWR sky130_fd_sc_hd__tapvpwrvgnd_1
Xtap_34_12 VGND VPWR sky130_fd_sc_hd__tapvpwrvgnd_1
XSLICE_16\[1\].RAM16.Do0_REG.OUTREG_BYTE\[3\].Do_FF\[7\] SLICE_16\[1\].RAM16.Do0_REG.CLKBUF\[3\]
+ SLICE_16\[1\].RAM16.BYTE\[3\].FLOATBUF0\[31\].Z VGND VGND VPWR VPWR Do0MUX.A1\[31\]
+ sky130_fd_sc_hd__dfxtp_1
Xfill_22_77 VGND VGND VPWR VPWR sky130_fd_sc_hd__decap_12
Xfill_22_66 VGND VPWR sky130_fd_sc_hd__tapvpwrvgnd_1
Xfill_22_55 VGND VGND VPWR VPWR sky130_fd_sc_hd__decap_12
Xfill_22_44 VGND VGND VPWR VPWR sky130_fd_sc_hd__decap_12
Xfill_22_33 VGND VPWR sky130_fd_sc_hd__tapvpwrvgnd_1
Xfill_22_22 VGND VGND VPWR VPWR sky130_fd_sc_hd__decap_12
Xfill_22_11 VGND VGND VPWR VPWR sky130_fd_sc_hd__decap_12
XSLICE_16\[0\].RAM16.SLICE\[0\].RAM8.WORD\[0\].W.BYTE\[0\].B.BIT\[2\].OBUF0 SLICE_16\[0\].RAM16.SLICE\[0\].RAM8.WORD\[0\].W.BYTE\[0\].B.Q_WIRE\[2\]
+ SLICE_16\[0\].RAM16.SLICE\[0\].RAM8.WORD\[0\].W.BYTE\[0\].B.SEL0_B VGND VGND VPWR
+ VPWR SLICE_16\[0\].RAM16.BYTE\[0\].FLOATBUF0\[2\].Z sky130_fd_sc_hd__ebufn_2
XDo0MUX.M\[2\].MUX\[1\] Do0MUX.A0\[17\] Do0MUX.A1\[17\] Do0MUX.SEL\[2\] VGND VGND
+ VPWR VPWR Do0[17] sky130_fd_sc_hd__mux2_1
Xfill_22_99 VGND VPWR sky130_fd_sc_hd__tapvpwrvgnd_1
Xfill_22_88 VGND VGND VPWR VPWR sky130_fd_sc_hd__decap_12
XSLICE_16\[0\].RAM16.SLICE\[0\].RAM8.WORD\[4\].W.BYTE\[3\].B.BIT\[5\].OBUF0 SLICE_16\[0\].RAM16.SLICE\[0\].RAM8.WORD\[4\].W.BYTE\[3\].B.Q_WIRE\[5\]
+ SLICE_16\[0\].RAM16.SLICE\[0\].RAM8.WORD\[4\].W.BYTE\[3\].B.SEL0_B VGND VGND VPWR
+ VPWR SLICE_16\[0\].RAM16.BYTE\[3\].FLOATBUF0\[29\].Z sky130_fd_sc_hd__ebufn_2
Xfill_47_63 VGND VPWR sky130_fd_sc_hd__tapvpwrvgnd_1
Xfill_47_52 VGND VGND VPWR VPWR sky130_fd_sc_hd__decap_12
Xfill_47_41 VGND VGND VPWR VPWR sky130_fd_sc_hd__decap_12
Xfill_47_30 VGND VPWR sky130_fd_sc_hd__tapvpwrvgnd_1
XDo0MUX.SEL0BUF\[1\] A0BUF\[4\].X VGND VGND VPWR VPWR Do0MUX.SEL\[1\] sky130_fd_sc_hd__clkbuf_2
XSLICE_16\[1\].RAM16.SLICE\[1\].RAM8.WORD\[6\].W.BYTE\[3\].B.BIT\[2\].OBUF0 SLICE_16\[1\].RAM16.SLICE\[1\].RAM8.WORD\[6\].W.BYTE\[3\].B.Q_WIRE\[2\]
+ SLICE_16\[1\].RAM16.SLICE\[1\].RAM8.WORD\[6\].W.BYTE\[3\].B.SEL0_B VGND VGND VPWR
+ VPWR SLICE_16\[1\].RAM16.BYTE\[3\].FLOATBUF0\[26\].Z sky130_fd_sc_hd__ebufn_2
XSLICE_16\[1\].RAM16.SLICE\[0\].RAM8.WORD\[4\].W.BYTE\[1\].B.DIODE_CLK SLICE_16\[1\].RAM16.SLICE\[0\].RAM8.WORD\[4\].W.BYTE\[0\].B.CLK
+ VGND VGND VPWR VPWR sky130_fd_sc_hd__diode_2
XSLICE_16\[1\].RAM16.SLICE\[1\].RAM8.WORD\[3\].W.BYTE\[0\].B.BIT\[7\].OBUF0 SLICE_16\[1\].RAM16.SLICE\[1\].RAM8.WORD\[3\].W.BYTE\[0\].B.Q_WIRE\[7\]
+ SLICE_16\[1\].RAM16.SLICE\[1\].RAM8.WORD\[3\].W.BYTE\[0\].B.SEL0_B VGND VGND VPWR
+ VPWR SLICE_16\[1\].RAM16.BYTE\[0\].FLOATBUF0\[7\].Z sky130_fd_sc_hd__ebufn_2
XSLICE_16\[1\].RAM16.SLICE\[0\].RAM8.WORD\[1\].W.BYTE\[2\].B.BIT\[1\].OBUF0 SLICE_16\[1\].RAM16.SLICE\[0\].RAM8.WORD\[1\].W.BYTE\[2\].B.Q_WIRE\[1\]
+ SLICE_16\[1\].RAM16.SLICE\[0\].RAM8.WORD\[1\].W.BYTE\[2\].B.SEL0_B VGND VGND VPWR
+ VPWR SLICE_16\[1\].RAM16.BYTE\[2\].FLOATBUF0\[17\].Z sky130_fd_sc_hd__ebufn_2
Xtap_1_29 VGND VPWR sky130_fd_sc_hd__tapvpwrvgnd_1
Xtap_1_18 VGND VPWR sky130_fd_sc_hd__tapvpwrvgnd_1
XDo0MUX.M\[1\].MUX\[3\] Do0MUX.A0\[11\] Do0MUX.A1\[11\] Do0MUX.SEL\[1\] VGND VGND
+ VPWR VPWR Do0[11] sky130_fd_sc_hd__mux2_1
Xfill_31_0 VGND VPWR sky130_fd_sc_hd__tapvpwrvgnd_1
XSLICE_16\[0\].RAM16.SLICE\[1\].RAM8.WORD\[7\].W.BYTE\[2\].B.genblk1.CG SLICE_16\[0\].RAM16.SLICE\[1\].RAM8.WORD\[7\].W.BYTE\[2\].B.CLK_B
+ SLICE_16\[0\].RAM16.SLICE\[1\].RAM8.WORD\[7\].W.BYTE\[2\].B.WE0_WIRE VGND VGND VPWR
+ VPWR SLICE_16\[0\].RAM16.SLICE\[1\].RAM8.WORD\[7\].W.BYTE\[2\].B.GCLK sky130_fd_sc_hd__dlclkp_1
XSLICE_16\[0\].RAM16.SLICE\[0\].RAM8.WORD\[3\].W.BYTE\[1\].B.BIT\[2\].OBUF0 SLICE_16\[0\].RAM16.SLICE\[0\].RAM8.WORD\[3\].W.BYTE\[1\].B.Q_WIRE\[2\]
+ SLICE_16\[0\].RAM16.SLICE\[0\].RAM8.WORD\[3\].W.BYTE\[1\].B.SEL0_B VGND VGND VPWR
+ VPWR SLICE_16\[0\].RAM16.BYTE\[1\].FLOATBUF0\[10\].Z sky130_fd_sc_hd__ebufn_2
XSLICE_16\[0\].RAM16.SLICE\[0\].RAM8.WORD\[6\].W.BYTE\[1\].B.CGAND SLICE_16\[0\].RAM16.SLICE\[0\].RAM8.WORD\[6\].W.BYTE\[0\].B.SEL0
+ SLICE_16\[0\].RAM16.SLICE\[0\].RAM8.WE0_buf\[1\] VGND VGND VPWR VPWR SLICE_16\[0\].RAM16.SLICE\[0\].RAM8.WORD\[6\].W.BYTE\[1\].B.WE0_WIRE
+ sky130_fd_sc_hd__and2_1
XSLICE_16\[0\].RAM16.SLICE\[0\].RAM8.WORD\[7\].W.BYTE\[0\].B.DIODE_CLK SLICE_16\[0\].RAM16.SLICE\[0\].RAM8.WORD\[7\].W.BYTE\[0\].B.CLK
+ VGND VGND VPWR VPWR sky130_fd_sc_hd__diode_2
XSLICE_16\[0\].RAM16.SLICE\[1\].RAM8.WORD\[1\].W.BYTE\[1\].B.DIODE_CLK SLICE_16\[0\].RAM16.SLICE\[1\].RAM8.WORD\[1\].W.BYTE\[0\].B.CLK
+ VGND VGND VPWR VPWR sky130_fd_sc_hd__diode_2
XSLICE_16\[1\].RAM16.SLICE\[0\].RAM8.WORD\[3\].W.BYTE\[2\].B.BIT\[4\].genblk1.STORAGE
+ DIBUF\[20\].X SLICE_16\[1\].RAM16.SLICE\[0\].RAM8.WORD\[3\].W.BYTE\[2\].B.GCLK VGND
+ VGND VPWR VPWR SLICE_16\[1\].RAM16.SLICE\[0\].RAM8.WORD\[3\].W.BYTE\[2\].B.Q_WIRE\[4\]
+ sky130_fd_sc_hd__dlxtp_1
Xtap_39_5 VGND VPWR sky130_fd_sc_hd__tapvpwrvgnd_1
Xtap_29_34 VGND VPWR sky130_fd_sc_hd__tapvpwrvgnd_1
Xtap_29_23 VGND VPWR sky130_fd_sc_hd__tapvpwrvgnd_1
Xtap_29_12 VGND VPWR sky130_fd_sc_hd__tapvpwrvgnd_1
XSLICE_16\[1\].RAM16.SLICE\[0\].RAM8.WORD\[1\].W.BYTE\[0\].B.BIT\[3\].genblk1.STORAGE
+ DIBUF\[3\].X SLICE_16\[1\].RAM16.SLICE\[0\].RAM8.WORD\[1\].W.BYTE\[0\].B.GCLK VGND
+ VGND VPWR VPWR SLICE_16\[1\].RAM16.SLICE\[0\].RAM8.WORD\[1\].W.BYTE\[0\].B.Q_WIRE\[3\]
+ sky130_fd_sc_hd__dlxtp_1
XSLICE_16\[0\].RAM16.SLICE\[1\].RAM8.WORD\[5\].W.BYTE\[2\].B.BIT\[5\].genblk1.STORAGE
+ DIBUF\[21\].X SLICE_16\[0\].RAM16.SLICE\[1\].RAM8.WORD\[5\].W.BYTE\[2\].B.GCLK VGND
+ VGND VPWR VPWR SLICE_16\[0\].RAM16.SLICE\[1\].RAM8.WORD\[5\].W.BYTE\[2\].B.Q_WIRE\[5\]
+ sky130_fd_sc_hd__dlxtp_1
Xfill_17_33 VGND VPWR sky130_fd_sc_hd__tapvpwrvgnd_1
Xfill_17_22 VGND VGND VPWR VPWR sky130_fd_sc_hd__decap_12
Xfill_17_11 VGND VGND VPWR VPWR sky130_fd_sc_hd__decap_12
XSLICE_16\[0\].RAM16.SLICE\[1\].RAM8.WORD\[3\].W.BYTE\[0\].B.BIT\[4\].genblk1.STORAGE
+ DIBUF\[4\].X SLICE_16\[0\].RAM16.SLICE\[1\].RAM8.WORD\[3\].W.BYTE\[0\].B.GCLK VGND
+ VGND VPWR VPWR SLICE_16\[0\].RAM16.SLICE\[1\].RAM8.WORD\[3\].W.BYTE\[0\].B.Q_WIRE\[4\]
+ sky130_fd_sc_hd__dlxtp_1
Xfill_17_66 VGND VPWR sky130_fd_sc_hd__tapvpwrvgnd_1
Xfill_17_55 VGND VGND VPWR VPWR sky130_fd_sc_hd__decap_12
Xfill_17_44 VGND VGND VPWR VPWR sky130_fd_sc_hd__decap_12
XSLICE_16\[0\].RAM16.SLICE\[1\].RAM8.WORD\[7\].W.BYTE\[0\].B.BIT\[0\].OBUF0 SLICE_16\[0\].RAM16.SLICE\[1\].RAM8.WORD\[7\].W.BYTE\[0\].B.Q_WIRE\[0\]
+ SLICE_16\[0\].RAM16.SLICE\[1\].RAM8.WORD\[7\].W.BYTE\[0\].B.SEL0_B VGND VGND VPWR
+ VPWR SLICE_16\[0\].RAM16.BYTE\[0\].FLOATBUF0\[0\].Z sky130_fd_sc_hd__ebufn_2
XSLICE_16\[0\].RAM16.SLICE\[0\].RAM8.WORD\[4\].W.BYTE\[2\].B.BIT\[0\].genblk1.STORAGE
+ DIBUF\[16\].X SLICE_16\[0\].RAM16.SLICE\[0\].RAM8.WORD\[4\].W.BYTE\[2\].B.GCLK VGND
+ VGND VPWR VPWR SLICE_16\[0\].RAM16.SLICE\[0\].RAM8.WORD\[4\].W.BYTE\[2\].B.Q_WIRE\[0\]
+ sky130_fd_sc_hd__dlxtp_1
XSLICE_16\[1\].RAM16.SLICE\[1\].RAM8.WORD\[6\].W.BYTE\[1\].B.BIT\[7\].OBUF0 SLICE_16\[1\].RAM16.SLICE\[1\].RAM8.WORD\[6\].W.BYTE\[1\].B.Q_WIRE\[7\]
+ SLICE_16\[1\].RAM16.SLICE\[1\].RAM8.WORD\[6\].W.BYTE\[1\].B.SEL0_B VGND VGND VPWR
+ VPWR SLICE_16\[1\].RAM16.BYTE\[1\].FLOATBUF0\[15\].Z sky130_fd_sc_hd__ebufn_2
XSLICE_16\[1\].RAM16.SLICE\[0\].RAM8.WORD\[4\].W.BYTE\[3\].B.BIT\[1\].OBUF0 SLICE_16\[1\].RAM16.SLICE\[0\].RAM8.WORD\[4\].W.BYTE\[3\].B.Q_WIRE\[1\]
+ SLICE_16\[1\].RAM16.SLICE\[0\].RAM8.WORD\[4\].W.BYTE\[3\].B.SEL0_B VGND VGND VPWR
+ VPWR SLICE_16\[1\].RAM16.BYTE\[3\].FLOATBUF0\[25\].Z sky130_fd_sc_hd__ebufn_2
XDo0MUX.M\[0\].MUX\[5\] Do0MUX.A0\[5\] Do0MUX.A1\[5\] Do0MUX.SEL\[0\] VGND VGND VPWR
+ VPWR Do0[5] sky130_fd_sc_hd__mux2_1
XSLICE_16\[1\].RAM16.SLICE\[1\].RAM8.WORD\[4\].W.BYTE\[1\].B.genblk1.CG SLICE_16\[1\].RAM16.SLICE\[1\].RAM8.WORD\[4\].W.BYTE\[1\].B.CLK_B
+ SLICE_16\[1\].RAM16.SLICE\[1\].RAM8.WORD\[4\].W.BYTE\[1\].B.WE0_WIRE VGND VGND VPWR
+ VPWR SLICE_16\[1\].RAM16.SLICE\[1\].RAM8.WORD\[4\].W.BYTE\[1\].B.GCLK sky130_fd_sc_hd__dlclkp_1
XSLICE_16\[1\].RAM16.SLICE\[0\].RAM8.WORD\[1\].W.BYTE\[0\].B.BIT\[6\].OBUF0 SLICE_16\[1\].RAM16.SLICE\[0\].RAM8.WORD\[1\].W.BYTE\[0\].B.Q_WIRE\[6\]
+ SLICE_16\[1\].RAM16.SLICE\[0\].RAM8.WORD\[1\].W.BYTE\[0\].B.SEL0_B VGND VGND VPWR
+ VPWR SLICE_16\[1\].RAM16.BYTE\[0\].FLOATBUF0\[6\].Z sky130_fd_sc_hd__ebufn_2
XSLICE_16\[0\].RAM16.Do0_REG.OUTREG_BYTE\[2\].DIODE\[7\] SLICE_16\[0\].RAM16.BYTE\[2\].FLOATBUF0\[23\].Z
+ VGND VGND VPWR VPWR sky130_fd_sc_hd__diode_2
XSLICE_16\[0\].RAM16.SLICE\[0\].RAM8.WORD\[6\].W.BYTE\[2\].B.BIT\[2\].OBUF0 SLICE_16\[0\].RAM16.SLICE\[0\].RAM8.WORD\[6\].W.BYTE\[2\].B.Q_WIRE\[2\]
+ SLICE_16\[0\].RAM16.SLICE\[0\].RAM8.WORD\[6\].W.BYTE\[2\].B.SEL0_B VGND VGND VPWR
+ VPWR SLICE_16\[0\].RAM16.BYTE\[2\].FLOATBUF0\[18\].Z sky130_fd_sc_hd__ebufn_2
Xfill_8_7 VGND VPWR sky130_fd_sc_hd__tapvpwrvgnd_1
Xfill_10_5 VGND VPWR sky130_fd_sc_hd__tapvpwrvgnd_1
Xfill_44_101 VGND VGND VPWR VPWR sky130_fd_sc_hd__decap_12
XDEC0.AND0 A0BUF\[4\].X DEC0.EN VGND VGND VPWR VPWR DEC0.SEL\[0\] sky130_fd_sc_hd__and2b_2
XDo0MUX.M\[2\].DIODE_A1MUX\[22\] Do0MUX.A1\[22\] VGND VGND VPWR VPWR sky130_fd_sc_hd__diode_2
XDo0MUX.M\[1\].DIODE_A0MUX\[8\] Do0MUX.A0\[8\] VGND VGND VPWR VPWR sky130_fd_sc_hd__diode_2
Xtap_15_14 VGND VPWR sky130_fd_sc_hd__tapvpwrvgnd_1
Xtap_31_35 VGND VPWR sky130_fd_sc_hd__tapvpwrvgnd_1
Xtap_31_24 VGND VPWR sky130_fd_sc_hd__tapvpwrvgnd_1
Xtap_31_13 VGND VPWR sky130_fd_sc_hd__tapvpwrvgnd_1
XSLICE_16\[0\].RAM16.SLICE\[1\].RAM8.WORD\[7\].W.BYTE\[0\].B.CGAND SLICE_16\[0\].RAM16.SLICE\[1\].RAM8.WORD\[7\].W.BYTE\[0\].B.SEL0
+ SLICE_16\[0\].RAM16.SLICE\[1\].RAM8.WE0_buf\[0\] VGND VGND VPWR VPWR SLICE_16\[0\].RAM16.SLICE\[1\].RAM8.WORD\[7\].W.BYTE\[0\].B.WE0_WIRE
+ sky130_fd_sc_hd__and2_1
Xtap_15_36 VGND VPWR sky130_fd_sc_hd__tapvpwrvgnd_1
Xtap_15_25 VGND VPWR sky130_fd_sc_hd__tapvpwrvgnd_1
XSLICE_16\[1\].RAM16.SLICE\[1\].RAM8.WORD\[6\].W.BYTE\[1\].B.DIODE_CLK SLICE_16\[1\].RAM16.SLICE\[1\].RAM8.WORD\[6\].W.BYTE\[0\].B.CLK
+ VGND VGND VPWR VPWR sky130_fd_sc_hd__diode_2
Xtap_37_2 VGND VPWR sky130_fd_sc_hd__tapvpwrvgnd_1
XDo0MUX.M\[3\].DIODE_A1MUX\[26\] Do0MUX.A1\[26\] VGND VGND VPWR VPWR sky130_fd_sc_hd__diode_2
Xfill_44_20 VGND VGND VPWR VPWR sky130_fd_sc_hd__decap_12
XSLICE_16\[1\].RAM16.SLICE\[0\].RAM8.WORD\[6\].W.BYTE\[3\].B.BIT\[4\].genblk1.STORAGE
+ DIBUF\[28\].X SLICE_16\[1\].RAM16.SLICE\[0\].RAM8.WORD\[6\].W.BYTE\[3\].B.GCLK VGND
+ VGND VPWR VPWR SLICE_16\[1\].RAM16.SLICE\[0\].RAM8.WORD\[6\].W.BYTE\[3\].B.Q_WIRE\[4\]
+ sky130_fd_sc_hd__dlxtp_1
XSLICE_16\[1\].RAM16.SLICE\[0\].RAM8.WORD\[4\].W.BYTE\[1\].B.BIT\[6\].OBUF0 SLICE_16\[1\].RAM16.SLICE\[0\].RAM8.WORD\[4\].W.BYTE\[1\].B.Q_WIRE\[6\]
+ SLICE_16\[1\].RAM16.SLICE\[0\].RAM8.WORD\[4\].W.BYTE\[1\].B.SEL0_B VGND VGND VPWR
+ VPWR SLICE_16\[1\].RAM16.BYTE\[1\].FLOATBUF0\[14\].Z sky130_fd_sc_hd__ebufn_2
XSLICE_16\[0\].RAM16.SLICE\[1\].RAM8.WORD\[1\].W.BYTE\[3\].B.BIT\[5\].OBUF0 SLICE_16\[0\].RAM16.SLICE\[1\].RAM8.WORD\[1\].W.BYTE\[3\].B.Q_WIRE\[5\]
+ SLICE_16\[0\].RAM16.SLICE\[1\].RAM8.WORD\[1\].W.BYTE\[3\].B.SEL0_B VGND VGND VPWR
+ VPWR SLICE_16\[0\].RAM16.BYTE\[3\].FLOATBUF0\[29\].Z sky130_fd_sc_hd__ebufn_2
Xfill_44_97 VGND VGND VPWR VPWR sky130_fd_sc_hd__decap_12
Xfill_44_86 VGND VGND VPWR VPWR sky130_fd_sc_hd__decap_12
Xfill_44_75 VGND VPWR sky130_fd_sc_hd__tapvpwrvgnd_1
Xfill_44_64 VGND VGND VPWR VPWR sky130_fd_sc_hd__decap_12
Xfill_44_53 VGND VGND VPWR VPWR sky130_fd_sc_hd__decap_12
Xfill_44_42 VGND VPWR sky130_fd_sc_hd__tapvpwrvgnd_1
Xfill_44_31 VGND VGND VPWR VPWR sky130_fd_sc_hd__decap_12
Xfill_41_104 VGND VGND VPWR VPWR sky130_fd_sc_hd__decap_6
XSLICE_16\[1\].RAM16.SLICE\[0\].RAM8.WORD\[4\].W.BYTE\[1\].B.BIT\[3\].genblk1.STORAGE
+ DIBUF\[11\].X SLICE_16\[1\].RAM16.SLICE\[0\].RAM8.WORD\[4\].W.BYTE\[1\].B.GCLK VGND
+ VGND VPWR VPWR SLICE_16\[1\].RAM16.SLICE\[0\].RAM8.WORD\[4\].W.BYTE\[1\].B.Q_WIRE\[3\]
+ sky130_fd_sc_hd__dlxtp_1
XSLICE_16\[0\].RAM16.A0BUF\[2\].__cell__ A0BUF\[2\].X VGND VGND VPWR VPWR SLICE_16\[0\].RAM16.A0BUF\[2\].X
+ sky130_fd_sc_hd__clkbuf_2
XSLICE_16\[0\].RAM16.SLICE\[1\].RAM8.WORD\[6\].W.BYTE\[1\].B.BIT\[4\].genblk1.STORAGE
+ DIBUF\[12\].X SLICE_16\[0\].RAM16.SLICE\[1\].RAM8.WORD\[6\].W.BYTE\[1\].B.GCLK VGND
+ VGND VPWR VPWR SLICE_16\[0\].RAM16.SLICE\[1\].RAM8.WORD\[6\].W.BYTE\[1\].B.Q_WIRE\[4\]
+ sky130_fd_sc_hd__dlxtp_1
XSLICE_16\[0\].RAM16.SLICE\[0\].RAM8.CLKBUF.__cell__ SLICE_16\[0\].RAM16.CLKBUF.X
+ VGND VGND VPWR VPWR SLICE_16\[0\].RAM16.SLICE\[0\].RAM8.CLKBUF.X sky130_fd_sc_hd__clkbuf_2
XSLICE_16\[0\].RAM16.SLICE\[0\].RAM8.WORD\[6\].W.BYTE\[0\].B.BIT\[7\].OBUF0 SLICE_16\[0\].RAM16.SLICE\[0\].RAM8.WORD\[6\].W.BYTE\[0\].B.Q_WIRE\[7\]
+ SLICE_16\[0\].RAM16.SLICE\[0\].RAM8.WORD\[6\].W.BYTE\[0\].B.SEL0_B VGND VGND VPWR
+ VPWR SLICE_16\[0\].RAM16.BYTE\[0\].FLOATBUF0\[7\].Z sky130_fd_sc_hd__ebufn_2
XSLICE_16\[0\].RAM16.SLICE\[1\].RAM8.WORD\[0\].W.BYTE\[2\].B.BIT\[5\].genblk1.STORAGE
+ DIBUF\[21\].X SLICE_16\[0\].RAM16.SLICE\[1\].RAM8.WORD\[0\].W.BYTE\[2\].B.GCLK VGND
+ VGND VPWR VPWR SLICE_16\[0\].RAM16.SLICE\[1\].RAM8.WORD\[0\].W.BYTE\[2\].B.Q_WIRE\[5\]
+ sky130_fd_sc_hd__dlxtp_1
XSLICE_16\[0\].RAM16.SLICE\[0\].RAM8.WORD\[7\].W.BYTE\[3\].B.BIT\[0\].genblk1.STORAGE
+ DIBUF\[24\].X SLICE_16\[0\].RAM16.SLICE\[0\].RAM8.WORD\[7\].W.BYTE\[3\].B.GCLK VGND
+ VGND VPWR VPWR SLICE_16\[0\].RAM16.SLICE\[0\].RAM8.WORD\[7\].W.BYTE\[3\].B.Q_WIRE\[0\]
+ sky130_fd_sc_hd__dlxtp_1
Xtap_7_17 VGND VPWR sky130_fd_sc_hd__tapvpwrvgnd_1
Xfill_6_4 VGND VGND VPWR VPWR sky130_fd_sc_hd__decap_6
Xtap_7_28 VGND VPWR sky130_fd_sc_hd__tapvpwrvgnd_1
Xtap_30_9 VGND VPWR sky130_fd_sc_hd__tapvpwrvgnd_1
Xtap_23_8 VGND VPWR sky130_fd_sc_hd__tapvpwrvgnd_1
Xtap_16_7 VGND VPWR sky130_fd_sc_hd__tapvpwrvgnd_1
XSLICE_16\[0\].RAM16.SLICE\[1\].RAM8.WORD\[0\].W.BYTE\[1\].B.BIT\[2\].OBUF0 SLICE_16\[0\].RAM16.SLICE\[1\].RAM8.WORD\[0\].W.BYTE\[1\].B.Q_WIRE\[2\]
+ SLICE_16\[0\].RAM16.SLICE\[1\].RAM8.WORD\[0\].W.BYTE\[1\].B.SEL0_B VGND VGND VPWR
+ VPWR SLICE_16\[0\].RAM16.BYTE\[1\].FLOATBUF0\[10\].Z sky130_fd_sc_hd__ebufn_2
XSLICE_16\[1\].RAM16.SLICE\[0\].RAM8.WORD\[7\].W.BYTE\[2\].B.BIT\[6\].OBUF0 SLICE_16\[1\].RAM16.SLICE\[0\].RAM8.WORD\[7\].W.BYTE\[2\].B.Q_WIRE\[6\]
+ SLICE_16\[1\].RAM16.SLICE\[0\].RAM8.WORD\[7\].W.BYTE\[2\].B.SEL0_B VGND VGND VPWR
+ VPWR SLICE_16\[1\].RAM16.BYTE\[2\].FLOATBUF0\[22\].Z sky130_fd_sc_hd__ebufn_2
Xtap_26_35 VGND VPWR sky130_fd_sc_hd__tapvpwrvgnd_1
Xtap_26_24 VGND VPWR sky130_fd_sc_hd__tapvpwrvgnd_1
Xtap_26_13 VGND VPWR sky130_fd_sc_hd__tapvpwrvgnd_1
Xtap_9_6 VGND VPWR sky130_fd_sc_hd__tapvpwrvgnd_1
Xfill_39_64 VGND VPWR sky130_fd_sc_hd__tapvpwrvgnd_1
Xfill_39_53 VGND VGND VPWR VPWR sky130_fd_sc_hd__decap_12
Xfill_39_42 VGND VPWR sky130_fd_sc_hd__tapvpwrvgnd_1
Xfill_39_31 VGND VGND VPWR VPWR sky130_fd_sc_hd__decap_12
Xfill_39_20 VGND VGND VPWR VPWR sky130_fd_sc_hd__decap_12
XSLICE_16\[1\].RAM16.SLICE\[1\].RAM8.WORD\[1\].W.BYTE\[3\].B.BIT\[1\].OBUF0 SLICE_16\[1\].RAM16.SLICE\[1\].RAM8.WORD\[1\].W.BYTE\[3\].B.Q_WIRE\[1\]
+ SLICE_16\[1\].RAM16.SLICE\[1\].RAM8.WORD\[1\].W.BYTE\[3\].B.SEL0_B VGND VGND VPWR
+ VPWR SLICE_16\[1\].RAM16.BYTE\[3\].FLOATBUF0\[25\].Z sky130_fd_sc_hd__ebufn_2
XSLICE_16\[1\].RAM16.SLICE\[0\].RAM8.WORD\[6\].W.BYTE\[0\].B.BIT\[3\].OBUF0 SLICE_16\[1\].RAM16.SLICE\[0\].RAM8.WORD\[6\].W.BYTE\[0\].B.Q_WIRE\[3\]
+ SLICE_16\[1\].RAM16.SLICE\[0\].RAM8.WORD\[6\].W.BYTE\[0\].B.SEL0_B VGND VGND VPWR
+ VPWR SLICE_16\[1\].RAM16.BYTE\[0\].FLOATBUF0\[3\].Z sky130_fd_sc_hd__ebufn_2
XSLICE_16\[0\].RAM16.SLICE\[0\].RAM8.WORD\[2\].W.BYTE\[0\].B.CGAND SLICE_16\[0\].RAM16.SLICE\[0\].RAM8.WORD\[2\].W.BYTE\[0\].B.SEL0
+ SLICE_16\[0\].RAM16.SLICE\[0\].RAM8.WE0_buf\[0\] VGND VGND VPWR VPWR SLICE_16\[0\].RAM16.SLICE\[0\].RAM8.WORD\[2\].W.BYTE\[0\].B.WE0_WIRE
+ sky130_fd_sc_hd__and2_1
XDIBUF\[28\].__cell__ Di0[28] VGND VGND VPWR VPWR DIBUF\[28\].X sky130_fd_sc_hd__clkbuf_16
XSLICE_16\[1\].RAM16.SLICE\[1\].RAM8.WORD\[6\].W.BYTE\[0\].B.BIT\[7\].genblk1.STORAGE
+ DIBUF\[7\].X SLICE_16\[1\].RAM16.SLICE\[1\].RAM8.WORD\[6\].W.BYTE\[0\].B.GCLK VGND
+ VGND VPWR VPWR SLICE_16\[1\].RAM16.SLICE\[1\].RAM8.WORD\[6\].W.BYTE\[0\].B.Q_WIRE\[7\]
+ sky130_fd_sc_hd__dlxtp_1
XSLICE_16\[1\].RAM16.SLICE\[0\].RAM8.WORD\[1\].W.BYTE\[2\].B.genblk1.CLKINV SLICE_16\[1\].RAM16.SLICE\[0\].RAM8.WORD\[1\].W.BYTE\[0\].B.CLK
+ VGND VGND VPWR VPWR SLICE_16\[1\].RAM16.SLICE\[0\].RAM8.WORD\[1\].W.BYTE\[2\].B.CLK_B
+ sky130_fd_sc_hd__inv_1
XSLICE_16\[0\].RAM16.SLICE\[1\].RAM8.WORD\[3\].W.BYTE\[2\].B.BIT\[2\].OBUF0 SLICE_16\[0\].RAM16.SLICE\[1\].RAM8.WORD\[3\].W.BYTE\[2\].B.Q_WIRE\[2\]
+ SLICE_16\[0\].RAM16.SLICE\[1\].RAM8.WORD\[3\].W.BYTE\[2\].B.SEL0_B VGND VGND VPWR
+ VPWR SLICE_16\[0\].RAM16.BYTE\[2\].FLOATBUF0\[18\].Z sky130_fd_sc_hd__ebufn_2
XSLICE_16\[1\].RAM16.SLICE\[0\].RAM8.WORD\[7\].W.BYTE\[2\].B.BIT\[3\].genblk1.STORAGE
+ DIBUF\[19\].X SLICE_16\[1\].RAM16.SLICE\[0\].RAM8.WORD\[7\].W.BYTE\[2\].B.GCLK VGND
+ VGND VPWR VPWR SLICE_16\[1\].RAM16.SLICE\[0\].RAM8.WORD\[7\].W.BYTE\[2\].B.Q_WIRE\[3\]
+ sky130_fd_sc_hd__dlxtp_1
XSLICE_16\[1\].RAM16.SLICE\[0\].RAM8.WORD\[1\].W.BYTE\[3\].B.BIT\[4\].genblk1.STORAGE
+ DIBUF\[28\].X SLICE_16\[1\].RAM16.SLICE\[0\].RAM8.WORD\[1\].W.BYTE\[3\].B.GCLK VGND
+ VGND VPWR VPWR SLICE_16\[1\].RAM16.SLICE\[0\].RAM8.WORD\[1\].W.BYTE\[3\].B.Q_WIRE\[4\]
+ sky130_fd_sc_hd__dlxtp_1
XSLICE_16\[1\].RAM16.Do0_REG.OUTREG_BYTE\[1\].DIODE\[3\] SLICE_16\[1\].RAM16.BYTE\[1\].FLOATBUF0\[11\].Z
+ VGND VGND VPWR VPWR sky130_fd_sc_hd__diode_2
XSLICE_16\[1\].RAM16.SLICE\[0\].RAM8.WORD\[5\].W.BYTE\[0\].B.BIT\[2\].genblk1.STORAGE
+ DIBUF\[2\].X SLICE_16\[1\].RAM16.SLICE\[0\].RAM8.WORD\[5\].W.BYTE\[0\].B.GCLK VGND
+ VGND VPWR VPWR SLICE_16\[1\].RAM16.SLICE\[0\].RAM8.WORD\[5\].W.BYTE\[0\].B.Q_WIRE\[2\]
+ sky130_fd_sc_hd__dlxtp_1
XSLICE_16\[0\].RAM16.SLICE\[1\].RAM8.WORD\[3\].W.BYTE\[3\].B.BIT\[5\].genblk1.STORAGE
+ DIBUF\[29\].X SLICE_16\[0\].RAM16.SLICE\[1\].RAM8.WORD\[3\].W.BYTE\[3\].B.GCLK VGND
+ VGND VPWR VPWR SLICE_16\[0\].RAM16.SLICE\[1\].RAM8.WORD\[3\].W.BYTE\[3\].B.Q_WIRE\[5\]
+ sky130_fd_sc_hd__dlxtp_1
Xtap_12_26 VGND VPWR sky130_fd_sc_hd__tapvpwrvgnd_1
Xtap_12_15 VGND VPWR sky130_fd_sc_hd__tapvpwrvgnd_1
Xfill_4_1 VGND VPWR sky130_fd_sc_hd__tapvpwrvgnd_1
XSLICE_16\[0\].RAM16.SLICE\[1\].RAM8.WORD\[7\].W.BYTE\[0\].B.BIT\[3\].genblk1.STORAGE
+ DIBUF\[3\].X SLICE_16\[0\].RAM16.SLICE\[1\].RAM8.WORD\[7\].W.BYTE\[0\].B.GCLK VGND
+ VGND VPWR VPWR SLICE_16\[0\].RAM16.SLICE\[1\].RAM8.WORD\[7\].W.BYTE\[0\].B.Q_WIRE\[3\]
+ sky130_fd_sc_hd__dlxtp_1
XSLICE_16\[0\].RAM16.SLICE\[0\].RAM8.WORD\[2\].W.BYTE\[3\].B.BIT\[0\].genblk1.STORAGE
+ DIBUF\[24\].X SLICE_16\[0\].RAM16.SLICE\[0\].RAM8.WORD\[2\].W.BYTE\[3\].B.GCLK VGND
+ VGND VPWR VPWR SLICE_16\[0\].RAM16.SLICE\[0\].RAM8.WORD\[2\].W.BYTE\[3\].B.Q_WIRE\[0\]
+ sky130_fd_sc_hd__dlxtp_1
XSLICE_16\[0\].RAM16.SLICE\[1\].RAM8.WORD\[1\].W.BYTE\[1\].B.BIT\[4\].genblk1.STORAGE
+ DIBUF\[12\].X SLICE_16\[0\].RAM16.SLICE\[1\].RAM8.WORD\[1\].W.BYTE\[1\].B.GCLK VGND
+ VGND VPWR VPWR SLICE_16\[0\].RAM16.SLICE\[1\].RAM8.WORD\[1\].W.BYTE\[1\].B.Q_WIRE\[4\]
+ sky130_fd_sc_hd__dlxtp_1
Xtap_37_34 VGND VPWR sky130_fd_sc_hd__tapvpwrvgnd_1
Xtap_37_23 VGND VPWR sky130_fd_sc_hd__tapvpwrvgnd_1
Xtap_37_12 VGND VPWR sky130_fd_sc_hd__tapvpwrvgnd_1
Xtap_14_4 VGND VPWR sky130_fd_sc_hd__tapvpwrvgnd_1
Xtap_7_3 VGND VPWR sky130_fd_sc_hd__tapvpwrvgnd_1
Xfill_41_76 VGND VGND VPWR VPWR sky130_fd_sc_hd__decap_12
Xfill_41_65 VGND VGND VPWR VPWR sky130_fd_sc_hd__decap_12
Xfill_41_54 VGND VPWR sky130_fd_sc_hd__tapvpwrvgnd_1
Xfill_41_43 VGND VGND VPWR VPWR sky130_fd_sc_hd__decap_12
Xfill_41_32 VGND VGND VPWR VPWR sky130_fd_sc_hd__decap_12
Xfill_41_21 VGND VPWR sky130_fd_sc_hd__tapvpwrvgnd_1
Xfill_41_10 VGND VGND VPWR VPWR sky130_fd_sc_hd__decap_12
XSLICE_16\[1\].RAM16.SLICE\[1\].RAM8.WORD\[1\].W.BYTE\[1\].B.BIT\[6\].OBUF0 SLICE_16\[1\].RAM16.SLICE\[1\].RAM8.WORD\[1\].W.BYTE\[1\].B.Q_WIRE\[6\]
+ SLICE_16\[1\].RAM16.SLICE\[1\].RAM8.WORD\[1\].W.BYTE\[1\].B.SEL0_B VGND VGND VPWR
+ VPWR SLICE_16\[1\].RAM16.BYTE\[1\].FLOATBUF0\[14\].Z sky130_fd_sc_hd__ebufn_2
XSLICE_16\[0\].RAM16.Do0_REG.OUTREG_BYTE\[3\].DIODE\[0\] SLICE_16\[0\].RAM16.BYTE\[3\].FLOATBUF0\[24\].Z
+ VGND VGND VPWR VPWR sky130_fd_sc_hd__diode_2
XSLICE_16\[0\].RAM16.SLICE\[1\].RAM8.WORD\[6\].W.BYTE\[3\].B.BIT\[2\].OBUF0 SLICE_16\[0\].RAM16.SLICE\[1\].RAM8.WORD\[6\].W.BYTE\[3\].B.Q_WIRE\[2\]
+ SLICE_16\[0\].RAM16.SLICE\[1\].RAM8.WORD\[6\].W.BYTE\[3\].B.SEL0_B VGND VGND VPWR
+ VPWR SLICE_16\[0\].RAM16.BYTE\[3\].FLOATBUF0\[26\].Z sky130_fd_sc_hd__ebufn_2
Xfill_41_98 VGND VGND VPWR VPWR sky130_fd_sc_hd__decap_12
Xfill_41_87 VGND VPWR sky130_fd_sc_hd__tapvpwrvgnd_1
XSLICE_16\[1\].RAM16.SLICE\[0\].RAM8.WORD\[4\].W.BYTE\[3\].B.genblk1.CLKINV SLICE_16\[1\].RAM16.SLICE\[0\].RAM8.WORD\[4\].W.BYTE\[0\].B.CLK
+ VGND VGND VPWR VPWR SLICE_16\[1\].RAM16.SLICE\[0\].RAM8.WORD\[4\].W.BYTE\[3\].B.CLK_B
+ sky130_fd_sc_hd__inv_1
Xfill_42_8 VGND VGND VPWR VPWR sky130_fd_sc_hd__decap_12
Xfill_28_6 VGND VGND VPWR VPWR sky130_fd_sc_hd__decap_4
XSLICE_16\[0\].RAM16.SLICE\[1\].RAM8.WORD\[3\].W.BYTE\[1\].B.genblk1.CG SLICE_16\[0\].RAM16.SLICE\[1\].RAM8.WORD\[3\].W.BYTE\[1\].B.CLK_B
+ SLICE_16\[0\].RAM16.SLICE\[1\].RAM8.WORD\[3\].W.BYTE\[1\].B.WE0_WIRE VGND VGND VPWR
+ VPWR SLICE_16\[0\].RAM16.SLICE\[1\].RAM8.WORD\[3\].W.BYTE\[1\].B.GCLK sky130_fd_sc_hd__dlclkp_1
XSLICE_16\[0\].RAM16.SLICE\[1\].RAM8.WORD\[3\].W.BYTE\[0\].B.BIT\[7\].OBUF0 SLICE_16\[0\].RAM16.SLICE\[1\].RAM8.WORD\[3\].W.BYTE\[0\].B.Q_WIRE\[7\]
+ SLICE_16\[0\].RAM16.SLICE\[1\].RAM8.WORD\[3\].W.BYTE\[0\].B.SEL0_B VGND VGND VPWR
+ VPWR SLICE_16\[0\].RAM16.BYTE\[0\].FLOATBUF0\[7\].Z sky130_fd_sc_hd__ebufn_2
XSLICE_16\[0\].RAM16.SLICE\[0\].RAM8.WORD\[1\].W.BYTE\[2\].B.BIT\[1\].OBUF0 SLICE_16\[0\].RAM16.SLICE\[0\].RAM8.WORD\[1\].W.BYTE\[2\].B.Q_WIRE\[1\]
+ SLICE_16\[0\].RAM16.SLICE\[0\].RAM8.WORD\[1\].W.BYTE\[2\].B.SEL0_B VGND VGND VPWR
+ VPWR SLICE_16\[0\].RAM16.BYTE\[2\].FLOATBUF0\[17\].Z sky130_fd_sc_hd__ebufn_2
Xtap_4_18 VGND VPWR sky130_fd_sc_hd__tapvpwrvgnd_1
Xtap_4_29 VGND VPWR sky130_fd_sc_hd__tapvpwrvgnd_1
XSLICE_16\[0\].RAM16.DIODE_A0\[3\].__cell__ A0BUF\[3\].X VGND VGND VPWR VPWR sky130_fd_sc_hd__diode_2
XSLICE_16\[1\].RAM16.Do0_REG.OUTREG_BYTE\[0\].Do_FF\[4\] SLICE_16\[1\].RAM16.Do0_REG.CLKBUF\[0\]
+ SLICE_16\[1\].RAM16.BYTE\[0\].FLOATBUF0\[4\].Z VGND VGND VPWR VPWR Do0MUX.A1\[4\]
+ sky130_fd_sc_hd__dfxtp_1
Xtap_23_36 VGND VPWR sky130_fd_sc_hd__tapvpwrvgnd_1
Xtap_23_25 VGND VPWR sky130_fd_sc_hd__tapvpwrvgnd_1
Xtap_23_14 VGND VPWR sky130_fd_sc_hd__tapvpwrvgnd_1
XSLICE_16\[1\].RAM16.SLICE\[1\].RAM8.WORD\[4\].W.BYTE\[2\].B.BIT\[6\].OBUF0 SLICE_16\[1\].RAM16.SLICE\[1\].RAM8.WORD\[4\].W.BYTE\[2\].B.Q_WIRE\[6\]
+ SLICE_16\[1\].RAM16.SLICE\[1\].RAM8.WORD\[4\].W.BYTE\[2\].B.SEL0_B VGND VGND VPWR
+ VPWR SLICE_16\[1\].RAM16.BYTE\[2\].FLOATBUF0\[22\].Z sky130_fd_sc_hd__ebufn_2
XSLICE_16\[1\].RAM16.SLICE\[1\].RAM8.WORD\[1\].W.BYTE\[0\].B.BIT\[7\].genblk1.STORAGE
+ DIBUF\[7\].X SLICE_16\[1\].RAM16.SLICE\[1\].RAM8.WORD\[1\].W.BYTE\[0\].B.GCLK VGND
+ VGND VPWR VPWR SLICE_16\[1\].RAM16.SLICE\[1\].RAM8.WORD\[1\].W.BYTE\[0\].B.Q_WIRE\[7\]
+ sky130_fd_sc_hd__dlxtp_1
XSLICE_16\[1\].RAM16.SLICE\[0\].RAM8.WORD\[2\].W.BYTE\[2\].B.BIT\[3\].genblk1.STORAGE
+ DIBUF\[19\].X SLICE_16\[1\].RAM16.SLICE\[0\].RAM8.WORD\[2\].W.BYTE\[2\].B.GCLK VGND
+ VGND VPWR VPWR SLICE_16\[1\].RAM16.SLICE\[0\].RAM8.WORD\[2\].W.BYTE\[2\].B.Q_WIRE\[3\]
+ sky130_fd_sc_hd__dlxtp_1
XSLICE_16\[1\].RAM16.SLICE\[0\].RAM8.WORD\[0\].W.BYTE\[0\].B.BIT\[2\].genblk1.STORAGE
+ DIBUF\[2\].X SLICE_16\[1\].RAM16.SLICE\[0\].RAM8.WORD\[0\].W.BYTE\[0\].B.GCLK VGND
+ VGND VPWR VPWR SLICE_16\[1\].RAM16.SLICE\[0\].RAM8.WORD\[0\].W.BYTE\[0\].B.Q_WIRE\[2\]
+ sky130_fd_sc_hd__dlxtp_1
XSLICE_16\[0\].RAM16.SLICE\[1\].RAM8.WORD\[6\].W.BYTE\[1\].B.BIT\[7\].OBUF0 SLICE_16\[0\].RAM16.SLICE\[1\].RAM8.WORD\[6\].W.BYTE\[1\].B.Q_WIRE\[7\]
+ SLICE_16\[0\].RAM16.SLICE\[1\].RAM8.WORD\[6\].W.BYTE\[1\].B.SEL0_B VGND VGND VPWR
+ VPWR SLICE_16\[0\].RAM16.BYTE\[1\].FLOATBUF0\[15\].Z sky130_fd_sc_hd__ebufn_2
Xtap_12_1 VGND VPWR sky130_fd_sc_hd__tapvpwrvgnd_1
XDIBUF\[1\].__cell__ Di0[1] VGND VGND VPWR VPWR DIBUF\[1\].X sky130_fd_sc_hd__clkbuf_16
Xtap_5_0 VGND VPWR sky130_fd_sc_hd__tapvpwrvgnd_1
XSLICE_16\[0\].RAM16.SLICE\[0\].RAM8.WORD\[4\].W.BYTE\[3\].B.BIT\[1\].OBUF0 SLICE_16\[0\].RAM16.SLICE\[0\].RAM8.WORD\[4\].W.BYTE\[3\].B.Q_WIRE\[1\]
+ SLICE_16\[0\].RAM16.SLICE\[0\].RAM8.WORD\[4\].W.BYTE\[3\].B.SEL0_B VGND VGND VPWR
+ VPWR SLICE_16\[0\].RAM16.BYTE\[3\].FLOATBUF0\[25\].Z sky130_fd_sc_hd__ebufn_2
XSLICE_16\[1\].RAM16.SLICE\[1\].RAM8.WORD\[0\].W.BYTE\[0\].B.genblk1.CG SLICE_16\[1\].RAM16.SLICE\[1\].RAM8.WORD\[0\].W.BYTE\[0\].B.CLK_B
+ SLICE_16\[1\].RAM16.SLICE\[1\].RAM8.WORD\[0\].W.BYTE\[0\].B.WE0_WIRE VGND VGND VPWR
+ VPWR SLICE_16\[1\].RAM16.SLICE\[1\].RAM8.WORD\[0\].W.BYTE\[0\].B.GCLK sky130_fd_sc_hd__dlclkp_1
XSLICE_16\[0\].RAM16.Do0_REG.OUTREG_BYTE\[2\].Do_FF\[1\] SLICE_16\[0\].RAM16.Do0_REG.CLKBUF\[2\]
+ SLICE_16\[0\].RAM16.BYTE\[2\].FLOATBUF0\[17\].Z VGND VGND VPWR VPWR Do0MUX.A0\[17\]
+ sky130_fd_sc_hd__dfxtp_1
XSLICE_16\[0\].RAM16.SLICE\[1\].RAM8.WORD\[4\].W.BYTE\[2\].B.BIT\[4\].genblk1.STORAGE
+ DIBUF\[20\].X SLICE_16\[0\].RAM16.SLICE\[1\].RAM8.WORD\[4\].W.BYTE\[2\].B.GCLK VGND
+ VGND VPWR VPWR SLICE_16\[0\].RAM16.SLICE\[1\].RAM8.WORD\[4\].W.BYTE\[2\].B.Q_WIRE\[4\]
+ sky130_fd_sc_hd__dlxtp_1
XSLICE_16\[0\].RAM16.SLICE\[1\].RAM8.WORD\[2\].W.BYTE\[0\].B.BIT\[3\].genblk1.STORAGE
+ DIBUF\[3\].X SLICE_16\[0\].RAM16.SLICE\[1\].RAM8.WORD\[2\].W.BYTE\[0\].B.GCLK VGND
+ VGND VPWR VPWR SLICE_16\[0\].RAM16.SLICE\[1\].RAM8.WORD\[2\].W.BYTE\[0\].B.Q_WIRE\[3\]
+ sky130_fd_sc_hd__dlxtp_1
XSLICE_16\[1\].RAM16.BYTE\[3\].FLOATBUF0\[25\].__cell__ SLICE_16\[1\].RAM16.BYTE\[3\].FLOATBUF0\[24\].A
+ SLICE_16\[1\].RAM16.BYTE\[3\].FLOATBUF0\[24\].TE_B VGND VGND VPWR VPWR SLICE_16\[1\].RAM16.BYTE\[3\].FLOATBUF0\[25\].Z
+ sky130_fd_sc_hd__ebufn_2
XSLICE_16\[0\].RAM16.SLICE\[0\].RAM8.WORD\[1\].W.BYTE\[0\].B.BIT\[6\].OBUF0 SLICE_16\[0\].RAM16.SLICE\[0\].RAM8.WORD\[1\].W.BYTE\[0\].B.Q_WIRE\[6\]
+ SLICE_16\[0\].RAM16.SLICE\[0\].RAM8.WORD\[1\].W.BYTE\[0\].B.SEL0_B VGND VGND VPWR
+ VPWR SLICE_16\[0\].RAM16.BYTE\[0\].FLOATBUF0\[6\].Z sky130_fd_sc_hd__ebufn_2
Xfill_40_5 VGND VGND VPWR VPWR sky130_fd_sc_hd__decap_12
Xfill_33_4 VGND VPWR sky130_fd_sc_hd__tapvpwrvgnd_1
XSLICE_16\[1\].RAM16.SLICE\[1\].RAM8.WORD\[3\].W.BYTE\[0\].B.BIT\[3\].OBUF0 SLICE_16\[1\].RAM16.SLICE\[1\].RAM8.WORD\[3\].W.BYTE\[0\].B.Q_WIRE\[3\]
+ SLICE_16\[1\].RAM16.SLICE\[1\].RAM8.WORD\[3\].W.BYTE\[0\].B.SEL0_B VGND VGND VPWR
+ VPWR SLICE_16\[1\].RAM16.BYTE\[0\].FLOATBUF0\[3\].Z sky130_fd_sc_hd__ebufn_2
Xfill_26_3 VGND VPWR sky130_fd_sc_hd__tapvpwrvgnd_1
Xfill_19_2 VGND VGND VPWR VPWR sky130_fd_sc_hd__decap_12
XSLICE_16\[1\].RAM16.SLICE\[1\].RAM8.WORD\[7\].W.BYTE\[3\].B.BIT\[6\].OBUF0 SLICE_16\[1\].RAM16.SLICE\[1\].RAM8.WORD\[7\].W.BYTE\[3\].B.Q_WIRE\[6\]
+ SLICE_16\[1\].RAM16.SLICE\[1\].RAM8.WORD\[7\].W.BYTE\[3\].B.SEL0_B VGND VGND VPWR
+ VPWR SLICE_16\[1\].RAM16.BYTE\[3\].FLOATBUF0\[30\].Z sky130_fd_sc_hd__ebufn_2
Xtap_34_13 VGND VPWR sky130_fd_sc_hd__tapvpwrvgnd_1
XSLICE_16\[1\].RAM16.SLICE\[0\].RAM8.WORD\[2\].W.BYTE\[2\].B.BIT\[5\].OBUF0 SLICE_16\[1\].RAM16.SLICE\[0\].RAM8.WORD\[2\].W.BYTE\[2\].B.Q_WIRE\[5\]
+ SLICE_16\[1\].RAM16.SLICE\[0\].RAM8.WORD\[2\].W.BYTE\[2\].B.SEL0_B VGND VGND VPWR
+ VPWR SLICE_16\[1\].RAM16.BYTE\[2\].FLOATBUF0\[21\].Z sky130_fd_sc_hd__ebufn_2
Xtap_18_25 VGND VPWR sky130_fd_sc_hd__tapvpwrvgnd_1
Xtap_18_14 VGND VPWR sky130_fd_sc_hd__tapvpwrvgnd_1
Xtap_34_35 VGND VPWR sky130_fd_sc_hd__tapvpwrvgnd_1
Xtap_34_24 VGND VPWR sky130_fd_sc_hd__tapvpwrvgnd_1
XSLICE_16\[1\].RAM16.SLICE\[0\].RAM8.WORD\[4\].W.BYTE\[3\].B.CGAND SLICE_16\[1\].RAM16.SLICE\[0\].RAM8.WORD\[4\].W.BYTE\[0\].B.SEL0
+ SLICE_16\[1\].RAM16.SLICE\[0\].RAM8.WE0_buf\[3\] VGND VGND VPWR VPWR SLICE_16\[1\].RAM16.SLICE\[0\].RAM8.WORD\[4\].W.BYTE\[3\].B.WE0_WIRE
+ sky130_fd_sc_hd__and2_1
Xfill_22_89 VGND VGND VPWR VPWR sky130_fd_sc_hd__decap_12
Xfill_22_78 VGND VPWR sky130_fd_sc_hd__tapvpwrvgnd_1
Xfill_22_67 VGND VGND VPWR VPWR sky130_fd_sc_hd__decap_12
Xfill_22_56 VGND VGND VPWR VPWR sky130_fd_sc_hd__decap_12
Xfill_22_45 VGND VPWR sky130_fd_sc_hd__tapvpwrvgnd_1
Xfill_22_34 VGND VGND VPWR VPWR sky130_fd_sc_hd__decap_12
Xfill_22_23 VGND VGND VPWR VPWR sky130_fd_sc_hd__decap_12
Xfill_22_12 VGND VPWR sky130_fd_sc_hd__tapvpwrvgnd_1
XSLICE_16\[0\].RAM16.SLICE\[0\].RAM8.WORD\[4\].W.BYTE\[1\].B.BIT\[6\].OBUF0 SLICE_16\[0\].RAM16.SLICE\[0\].RAM8.WORD\[4\].W.BYTE\[1\].B.Q_WIRE\[6\]
+ SLICE_16\[0\].RAM16.SLICE\[0\].RAM8.WORD\[4\].W.BYTE\[1\].B.SEL0_B VGND VGND VPWR
+ VPWR SLICE_16\[0\].RAM16.BYTE\[1\].FLOATBUF0\[14\].Z sky130_fd_sc_hd__ebufn_2
Xfill_47_64 VGND VGND VPWR VPWR sky130_fd_sc_hd__decap_12
Xfill_47_53 VGND VGND VPWR VPWR sky130_fd_sc_hd__decap_12
Xfill_47_42 VGND VPWR sky130_fd_sc_hd__tapvpwrvgnd_1
Xfill_47_31 VGND VGND VPWR VPWR sky130_fd_sc_hd__decap_12
Xfill_47_20 VGND VGND VPWR VPWR sky130_fd_sc_hd__decap_12
XSLICE_16\[1\].RAM16.SLICE\[1\].RAM8.WORD\[6\].W.BYTE\[1\].B.BIT\[3\].OBUF0 SLICE_16\[1\].RAM16.SLICE\[1\].RAM8.WORD\[6\].W.BYTE\[1\].B.Q_WIRE\[3\]
+ SLICE_16\[1\].RAM16.SLICE\[1\].RAM8.WORD\[6\].W.BYTE\[1\].B.SEL0_B VGND VGND VPWR
+ VPWR SLICE_16\[1\].RAM16.BYTE\[1\].FLOATBUF0\[11\].Z sky130_fd_sc_hd__ebufn_2
XSLICE_16\[1\].RAM16.SLICE\[1\].RAM8.WORD\[1\].W.BYTE\[3\].B.genblk1.CLKINV SLICE_16\[1\].RAM16.SLICE\[1\].RAM8.WORD\[1\].W.BYTE\[0\].B.CLK
+ VGND VGND VPWR VPWR SLICE_16\[1\].RAM16.SLICE\[1\].RAM8.WORD\[1\].W.BYTE\[3\].B.CLK_B
+ sky130_fd_sc_hd__inv_1
XSLICE_16\[1\].RAM16.SLICE\[1\].RAM8.WORD\[4\].W.BYTE\[1\].B.BIT\[7\].genblk1.STORAGE
+ DIBUF\[15\].X SLICE_16\[1\].RAM16.SLICE\[1\].RAM8.WORD\[4\].W.BYTE\[1\].B.GCLK VGND
+ VGND VPWR VPWR SLICE_16\[1\].RAM16.SLICE\[1\].RAM8.WORD\[4\].W.BYTE\[1\].B.Q_WIRE\[7\]
+ sky130_fd_sc_hd__dlxtp_1
XSLICE_16\[1\].RAM16.SLICE\[0\].RAM8.WORD\[5\].W.BYTE\[3\].B.BIT\[3\].genblk1.STORAGE
+ DIBUF\[27\].X SLICE_16\[1\].RAM16.SLICE\[0\].RAM8.WORD\[5\].W.BYTE\[3\].B.GCLK VGND
+ VGND VPWR VPWR SLICE_16\[1\].RAM16.SLICE\[0\].RAM8.WORD\[5\].W.BYTE\[3\].B.Q_WIRE\[3\]
+ sky130_fd_sc_hd__dlxtp_1
XSLICE_16\[1\].RAM16.SLICE\[0\].RAM8.WORD\[3\].W.BYTE\[1\].B.BIT\[2\].genblk1.STORAGE
+ DIBUF\[10\].X SLICE_16\[1\].RAM16.SLICE\[0\].RAM8.WORD\[3\].W.BYTE\[1\].B.GCLK VGND
+ VGND VPWR VPWR SLICE_16\[1\].RAM16.SLICE\[0\].RAM8.WORD\[3\].W.BYTE\[1\].B.Q_WIRE\[2\]
+ sky130_fd_sc_hd__dlxtp_1
XSLICE_16\[1\].RAM16.SLICE\[0\].RAM8.WORD\[1\].W.BYTE\[0\].B.BIT\[2\].OBUF0 SLICE_16\[1\].RAM16.SLICE\[0\].RAM8.WORD\[1\].W.BYTE\[0\].B.Q_WIRE\[2\]
+ SLICE_16\[1\].RAM16.SLICE\[0\].RAM8.WORD\[1\].W.BYTE\[0\].B.SEL0_B VGND VGND VPWR
+ VPWR SLICE_16\[1\].RAM16.BYTE\[0\].FLOATBUF0\[2\].Z sky130_fd_sc_hd__ebufn_2
XSLICE_16\[0\].RAM16.SLICE\[1\].RAM8.WORD\[7\].W.BYTE\[3\].B.BIT\[4\].genblk1.STORAGE
+ DIBUF\[28\].X SLICE_16\[0\].RAM16.SLICE\[1\].RAM8.WORD\[7\].W.BYTE\[3\].B.GCLK VGND
+ VGND VPWR VPWR SLICE_16\[0\].RAM16.SLICE\[1\].RAM8.WORD\[7\].W.BYTE\[3\].B.Q_WIRE\[4\]
+ sky130_fd_sc_hd__dlxtp_1
Xfill_31_1 VGND VPWR sky130_fd_sc_hd__tapvpwrvgnd_1
XSLICE_16\[1\].RAM16.SLICE\[0\].RAM8.WORD\[5\].W.BYTE\[3\].B.BIT\[5\].OBUF0 SLICE_16\[1\].RAM16.SLICE\[0\].RAM8.WORD\[5\].W.BYTE\[3\].B.Q_WIRE\[5\]
+ SLICE_16\[1\].RAM16.SLICE\[0\].RAM8.WORD\[5\].W.BYTE\[3\].B.SEL0_B VGND VGND VPWR
+ VPWR SLICE_16\[1\].RAM16.BYTE\[3\].FLOATBUF0\[29\].Z sky130_fd_sc_hd__ebufn_2
XSLICE_16\[0\].RAM16.SLICE\[1\].RAM8.WORD\[5\].W.BYTE\[1\].B.BIT\[3\].genblk1.STORAGE
+ DIBUF\[11\].X SLICE_16\[0\].RAM16.SLICE\[1\].RAM8.WORD\[5\].W.BYTE\[1\].B.GCLK VGND
+ VGND VPWR VPWR SLICE_16\[0\].RAM16.SLICE\[1\].RAM8.WORD\[5\].W.BYTE\[1\].B.Q_WIRE\[3\]
+ sky130_fd_sc_hd__dlxtp_1
Xtap_1_19 VGND VPWR sky130_fd_sc_hd__tapvpwrvgnd_1
Xfill_24_0 VGND VPWR sky130_fd_sc_hd__tapvpwrvgnd_1
XSLICE_16\[0\].RAM16.SLICE\[0\].RAM8.WORD\[7\].W.BYTE\[2\].B.BIT\[6\].OBUF0 SLICE_16\[0\].RAM16.SLICE\[0\].RAM8.WORD\[7\].W.BYTE\[2\].B.Q_WIRE\[6\]
+ SLICE_16\[0\].RAM16.SLICE\[0\].RAM8.WORD\[7\].W.BYTE\[2\].B.SEL0_B VGND VGND VPWR
+ VPWR SLICE_16\[0\].RAM16.BYTE\[2\].FLOATBUF0\[22\].Z sky130_fd_sc_hd__ebufn_2
Xtap_39_6 VGND VPWR sky130_fd_sc_hd__tapvpwrvgnd_1
Xtap_29_35 VGND VPWR sky130_fd_sc_hd__tapvpwrvgnd_1
Xtap_29_24 VGND VPWR sky130_fd_sc_hd__tapvpwrvgnd_1
Xtap_29_13 VGND VPWR sky130_fd_sc_hd__tapvpwrvgnd_1
Xfill_17_56 VGND VGND VPWR VPWR sky130_fd_sc_hd__decap_12
Xfill_17_45 VGND VPWR sky130_fd_sc_hd__tapvpwrvgnd_1
Xfill_17_34 VGND VGND VPWR VPWR sky130_fd_sc_hd__decap_12
Xfill_17_23 VGND VGND VPWR VPWR sky130_fd_sc_hd__decap_12
Xfill_17_12 VGND VPWR sky130_fd_sc_hd__tapvpwrvgnd_1
XSLICE_16\[0\].RAM16.SLICE\[1\].RAM8.WORD\[4\].W.CLKBUF SLICE_16\[0\].RAM16.SLICE\[1\].RAM8.CLKBUF.X
+ VGND VGND VPWR VPWR SLICE_16\[0\].RAM16.SLICE\[1\].RAM8.WORD\[4\].W.BYTE\[0\].B.CLK
+ sky130_fd_sc_hd__clkbuf_4
XDo0MUX.M\[1\].DIODE_A1MUX\[11\] Do0MUX.A1\[11\] VGND VGND VPWR VPWR sky130_fd_sc_hd__diode_2
XSLICE_16\[1\].RAM16.SLICE\[1\].RAM8.WORD\[5\].W.BYTE\[2\].B.CGAND SLICE_16\[1\].RAM16.SLICE\[1\].RAM8.WORD\[5\].W.BYTE\[0\].B.SEL0
+ SLICE_16\[1\].RAM16.SLICE\[1\].RAM8.WE0_buf\[2\] VGND VGND VPWR VPWR SLICE_16\[1\].RAM16.SLICE\[1\].RAM8.WORD\[5\].W.BYTE\[2\].B.WE0_WIRE
+ sky130_fd_sc_hd__and2_1
Xfill_17_67 VGND VGND VPWR VPWR sky130_fd_sc_hd__decap_4
XSLICE_16\[1\].RAM16.SLICE\[0\].RAM8.WORD\[4\].W.BYTE\[1\].B.BIT\[2\].OBUF0 SLICE_16\[1\].RAM16.SLICE\[0\].RAM8.WORD\[4\].W.BYTE\[1\].B.Q_WIRE\[2\]
+ SLICE_16\[1\].RAM16.SLICE\[0\].RAM8.WORD\[4\].W.BYTE\[1\].B.SEL0_B VGND VGND VPWR
+ VPWR SLICE_16\[1\].RAM16.BYTE\[1\].FLOATBUF0\[10\].Z sky130_fd_sc_hd__ebufn_2
XSLICE_16\[0\].RAM16.SLICE\[1\].RAM8.WORD\[1\].W.BYTE\[3\].B.BIT\[1\].OBUF0 SLICE_16\[0\].RAM16.SLICE\[1\].RAM8.WORD\[1\].W.BYTE\[3\].B.Q_WIRE\[1\]
+ SLICE_16\[0\].RAM16.SLICE\[1\].RAM8.WORD\[1\].W.BYTE\[3\].B.SEL0_B VGND VGND VPWR
+ VPWR SLICE_16\[0\].RAM16.BYTE\[3\].FLOATBUF0\[25\].Z sky130_fd_sc_hd__ebufn_2
Xfill_44_102 VGND VPWR sky130_fd_sc_hd__tapvpwrvgnd_1
XDEC0.AND1 A0BUF\[4\].X DEC0.EN VGND VGND VPWR VPWR DEC0.SEL\[1\] sky130_fd_sc_hd__and2_2
XSLICE_16\[0\].RAM16.SLICE\[0\].RAM8.WORD\[6\].W.BYTE\[0\].B.BIT\[3\].OBUF0 SLICE_16\[0\].RAM16.SLICE\[0\].RAM8.WORD\[6\].W.BYTE\[0\].B.Q_WIRE\[3\]
+ SLICE_16\[0\].RAM16.SLICE\[0\].RAM8.WORD\[6\].W.BYTE\[0\].B.SEL0_B VGND VGND VPWR
+ VPWR SLICE_16\[0\].RAM16.BYTE\[0\].FLOATBUF0\[3\].Z sky130_fd_sc_hd__ebufn_2
Xfill_8_8 VGND VGND VPWR VPWR sky130_fd_sc_hd__fill_2
Xfill_10_6 VGND VGND VPWR VPWR sky130_fd_sc_hd__decap_6
XSLICE_16\[0\].RAM16.SLICE\[0\].RAM8.WORD\[1\].W.BYTE\[2\].B.genblk1.CLKINV SLICE_16\[0\].RAM16.SLICE\[0\].RAM8.WORD\[1\].W.BYTE\[0\].B.CLK
+ VGND VGND VPWR VPWR SLICE_16\[0\].RAM16.SLICE\[0\].RAM8.WORD\[1\].W.BYTE\[2\].B.CLK_B
+ sky130_fd_sc_hd__inv_1
XSLICE_16\[0\].RAM16.SLICE\[0\].RAM8.WORD\[1\].W.BYTE\[2\].B.DIODE_CLK SLICE_16\[0\].RAM16.SLICE\[0\].RAM8.WORD\[1\].W.BYTE\[0\].B.CLK
+ VGND VGND VPWR VPWR sky130_fd_sc_hd__diode_2
XSLICE_16\[1\].RAM16.SLICE\[1\].RAM8.WORD\[7\].W.BYTE\[2\].B.BIT\[7\].genblk1.STORAGE
+ DIBUF\[23\].X SLICE_16\[1\].RAM16.SLICE\[1\].RAM8.WORD\[7\].W.BYTE\[2\].B.GCLK VGND
+ VGND VPWR VPWR SLICE_16\[1\].RAM16.SLICE\[1\].RAM8.WORD\[7\].W.BYTE\[2\].B.Q_WIRE\[7\]
+ sky130_fd_sc_hd__dlxtp_1
XSLICE_16\[1\].RAM16.SLICE\[1\].RAM8.WORD\[5\].W.BYTE\[0\].B.BIT\[6\].genblk1.STORAGE
+ DIBUF\[6\].X SLICE_16\[1\].RAM16.SLICE\[1\].RAM8.WORD\[5\].W.BYTE\[0\].B.GCLK VGND
+ VGND VPWR VPWR SLICE_16\[1\].RAM16.SLICE\[1\].RAM8.WORD\[5\].W.BYTE\[0\].B.Q_WIRE\[6\]
+ sky130_fd_sc_hd__dlxtp_1
Xtap_15_26 VGND VPWR sky130_fd_sc_hd__tapvpwrvgnd_1
Xtap_15_15 VGND VPWR sky130_fd_sc_hd__tapvpwrvgnd_1
Xtap_31_36 VGND VPWR sky130_fd_sc_hd__tapvpwrvgnd_1
Xtap_31_25 VGND VPWR sky130_fd_sc_hd__tapvpwrvgnd_1
Xtap_31_14 VGND VPWR sky130_fd_sc_hd__tapvpwrvgnd_1
XSLICE_16\[1\].RAM16.SLICE\[0\].RAM8.WORD\[6\].W.BYTE\[2\].B.BIT\[2\].genblk1.STORAGE
+ DIBUF\[18\].X SLICE_16\[1\].RAM16.SLICE\[0\].RAM8.WORD\[6\].W.BYTE\[2\].B.GCLK VGND
+ VGND VPWR VPWR SLICE_16\[1\].RAM16.SLICE\[0\].RAM8.WORD\[6\].W.BYTE\[2\].B.Q_WIRE\[2\]
+ sky130_fd_sc_hd__dlxtp_1
XSLICE_16\[1\].RAM16.SLICE\[0\].RAM8.WORD\[0\].W.BYTE\[3\].B.BIT\[3\].genblk1.STORAGE
+ DIBUF\[27\].X SLICE_16\[1\].RAM16.SLICE\[0\].RAM8.WORD\[0\].W.BYTE\[3\].B.GCLK VGND
+ VGND VPWR VPWR SLICE_16\[1\].RAM16.SLICE\[0\].RAM8.WORD\[0\].W.BYTE\[3\].B.Q_WIRE\[3\]
+ sky130_fd_sc_hd__dlxtp_1
Xtap_37_3 VGND VPWR sky130_fd_sc_hd__tapvpwrvgnd_1
XSLICE_16\[1\].RAM16.SLICE\[0\].RAM8.WORD\[7\].W.BYTE\[2\].B.BIT\[2\].OBUF0 SLICE_16\[1\].RAM16.SLICE\[0\].RAM8.WORD\[7\].W.BYTE\[2\].B.Q_WIRE\[2\]
+ SLICE_16\[1\].RAM16.SLICE\[0\].RAM8.WORD\[7\].W.BYTE\[2\].B.SEL0_B VGND VGND VPWR
+ VPWR SLICE_16\[1\].RAM16.BYTE\[2\].FLOATBUF0\[18\].Z sky130_fd_sc_hd__ebufn_2
XSLICE_16\[1\].RAM16.SLICE\[0\].RAM8.WORD\[4\].W.BYTE\[0\].B.BIT\[1\].genblk1.STORAGE
+ DIBUF\[1\].X SLICE_16\[1\].RAM16.SLICE\[0\].RAM8.WORD\[4\].W.BYTE\[0\].B.GCLK VGND
+ VGND VPWR VPWR SLICE_16\[1\].RAM16.SLICE\[0\].RAM8.WORD\[4\].W.BYTE\[0\].B.Q_WIRE\[1\]
+ sky130_fd_sc_hd__dlxtp_1
XSLICE_16\[0\].RAM16.SLICE\[1\].RAM8.WORD\[2\].W.BYTE\[3\].B.BIT\[4\].genblk1.STORAGE
+ DIBUF\[28\].X SLICE_16\[0\].RAM16.SLICE\[1\].RAM8.WORD\[2\].W.BYTE\[3\].B.GCLK VGND
+ VGND VPWR VPWR SLICE_16\[0\].RAM16.SLICE\[1\].RAM8.WORD\[2\].W.BYTE\[3\].B.Q_WIRE\[4\]
+ sky130_fd_sc_hd__dlxtp_1
XSLICE_16\[0\].RAM16.SLICE\[1\].RAM8.WORD\[6\].W.BYTE\[0\].B.BIT\[2\].genblk1.STORAGE
+ DIBUF\[2\].X SLICE_16\[0\].RAM16.SLICE\[1\].RAM8.WORD\[6\].W.BYTE\[0\].B.GCLK VGND
+ VGND VPWR VPWR SLICE_16\[0\].RAM16.SLICE\[1\].RAM8.WORD\[6\].W.BYTE\[0\].B.Q_WIRE\[2\]
+ sky130_fd_sc_hd__dlxtp_1
XSLICE_16\[0\].RAM16.SLICE\[1\].RAM8.WORD\[0\].W.BYTE\[1\].B.BIT\[3\].genblk1.STORAGE
+ DIBUF\[11\].X SLICE_16\[0\].RAM16.SLICE\[1\].RAM8.WORD\[0\].W.BYTE\[1\].B.GCLK VGND
+ VGND VPWR VPWR SLICE_16\[0\].RAM16.SLICE\[1\].RAM8.WORD\[0\].W.BYTE\[1\].B.Q_WIRE\[3\]
+ sky130_fd_sc_hd__dlxtp_1
Xfill_44_54 VGND VPWR sky130_fd_sc_hd__tapvpwrvgnd_1
Xfill_44_43 VGND VGND VPWR VPWR sky130_fd_sc_hd__decap_12
Xfill_44_32 VGND VGND VPWR VPWR sky130_fd_sc_hd__decap_12
Xfill_44_21 VGND VPWR sky130_fd_sc_hd__tapvpwrvgnd_1
Xfill_44_10 VGND VGND VPWR VPWR sky130_fd_sc_hd__decap_12
XSLICE_16\[0\].RAM16.SLICE\[1\].RAM8.WORD\[1\].W.BYTE\[1\].B.BIT\[6\].OBUF0 SLICE_16\[0\].RAM16.SLICE\[1\].RAM8.WORD\[1\].W.BYTE\[1\].B.Q_WIRE\[6\]
+ SLICE_16\[0\].RAM16.SLICE\[1\].RAM8.WORD\[1\].W.BYTE\[1\].B.SEL0_B VGND VGND VPWR
+ VPWR SLICE_16\[0\].RAM16.BYTE\[1\].FLOATBUF0\[14\].Z sky130_fd_sc_hd__ebufn_2
Xfill_44_98 VGND VGND VPWR VPWR sky130_fd_sc_hd__decap_12
Xfill_44_87 VGND VPWR sky130_fd_sc_hd__tapvpwrvgnd_1
Xfill_44_76 VGND VGND VPWR VPWR sky130_fd_sc_hd__decap_12
Xfill_44_65 VGND VGND VPWR VPWR sky130_fd_sc_hd__decap_12
XDIBUF\[18\].__cell__ Di0[18] VGND VGND VPWR VPWR DIBUF\[18\].X sky130_fd_sc_hd__clkbuf_16
XSLICE_16\[0\].RAM16.SLICE\[0\].RAM8.WORD\[4\].W.BYTE\[3\].B.genblk1.CLKINV SLICE_16\[0\].RAM16.SLICE\[0\].RAM8.WORD\[4\].W.BYTE\[0\].B.CLK
+ VGND VGND VPWR VPWR SLICE_16\[0\].RAM16.SLICE\[0\].RAM8.WORD\[4\].W.BYTE\[3\].B.CLK_B
+ sky130_fd_sc_hd__inv_1
XSLICE_16\[1\].RAM16.SLICE\[1\].RAM8.WORD\[2\].W.BYTE\[3\].B.BIT\[5\].OBUF0 SLICE_16\[1\].RAM16.SLICE\[1\].RAM8.WORD\[2\].W.BYTE\[3\].B.Q_WIRE\[5\]
+ SLICE_16\[1\].RAM16.SLICE\[1\].RAM8.WORD\[2\].W.BYTE\[3\].B.SEL0_B VGND VGND VPWR
+ VPWR SLICE_16\[1\].RAM16.BYTE\[3\].FLOATBUF0\[29\].Z sky130_fd_sc_hd__ebufn_2
XSLICE_16\[1\].RAM16.SLICE\[1\].RAM8.WORD\[1\].W.BYTE\[3\].B.genblk1.CG SLICE_16\[1\].RAM16.SLICE\[1\].RAM8.WORD\[1\].W.BYTE\[3\].B.CLK_B
+ SLICE_16\[1\].RAM16.SLICE\[1\].RAM8.WORD\[1\].W.BYTE\[3\].B.WE0_WIRE VGND VGND VPWR
+ VPWR SLICE_16\[1\].RAM16.SLICE\[1\].RAM8.WORD\[1\].W.BYTE\[3\].B.GCLK sky130_fd_sc_hd__dlclkp_1
Xtap_7_18 VGND VPWR sky130_fd_sc_hd__tapvpwrvgnd_1
Xtap_7_29 VGND VPWR sky130_fd_sc_hd__tapvpwrvgnd_1
Xfill_6_5 VGND VPWR sky130_fd_sc_hd__tapvpwrvgnd_1
XSLICE_16\[1\].RAM16.SLICE\[0\].RAM8.WORD\[0\].W.BYTE\[2\].B.CGAND SLICE_16\[1\].RAM16.SLICE\[0\].RAM8.WORD\[0\].W.BYTE\[0\].B.SEL0
+ SLICE_16\[1\].RAM16.SLICE\[0\].RAM8.WE0_buf\[2\] VGND VGND VPWR VPWR SLICE_16\[1\].RAM16.SLICE\[0\].RAM8.WORD\[0\].W.BYTE\[2\].B.WE0_WIRE
+ sky130_fd_sc_hd__and2_1
Xtap_26_25 VGND VPWR sky130_fd_sc_hd__tapvpwrvgnd_1
Xtap_26_14 VGND VPWR sky130_fd_sc_hd__tapvpwrvgnd_1
Xtap_23_9 VGND VPWR sky130_fd_sc_hd__tapvpwrvgnd_1
Xtap_16_8 VGND VPWR sky130_fd_sc_hd__tapvpwrvgnd_1
XSLICE_16\[1\].RAM16.SLICE\[1\].RAM8.WORD\[0\].W.BYTE\[3\].B.DIODE_CLK SLICE_16\[1\].RAM16.SLICE\[1\].RAM8.WORD\[0\].W.BYTE\[0\].B.CLK
+ VGND VGND VPWR VPWR sky130_fd_sc_hd__diode_2
XSLICE_16\[1\].RAM16.SLICE\[0\].RAM8.WORD\[7\].W.BYTE\[0\].B.BIT\[7\].OBUF0 SLICE_16\[1\].RAM16.SLICE\[0\].RAM8.WORD\[7\].W.BYTE\[0\].B.Q_WIRE\[7\]
+ SLICE_16\[1\].RAM16.SLICE\[0\].RAM8.WORD\[7\].W.BYTE\[0\].B.SEL0_B VGND VGND VPWR
+ VPWR SLICE_16\[1\].RAM16.BYTE\[0\].FLOATBUF0\[7\].Z sky130_fd_sc_hd__ebufn_2
XSLICE_16\[0\].RAM16.SLICE\[1\].RAM8.WORD\[4\].W.BYTE\[2\].B.BIT\[6\].OBUF0 SLICE_16\[0\].RAM16.SLICE\[1\].RAM8.WORD\[4\].W.BYTE\[2\].B.Q_WIRE\[6\]
+ SLICE_16\[0\].RAM16.SLICE\[1\].RAM8.WORD\[4\].W.BYTE\[2\].B.SEL0_B VGND VGND VPWR
+ VPWR SLICE_16\[0\].RAM16.BYTE\[2\].FLOATBUF0\[22\].Z sky130_fd_sc_hd__ebufn_2
Xtap_9_7 VGND VPWR sky130_fd_sc_hd__tapvpwrvgnd_1
XSLICE_16\[1\].RAM16.SLICE\[0\].RAM8.WORD\[6\].W.BYTE\[2\].B.DIODE_CLK SLICE_16\[1\].RAM16.SLICE\[0\].RAM8.WORD\[6\].W.BYTE\[0\].B.CLK
+ VGND VGND VPWR VPWR sky130_fd_sc_hd__diode_2
Xtap_35_0 VGND VPWR sky130_fd_sc_hd__tapvpwrvgnd_1
XSLICE_16\[1\].RAM16.SLICE\[1\].RAM8.WORD\[2\].W.BYTE\[2\].B.BIT\[7\].genblk1.STORAGE
+ DIBUF\[23\].X SLICE_16\[1\].RAM16.SLICE\[1\].RAM8.WORD\[2\].W.BYTE\[2\].B.GCLK VGND
+ VGND VPWR VPWR SLICE_16\[1\].RAM16.SLICE\[1\].RAM8.WORD\[2\].W.BYTE\[2\].B.Q_WIRE\[7\]
+ sky130_fd_sc_hd__dlxtp_1
Xfill_39_65 VGND VGND VPWR VPWR sky130_fd_sc_hd__fill_2
Xfill_39_54 VGND VPWR sky130_fd_sc_hd__tapvpwrvgnd_1
Xfill_39_43 VGND VGND VPWR VPWR sky130_fd_sc_hd__decap_12
Xfill_39_32 VGND VGND VPWR VPWR sky130_fd_sc_hd__decap_12
Xfill_39_21 VGND VPWR sky130_fd_sc_hd__tapvpwrvgnd_1
Xfill_39_10 VGND VGND VPWR VPWR sky130_fd_sc_hd__decap_12
XSLICE_16\[1\].RAM16.SLICE\[1\].RAM8.WORD\[1\].W.BYTE\[1\].B.BIT\[2\].OBUF0 SLICE_16\[1\].RAM16.SLICE\[1\].RAM8.WORD\[1\].W.BYTE\[1\].B.Q_WIRE\[2\]
+ SLICE_16\[1\].RAM16.SLICE\[1\].RAM8.WORD\[1\].W.BYTE\[1\].B.SEL0_B VGND VGND VPWR
+ VPWR SLICE_16\[1\].RAM16.BYTE\[1\].FLOATBUF0\[10\].Z sky130_fd_sc_hd__ebufn_2
XSLICE_16\[1\].RAM16.SLICE\[1\].RAM8.WORD\[0\].W.BYTE\[0\].B.BIT\[6\].genblk1.STORAGE
+ DIBUF\[6\].X SLICE_16\[1\].RAM16.SLICE\[1\].RAM8.WORD\[0\].W.BYTE\[0\].B.GCLK VGND
+ VGND VPWR VPWR SLICE_16\[1\].RAM16.SLICE\[1\].RAM8.WORD\[0\].W.BYTE\[0\].B.Q_WIRE\[6\]
+ sky130_fd_sc_hd__dlxtp_1
XSLICE_16\[1\].RAM16.SLICE\[0\].RAM8.WORD\[7\].W.BYTE\[1\].B.BIT\[1\].genblk1.STORAGE
+ DIBUF\[9\].X SLICE_16\[1\].RAM16.SLICE\[0\].RAM8.WORD\[7\].W.BYTE\[1\].B.GCLK VGND
+ VGND VPWR VPWR SLICE_16\[1\].RAM16.SLICE\[0\].RAM8.WORD\[7\].W.BYTE\[1\].B.Q_WIRE\[1\]
+ sky130_fd_sc_hd__dlxtp_1
XSLICE_16\[1\].RAM16.SLICE\[0\].RAM8.WORD\[1\].W.BYTE\[2\].B.BIT\[2\].genblk1.STORAGE
+ DIBUF\[18\].X SLICE_16\[1\].RAM16.SLICE\[0\].RAM8.WORD\[1\].W.BYTE\[2\].B.GCLK VGND
+ VGND VPWR VPWR SLICE_16\[1\].RAM16.SLICE\[0\].RAM8.WORD\[1\].W.BYTE\[2\].B.Q_WIRE\[2\]
+ sky130_fd_sc_hd__dlxtp_1
XSLICE_16\[0\].RAM16.SLICE\[1\].RAM8.WORD\[3\].W.BYTE\[2\].B.DIODE_CLK SLICE_16\[0\].RAM16.SLICE\[1\].RAM8.WORD\[3\].W.BYTE\[0\].B.CLK
+ VGND VGND VPWR VPWR sky130_fd_sc_hd__diode_2
XSLICE_16\[0\].RAM16.SLICE\[1\].RAM8.WORD\[3\].W.BYTE\[2\].B.BIT\[3\].genblk1.STORAGE
+ DIBUF\[19\].X SLICE_16\[0\].RAM16.SLICE\[1\].RAM8.WORD\[3\].W.BYTE\[2\].B.GCLK VGND
+ VGND VPWR VPWR SLICE_16\[0\].RAM16.SLICE\[1\].RAM8.WORD\[3\].W.BYTE\[2\].B.Q_WIRE\[3\]
+ sky130_fd_sc_hd__dlxtp_1
XSLICE_16\[0\].RAM16.SLICE\[1\].RAM8.WORD\[3\].W.BYTE\[0\].B.BIT\[3\].OBUF0 SLICE_16\[0\].RAM16.SLICE\[1\].RAM8.WORD\[3\].W.BYTE\[0\].B.Q_WIRE\[3\]
+ SLICE_16\[0\].RAM16.SLICE\[1\].RAM8.WORD\[3\].W.BYTE\[0\].B.SEL0_B VGND VGND VPWR
+ VPWR SLICE_16\[0\].RAM16.BYTE\[0\].FLOATBUF0\[3\].Z sky130_fd_sc_hd__ebufn_2
XSLICE_16\[1\].RAM16.Do0_REG.OUTREG_BYTE\[2\].DIODE\[7\] SLICE_16\[1\].RAM16.BYTE\[2\].FLOATBUF0\[23\].Z
+ VGND VGND VPWR VPWR sky130_fd_sc_hd__diode_2
XSLICE_16\[0\].RAM16.SLICE\[1\].RAM8.WORD\[1\].W.BYTE\[0\].B.BIT\[2\].genblk1.STORAGE
+ DIBUF\[2\].X SLICE_16\[0\].RAM16.SLICE\[1\].RAM8.WORD\[1\].W.BYTE\[0\].B.GCLK VGND
+ VGND VPWR VPWR SLICE_16\[0\].RAM16.SLICE\[1\].RAM8.WORD\[1\].W.BYTE\[0\].B.Q_WIRE\[2\]
+ sky130_fd_sc_hd__dlxtp_1
XSLICE_16\[1\].RAM16.SLICE\[0\].RAM8.WORD\[6\].W.BYTE\[3\].B.SEL0INV SLICE_16\[1\].RAM16.SLICE\[0\].RAM8.WORD\[6\].W.BYTE\[0\].B.SEL0
+ VGND VGND VPWR VPWR SLICE_16\[1\].RAM16.SLICE\[0\].RAM8.WORD\[6\].W.BYTE\[3\].B.SEL0_B
+ sky130_fd_sc_hd__inv_1
XSLICE_16\[1\].RAM16.SLICE\[0\].RAM8.WORD\[0\].W.BYTE\[3\].B.BIT\[4\].OBUF0 SLICE_16\[1\].RAM16.SLICE\[0\].RAM8.WORD\[0\].W.BYTE\[3\].B.Q_WIRE\[4\]
+ SLICE_16\[1\].RAM16.SLICE\[0\].RAM8.WORD\[0\].W.BYTE\[3\].B.SEL0_B VGND VGND VPWR
+ VPWR SLICE_16\[1\].RAM16.BYTE\[3\].FLOATBUF0\[28\].Z sky130_fd_sc_hd__ebufn_2
XSLICE_16\[0\].RAM16.SLICE\[1\].RAM8.WORD\[7\].W.BYTE\[3\].B.BIT\[6\].OBUF0 SLICE_16\[0\].RAM16.SLICE\[1\].RAM8.WORD\[7\].W.BYTE\[3\].B.Q_WIRE\[6\]
+ SLICE_16\[0\].RAM16.SLICE\[1\].RAM8.WORD\[7\].W.BYTE\[3\].B.SEL0_B VGND VGND VPWR
+ VPWR SLICE_16\[0\].RAM16.BYTE\[3\].FLOATBUF0\[30\].Z sky130_fd_sc_hd__ebufn_2
Xfill_4_2 VGND VGND VPWR VPWR sky130_fd_sc_hd__fill_2
Xtap_12_27 VGND VPWR sky130_fd_sc_hd__tapvpwrvgnd_1
Xtap_12_16 VGND VPWR sky130_fd_sc_hd__tapvpwrvgnd_1
XSLICE_16\[0\].RAM16.SLICE\[0\].RAM8.WORD\[2\].W.BYTE\[2\].B.BIT\[5\].OBUF0 SLICE_16\[0\].RAM16.SLICE\[0\].RAM8.WORD\[2\].W.BYTE\[2\].B.Q_WIRE\[5\]
+ SLICE_16\[0\].RAM16.SLICE\[0\].RAM8.WORD\[2\].W.BYTE\[2\].B.SEL0_B VGND VGND VPWR
+ VPWR SLICE_16\[0\].RAM16.BYTE\[2\].FLOATBUF0\[21\].Z sky130_fd_sc_hd__ebufn_2
Xtap_37_35 VGND VPWR sky130_fd_sc_hd__tapvpwrvgnd_1
Xtap_37_24 VGND VPWR sky130_fd_sc_hd__tapvpwrvgnd_1
Xtap_37_13 VGND VPWR sky130_fd_sc_hd__tapvpwrvgnd_1
XSLICE_16\[1\].RAM16.SLICE\[1\].RAM8.WORD\[4\].W.BYTE\[2\].B.BIT\[2\].OBUF0 SLICE_16\[1\].RAM16.SLICE\[1\].RAM8.WORD\[4\].W.BYTE\[2\].B.Q_WIRE\[2\]
+ SLICE_16\[1\].RAM16.SLICE\[1\].RAM8.WORD\[4\].W.BYTE\[2\].B.SEL0_B VGND VGND VPWR
+ VPWR SLICE_16\[1\].RAM16.BYTE\[2\].FLOATBUF0\[18\].Z sky130_fd_sc_hd__ebufn_2
XSLICE_16\[1\].RAM16.SLICE\[1\].RAM8.WORD\[1\].W.BYTE\[1\].B.CGAND SLICE_16\[1\].RAM16.SLICE\[1\].RAM8.WORD\[1\].W.BYTE\[0\].B.SEL0
+ SLICE_16\[1\].RAM16.SLICE\[1\].RAM8.WE0_buf\[1\] VGND VGND VPWR VPWR SLICE_16\[1\].RAM16.SLICE\[1\].RAM8.WORD\[1\].W.BYTE\[1\].B.WE0_WIRE
+ sky130_fd_sc_hd__and2_1
Xtap_14_5 VGND VPWR sky130_fd_sc_hd__tapvpwrvgnd_1
Xtap_7_4 VGND VPWR sky130_fd_sc_hd__tapvpwrvgnd_1
XSLICE_16\[0\].RAM16.SLICE\[1\].RAM8.WEBUF\[1\].__cell__ SLICE_16\[0\].RAM16.SLICE\[0\].RAM8.WE0\[1\]
+ VGND VGND VPWR VPWR SLICE_16\[0\].RAM16.SLICE\[1\].RAM8.WE0_buf\[1\] sky130_fd_sc_hd__clkbuf_2
XSLICE_16\[0\].RAM16.WEBUF\[0\].__cell__ SLICE_16\[0\].RAM16.WE0\[0\] VGND VGND VPWR
+ VPWR SLICE_16\[0\].RAM16.SLICE\[0\].RAM8.WE0\[0\] sky130_fd_sc_hd__clkbuf_2
Xfill_41_99 VGND VPWR sky130_fd_sc_hd__tapvpwrvgnd_1
Xfill_41_88 VGND VGND VPWR VPWR sky130_fd_sc_hd__decap_12
Xfill_41_77 VGND VGND VPWR VPWR sky130_fd_sc_hd__decap_12
Xfill_41_66 VGND VPWR sky130_fd_sc_hd__tapvpwrvgnd_1
Xfill_41_55 VGND VGND VPWR VPWR sky130_fd_sc_hd__decap_12
Xfill_41_44 VGND VGND VPWR VPWR sky130_fd_sc_hd__decap_12
Xfill_41_33 VGND VPWR sky130_fd_sc_hd__tapvpwrvgnd_1
Xfill_41_22 VGND VGND VPWR VPWR sky130_fd_sc_hd__decap_12
Xfill_41_11 VGND VGND VPWR VPWR sky130_fd_sc_hd__decap_12
XSLICE_16\[0\].RAM16.SLICE\[1\].RAM8.WORD\[6\].W.BYTE\[1\].B.BIT\[3\].OBUF0 SLICE_16\[0\].RAM16.SLICE\[1\].RAM8.WORD\[6\].W.BYTE\[1\].B.Q_WIRE\[3\]
+ SLICE_16\[0\].RAM16.SLICE\[1\].RAM8.WORD\[6\].W.BYTE\[1\].B.SEL0_B VGND VGND VPWR
+ VPWR SLICE_16\[0\].RAM16.BYTE\[1\].FLOATBUF0\[11\].Z sky130_fd_sc_hd__ebufn_2
XSLICE_16\[0\].RAM16.SLICE\[1\].RAM8.WORD\[1\].W.BYTE\[3\].B.genblk1.CLKINV SLICE_16\[0\].RAM16.SLICE\[1\].RAM8.WORD\[1\].W.BYTE\[0\].B.CLK
+ VGND VGND VPWR VPWR SLICE_16\[0\].RAM16.SLICE\[1\].RAM8.WORD\[1\].W.BYTE\[3\].B.CLK_B
+ sky130_fd_sc_hd__inv_1
Xfill_42_9 VGND VPWR sky130_fd_sc_hd__tapvpwrvgnd_1
Xfill_28_7 VGND VPWR sky130_fd_sc_hd__tapvpwrvgnd_1
XSLICE_16\[1\].RAM16.SLICE\[1\].RAM8.WORD\[5\].W.BYTE\[3\].B.BIT\[7\].genblk1.STORAGE
+ DIBUF\[31\].X SLICE_16\[1\].RAM16.SLICE\[1\].RAM8.WORD\[5\].W.BYTE\[3\].B.GCLK VGND
+ VGND VPWR VPWR SLICE_16\[1\].RAM16.SLICE\[1\].RAM8.WORD\[5\].W.BYTE\[3\].B.Q_WIRE\[7\]
+ sky130_fd_sc_hd__dlxtp_1
XSLICE_16\[0\].RAM16.SLICE\[0\].RAM8.WORD\[1\].W.BYTE\[0\].B.BIT\[2\].OBUF0 SLICE_16\[0\].RAM16.SLICE\[0\].RAM8.WORD\[1\].W.BYTE\[0\].B.Q_WIRE\[2\]
+ SLICE_16\[0\].RAM16.SLICE\[0\].RAM8.WORD\[1\].W.BYTE\[0\].B.SEL0_B VGND VGND VPWR
+ VPWR SLICE_16\[0\].RAM16.BYTE\[0\].FLOATBUF0\[2\].Z sky130_fd_sc_hd__ebufn_2
XSLICE_16\[1\].RAM16.SLICE\[1\].RAM8.WORD\[3\].W.BYTE\[1\].B.BIT\[6\].genblk1.STORAGE
+ DIBUF\[14\].X SLICE_16\[1\].RAM16.SLICE\[1\].RAM8.WORD\[3\].W.BYTE\[1\].B.GCLK VGND
+ VGND VPWR VPWR SLICE_16\[1\].RAM16.SLICE\[1\].RAM8.WORD\[3\].W.BYTE\[1\].B.Q_WIRE\[6\]
+ sky130_fd_sc_hd__dlxtp_1
Xtap_4_19 VGND VPWR sky130_fd_sc_hd__tapvpwrvgnd_1
XSLICE_16\[0\].RAM16.SLICE\[0\].RAM8.WORD\[5\].W.BYTE\[3\].B.BIT\[5\].OBUF0 SLICE_16\[0\].RAM16.SLICE\[0\].RAM8.WORD\[5\].W.BYTE\[3\].B.Q_WIRE\[5\]
+ SLICE_16\[0\].RAM16.SLICE\[0\].RAM8.WORD\[5\].W.BYTE\[3\].B.SEL0_B VGND VGND VPWR
+ VPWR SLICE_16\[0\].RAM16.BYTE\[3\].FLOATBUF0\[29\].Z sky130_fd_sc_hd__ebufn_2
XSLICE_16\[1\].RAM16.SLICE\[1\].RAM8.WORD\[7\].W.BYTE\[3\].B.BIT\[2\].OBUF0 SLICE_16\[1\].RAM16.SLICE\[1\].RAM8.WORD\[7\].W.BYTE\[3\].B.Q_WIRE\[2\]
+ SLICE_16\[1\].RAM16.SLICE\[1\].RAM8.WORD\[7\].W.BYTE\[3\].B.SEL0_B VGND VGND VPWR
+ VPWR SLICE_16\[1\].RAM16.BYTE\[3\].FLOATBUF0\[26\].Z sky130_fd_sc_hd__ebufn_2
XSLICE_16\[1\].RAM16.SLICE\[0\].RAM8.WORD\[4\].W.BYTE\[3\].B.BIT\[2\].genblk1.STORAGE
+ DIBUF\[26\].X SLICE_16\[1\].RAM16.SLICE\[0\].RAM8.WORD\[4\].W.BYTE\[3\].B.GCLK VGND
+ VGND VPWR VPWR SLICE_16\[1\].RAM16.SLICE\[0\].RAM8.WORD\[4\].W.BYTE\[3\].B.Q_WIRE\[2\]
+ sky130_fd_sc_hd__dlxtp_1
XSLICE_16\[0\].RAM16.SLICE\[1\].RAM8.WORD\[3\].W.BYTE\[3\].B.CGAND SLICE_16\[0\].RAM16.SLICE\[1\].RAM8.WORD\[3\].W.BYTE\[0\].B.SEL0
+ SLICE_16\[0\].RAM16.SLICE\[1\].RAM8.WE0_buf\[3\] VGND VGND VPWR VPWR SLICE_16\[0\].RAM16.SLICE\[1\].RAM8.WORD\[3\].W.BYTE\[3\].B.WE0_WIRE
+ sky130_fd_sc_hd__and2_1
XSLICE_16\[1\].RAM16.SLICE\[0\].RAM8.WORD\[2\].W.BYTE\[1\].B.BIT\[1\].genblk1.STORAGE
+ DIBUF\[9\].X SLICE_16\[1\].RAM16.SLICE\[0\].RAM8.WORD\[2\].W.BYTE\[1\].B.GCLK VGND
+ VGND VPWR VPWR SLICE_16\[1\].RAM16.SLICE\[0\].RAM8.WORD\[2\].W.BYTE\[1\].B.Q_WIRE\[1\]
+ sky130_fd_sc_hd__dlxtp_1
Xtap_23_37 VGND VPWR sky130_fd_sc_hd__tapvpwrvgnd_1
Xtap_23_26 VGND VPWR sky130_fd_sc_hd__tapvpwrvgnd_1
Xtap_23_15 VGND VPWR sky130_fd_sc_hd__tapvpwrvgnd_1
XSLICE_16\[0\].RAM16.SLICE\[1\].RAM8.WORD\[6\].W.BYTE\[3\].B.BIT\[3\].genblk1.STORAGE
+ DIBUF\[27\].X SLICE_16\[0\].RAM16.SLICE\[1\].RAM8.WORD\[6\].W.BYTE\[3\].B.GCLK VGND
+ VGND VPWR VPWR SLICE_16\[0\].RAM16.SLICE\[1\].RAM8.WORD\[6\].W.BYTE\[3\].B.Q_WIRE\[3\]
+ sky130_fd_sc_hd__dlxtp_1
XSLICE_16\[0\].RAM16.SLICE\[1\].RAM8.WORD\[4\].W.BYTE\[1\].B.BIT\[2\].genblk1.STORAGE
+ DIBUF\[10\].X SLICE_16\[0\].RAM16.SLICE\[1\].RAM8.WORD\[4\].W.BYTE\[1\].B.GCLK VGND
+ VGND VPWR VPWR SLICE_16\[0\].RAM16.SLICE\[1\].RAM8.WORD\[4\].W.BYTE\[1\].B.Q_WIRE\[2\]
+ sky130_fd_sc_hd__dlxtp_1
XSLICE_16\[1\].RAM16.SLICE\[1\].RAM8.WORD\[4\].W.BYTE\[0\].B.BIT\[7\].OBUF0 SLICE_16\[1\].RAM16.SLICE\[1\].RAM8.WORD\[4\].W.BYTE\[0\].B.Q_WIRE\[7\]
+ SLICE_16\[1\].RAM16.SLICE\[1\].RAM8.WORD\[4\].W.BYTE\[0\].B.SEL0_B VGND VGND VPWR
+ VPWR SLICE_16\[1\].RAM16.BYTE\[0\].FLOATBUF0\[7\].Z sky130_fd_sc_hd__ebufn_2
XSLICE_16\[1\].RAM16.SLICE\[0\].RAM8.WORD\[2\].W.BYTE\[2\].B.BIT\[1\].OBUF0 SLICE_16\[1\].RAM16.SLICE\[0\].RAM8.WORD\[2\].W.BYTE\[2\].B.Q_WIRE\[1\]
+ SLICE_16\[1\].RAM16.SLICE\[0\].RAM8.WORD\[2\].W.BYTE\[2\].B.SEL0_B VGND VGND VPWR
+ VPWR SLICE_16\[1\].RAM16.BYTE\[2\].FLOATBUF0\[17\].Z sky130_fd_sc_hd__ebufn_2
XSLICE_16\[0\].RAM16.Do0_REG.OUTREG_BYTE\[3\].Do_FF\[5\] SLICE_16\[0\].RAM16.Do0_REG.CLKBUF\[3\]
+ SLICE_16\[0\].RAM16.BYTE\[3\].FLOATBUF0\[29\].Z VGND VGND VPWR VPWR Do0MUX.A0\[29\]
+ sky130_fd_sc_hd__dfxtp_1
Xtap_12_2 VGND VPWR sky130_fd_sc_hd__tapvpwrvgnd_1
Xtap_5_1 VGND VPWR sky130_fd_sc_hd__tapvpwrvgnd_1
XSLICE_16\[0\].RAM16.SLICE\[0\].RAM8.WORD\[4\].W.BYTE\[1\].B.BIT\[2\].OBUF0 SLICE_16\[0\].RAM16.SLICE\[0\].RAM8.WORD\[4\].W.BYTE\[1\].B.Q_WIRE\[2\]
+ SLICE_16\[0\].RAM16.SLICE\[0\].RAM8.WORD\[4\].W.BYTE\[1\].B.SEL0_B VGND VGND VPWR
+ VPWR SLICE_16\[0\].RAM16.BYTE\[1\].FLOATBUF0\[10\].Z sky130_fd_sc_hd__ebufn_2
XSLICE_16\[0\].RAM16.SLICE\[0\].RAM8.WEBUF\[3\].__cell__ SLICE_16\[0\].RAM16.SLICE\[0\].RAM8.WE0\[3\]
+ VGND VGND VPWR VPWR SLICE_16\[0\].RAM16.SLICE\[0\].RAM8.WE0_buf\[3\] sky130_fd_sc_hd__clkbuf_2
XSLICE_16\[0\].RAM16.SLICE\[0\].RAM8.WORD\[7\].W.BYTE\[0\].B.BIT\[7\].genblk1.STORAGE
+ DIBUF\[7\].X SLICE_16\[0\].RAM16.SLICE\[0\].RAM8.WORD\[7\].W.BYTE\[0\].B.GCLK VGND
+ VGND VPWR VPWR SLICE_16\[0\].RAM16.SLICE\[0\].RAM8.WORD\[7\].W.BYTE\[0\].B.Q_WIRE\[7\]
+ sky130_fd_sc_hd__dlxtp_1
Xfill_40_6 VGND VPWR sky130_fd_sc_hd__tapvpwrvgnd_1
XSLICE_16\[1\].RAM16.BYTE\[2\].FLOATBUF0\[17\].__cell__ SLICE_16\[1\].RAM16.BYTE\[2\].FLOATBUF0\[16\].A
+ SLICE_16\[1\].RAM16.BYTE\[2\].FLOATBUF0\[16\].TE_B VGND VGND VPWR VPWR SLICE_16\[1\].RAM16.BYTE\[2\].FLOATBUF0\[17\].Z
+ sky130_fd_sc_hd__ebufn_2
Xfill_33_5 VGND VGND VPWR VPWR sky130_fd_sc_hd__decap_6
Xfill_26_4 VGND VGND VPWR VPWR sky130_fd_sc_hd__decap_4
Xfill_19_3 VGND VPWR sky130_fd_sc_hd__tapvpwrvgnd_1
XSLICE_16\[0\].RAM16.SLICE\[0\].RAM8.WORD\[7\].W.BYTE\[0\].B.CGAND SLICE_16\[0\].RAM16.SLICE\[0\].RAM8.WORD\[7\].W.BYTE\[0\].B.SEL0
+ SLICE_16\[0\].RAM16.SLICE\[0\].RAM8.WE0_buf\[0\] VGND VGND VPWR VPWR SLICE_16\[0\].RAM16.SLICE\[0\].RAM8.WORD\[7\].W.BYTE\[0\].B.WE0_WIRE
+ sky130_fd_sc_hd__and2_1
XSLICE_16\[1\].RAM16.SLICE\[1\].RAM8.WORD\[7\].W.BYTE\[1\].B.BIT\[7\].OBUF0 SLICE_16\[1\].RAM16.SLICE\[1\].RAM8.WORD\[7\].W.BYTE\[1\].B.Q_WIRE\[7\]
+ SLICE_16\[1\].RAM16.SLICE\[1\].RAM8.WORD\[7\].W.BYTE\[1\].B.SEL0_B VGND VGND VPWR
+ VPWR SLICE_16\[1\].RAM16.BYTE\[1\].FLOATBUF0\[15\].Z sky130_fd_sc_hd__ebufn_2
XSLICE_16\[1\].RAM16.SLICE\[0\].RAM8.WORD\[5\].W.BYTE\[3\].B.BIT\[1\].OBUF0 SLICE_16\[1\].RAM16.SLICE\[0\].RAM8.WORD\[5\].W.BYTE\[3\].B.Q_WIRE\[1\]
+ SLICE_16\[1\].RAM16.SLICE\[0\].RAM8.WORD\[5\].W.BYTE\[3\].B.SEL0_B VGND VGND VPWR
+ VPWR SLICE_16\[1\].RAM16.BYTE\[3\].FLOATBUF0\[25\].Z sky130_fd_sc_hd__ebufn_2
Xtap_18_26 VGND VPWR sky130_fd_sc_hd__tapvpwrvgnd_1
Xtap_18_15 VGND VPWR sky130_fd_sc_hd__tapvpwrvgnd_1
XSLICE_16\[0\].RAM16.SLICE\[1\].RAM8.WORD\[0\].W.BYTE\[3\].B.genblk1.CG SLICE_16\[0\].RAM16.SLICE\[1\].RAM8.WORD\[0\].W.BYTE\[3\].B.CLK_B
+ SLICE_16\[0\].RAM16.SLICE\[1\].RAM8.WORD\[0\].W.BYTE\[3\].B.WE0_WIRE VGND VGND VPWR
+ VPWR SLICE_16\[0\].RAM16.SLICE\[1\].RAM8.WORD\[0\].W.BYTE\[3\].B.GCLK sky130_fd_sc_hd__dlclkp_1
Xtap_34_25 VGND VPWR sky130_fd_sc_hd__tapvpwrvgnd_1
Xtap_34_14 VGND VPWR sky130_fd_sc_hd__tapvpwrvgnd_1
XSLICE_16\[1\].RAM16.SLICE\[0\].RAM8.WORD\[2\].W.BYTE\[0\].B.BIT\[6\].OBUF0 SLICE_16\[1\].RAM16.SLICE\[0\].RAM8.WORD\[2\].W.BYTE\[0\].B.Q_WIRE\[6\]
+ SLICE_16\[1\].RAM16.SLICE\[0\].RAM8.WORD\[2\].W.BYTE\[0\].B.SEL0_B VGND VGND VPWR
+ VPWR SLICE_16\[1\].RAM16.BYTE\[0\].FLOATBUF0\[6\].Z sky130_fd_sc_hd__ebufn_2
XSLICE_16\[0\].RAM16.SLICE\[0\].RAM8.WORD\[7\].W.BYTE\[2\].B.BIT\[2\].OBUF0 SLICE_16\[0\].RAM16.SLICE\[0\].RAM8.WORD\[7\].W.BYTE\[2\].B.Q_WIRE\[2\]
+ SLICE_16\[0\].RAM16.SLICE\[0\].RAM8.WORD\[7\].W.BYTE\[2\].B.SEL0_B VGND VGND VPWR
+ VPWR SLICE_16\[0\].RAM16.BYTE\[2\].FLOATBUF0\[18\].Z sky130_fd_sc_hd__ebufn_2
XSLICE_16\[0\].RAM16.SLICE\[0\].RAM8.WORD\[7\].W.CLKBUF SLICE_16\[0\].RAM16.SLICE\[0\].RAM8.CLKBUF.X
+ VGND VGND VPWR VPWR SLICE_16\[0\].RAM16.SLICE\[0\].RAM8.WORD\[7\].W.BYTE\[0\].B.CLK
+ sky130_fd_sc_hd__clkbuf_4
XSLICE_16\[1\].RAM16.SLICE\[1\].RAM8.WORD\[6\].W.BYTE\[2\].B.BIT\[6\].genblk1.STORAGE
+ DIBUF\[22\].X SLICE_16\[1\].RAM16.SLICE\[1\].RAM8.WORD\[6\].W.BYTE\[2\].B.GCLK VGND
+ VGND VPWR VPWR SLICE_16\[1\].RAM16.SLICE\[1\].RAM8.WORD\[6\].W.BYTE\[2\].B.Q_WIRE\[6\]
+ sky130_fd_sc_hd__dlxtp_1
XSLICE_16\[1\].RAM16.SLICE\[1\].RAM8.WORD\[0\].W.BYTE\[3\].B.BIT\[7\].genblk1.STORAGE
+ DIBUF\[31\].X SLICE_16\[1\].RAM16.SLICE\[1\].RAM8.WORD\[0\].W.BYTE\[3\].B.GCLK VGND
+ VGND VPWR VPWR SLICE_16\[1\].RAM16.SLICE\[1\].RAM8.WORD\[0\].W.BYTE\[3\].B.Q_WIRE\[7\]
+ sky130_fd_sc_hd__dlxtp_1
XSLICE_16\[1\].RAM16.SLICE\[1\].RAM8.WORD\[4\].W.BYTE\[0\].B.BIT\[5\].genblk1.STORAGE
+ DIBUF\[5\].X SLICE_16\[1\].RAM16.SLICE\[1\].RAM8.WORD\[4\].W.BYTE\[0\].B.GCLK VGND
+ VGND VPWR VPWR SLICE_16\[1\].RAM16.SLICE\[1\].RAM8.WORD\[4\].W.BYTE\[0\].B.Q_WIRE\[5\]
+ sky130_fd_sc_hd__dlxtp_1
XSLICE_16\[1\].RAM16.SLICE\[0\].RAM8.WORD\[5\].W.BYTE\[2\].B.BIT\[1\].genblk1.STORAGE
+ DIBUF\[17\].X SLICE_16\[1\].RAM16.SLICE\[0\].RAM8.WORD\[5\].W.BYTE\[2\].B.GCLK VGND
+ VGND VPWR VPWR SLICE_16\[1\].RAM16.SLICE\[0\].RAM8.WORD\[5\].W.BYTE\[2\].B.Q_WIRE\[1\]
+ sky130_fd_sc_hd__dlxtp_1
Xfill_22_79 VGND VGND VPWR VPWR sky130_fd_sc_hd__decap_12
Xfill_22_68 VGND VGND VPWR VPWR sky130_fd_sc_hd__decap_12
Xfill_22_57 VGND VPWR sky130_fd_sc_hd__tapvpwrvgnd_1
Xfill_22_46 VGND VGND VPWR VPWR sky130_fd_sc_hd__decap_12
Xfill_22_35 VGND VGND VPWR VPWR sky130_fd_sc_hd__decap_12
Xfill_22_24 VGND VPWR sky130_fd_sc_hd__tapvpwrvgnd_1
Xfill_22_13 VGND VGND VPWR VPWR sky130_fd_sc_hd__decap_12
Xfill_47_32 VGND VGND VPWR VPWR sky130_fd_sc_hd__decap_12
Xfill_47_21 VGND VPWR sky130_fd_sc_hd__tapvpwrvgnd_1
Xfill_47_10 VGND VGND VPWR VPWR sky130_fd_sc_hd__decap_12
XSLICE_16\[1\].RAM16.SLICE\[0\].RAM8.WORD\[3\].W.BYTE\[0\].B.BIT\[0\].genblk1.STORAGE
+ DIBUF\[0\].X SLICE_16\[1\].RAM16.SLICE\[0\].RAM8.WORD\[3\].W.BYTE\[0\].B.GCLK VGND
+ VGND VPWR VPWR SLICE_16\[1\].RAM16.SLICE\[0\].RAM8.WORD\[3\].W.BYTE\[0\].B.Q_WIRE\[0\]
+ sky130_fd_sc_hd__dlxtp_1
XSLICE_16\[0\].RAM16.SLICE\[1\].RAM8.WORD\[7\].W.BYTE\[2\].B.BIT\[2\].genblk1.STORAGE
+ DIBUF\[18\].X SLICE_16\[0\].RAM16.SLICE\[1\].RAM8.WORD\[7\].W.BYTE\[2\].B.GCLK VGND
+ VGND VPWR VPWR SLICE_16\[0\].RAM16.SLICE\[1\].RAM8.WORD\[7\].W.BYTE\[2\].B.Q_WIRE\[2\]
+ sky130_fd_sc_hd__dlxtp_1
XSLICE_16\[0\].RAM16.SLICE\[1\].RAM8.WORD\[1\].W.BYTE\[3\].B.BIT\[3\].genblk1.STORAGE
+ DIBUF\[27\].X SLICE_16\[0\].RAM16.SLICE\[1\].RAM8.WORD\[1\].W.BYTE\[3\].B.GCLK VGND
+ VGND VPWR VPWR SLICE_16\[0\].RAM16.SLICE\[1\].RAM8.WORD\[1\].W.BYTE\[3\].B.Q_WIRE\[3\]
+ sky130_fd_sc_hd__dlxtp_1
Xfill_47_65 VGND VPWR sky130_fd_sc_hd__tapvpwrvgnd_1
Xfill_47_54 VGND VPWR sky130_fd_sc_hd__tapvpwrvgnd_1
Xfill_47_43 VGND VGND VPWR VPWR sky130_fd_sc_hd__decap_12
XSLICE_16\[1\].RAM16.Do0_REG.OUTREG_BYTE\[3\].DIODE\[0\] SLICE_16\[1\].RAM16.BYTE\[3\].FLOATBUF0\[24\].Z
+ VGND VGND VPWR VPWR sky130_fd_sc_hd__diode_2
XSLICE_16\[0\].RAM16.SLICE\[1\].RAM8.WORD\[5\].W.BYTE\[0\].B.BIT\[1\].genblk1.STORAGE
+ DIBUF\[1\].X SLICE_16\[0\].RAM16.SLICE\[1\].RAM8.WORD\[5\].W.BYTE\[0\].B.GCLK VGND
+ VGND VPWR VPWR SLICE_16\[0\].RAM16.SLICE\[1\].RAM8.WORD\[5\].W.BYTE\[0\].B.Q_WIRE\[1\]
+ sky130_fd_sc_hd__dlxtp_1
XSLICE_16\[0\].RAM16.SLICE\[0\].RAM8.WORD\[7\].W.BYTE\[2\].B.genblk1.CG SLICE_16\[0\].RAM16.SLICE\[0\].RAM8.WORD\[7\].W.BYTE\[2\].B.CLK_B
+ SLICE_16\[0\].RAM16.SLICE\[0\].RAM8.WORD\[7\].W.BYTE\[2\].B.WE0_WIRE VGND VGND VPWR
+ VPWR SLICE_16\[0\].RAM16.SLICE\[0\].RAM8.WORD\[7\].W.BYTE\[2\].B.GCLK sky130_fd_sc_hd__dlclkp_1
Xfill_31_2 VGND VPWR sky130_fd_sc_hd__tapvpwrvgnd_1
XSLICE_16\[1\].RAM16.SLICE\[0\].RAM8.WORD\[5\].W.BYTE\[1\].B.BIT\[6\].OBUF0 SLICE_16\[1\].RAM16.SLICE\[0\].RAM8.WORD\[5\].W.BYTE\[1\].B.Q_WIRE\[6\]
+ SLICE_16\[1\].RAM16.SLICE\[0\].RAM8.WORD\[5\].W.BYTE\[1\].B.SEL0_B VGND VGND VPWR
+ VPWR SLICE_16\[1\].RAM16.BYTE\[1\].FLOATBUF0\[14\].Z sky130_fd_sc_hd__ebufn_2
XSLICE_16\[0\].RAM16.SLICE\[1\].RAM8.WORD\[2\].W.BYTE\[3\].B.BIT\[5\].OBUF0 SLICE_16\[0\].RAM16.SLICE\[1\].RAM8.WORD\[2\].W.BYTE\[3\].B.Q_WIRE\[5\]
+ SLICE_16\[0\].RAM16.SLICE\[1\].RAM8.WORD\[2\].W.BYTE\[3\].B.SEL0_B VGND VGND VPWR
+ VPWR SLICE_16\[0\].RAM16.BYTE\[3\].FLOATBUF0\[29\].Z sky130_fd_sc_hd__ebufn_2
Xfill_24_1 VGND VPWR sky130_fd_sc_hd__tapvpwrvgnd_1
Xfill_17_0 VGND VPWR sky130_fd_sc_hd__tapvpwrvgnd_1
XSLICE_16\[0\].RAM16.SLICE\[0\].RAM8.WORD\[2\].W.BYTE\[0\].B.BIT\[7\].genblk1.STORAGE
+ DIBUF\[7\].X SLICE_16\[0\].RAM16.SLICE\[0\].RAM8.WORD\[2\].W.BYTE\[0\].B.GCLK VGND
+ VGND VPWR VPWR SLICE_16\[0\].RAM16.SLICE\[0\].RAM8.WORD\[2\].W.BYTE\[0\].B.Q_WIRE\[7\]
+ sky130_fd_sc_hd__dlxtp_1
XSLICE_16\[1\].RAM16.TIE0\[0\].__cell__ VGND VGND VPWR VPWR SLICE_16\[1\].RAM16.TIE0\[0\].__cell__/HI
+ SLICE_16\[1\].RAM16.BYTE\[0\].FLOATBUF0\[0\].A sky130_fd_sc_hd__conb_1
XSLICE_16\[0\].RAM16.SLICE\[0\].RAM8.WORD\[7\].W.BYTE\[0\].B.BIT\[7\].OBUF0 SLICE_16\[0\].RAM16.SLICE\[0\].RAM8.WORD\[7\].W.BYTE\[0\].B.Q_WIRE\[7\]
+ SLICE_16\[0\].RAM16.SLICE\[0\].RAM8.WORD\[7\].W.BYTE\[0\].B.SEL0_B VGND VGND VPWR
+ VPWR SLICE_16\[0\].RAM16.BYTE\[0\].FLOATBUF0\[7\].Z sky130_fd_sc_hd__ebufn_2
Xtap_39_7 VGND VPWR sky130_fd_sc_hd__tapvpwrvgnd_1
Xtap_29_36 VGND VPWR sky130_fd_sc_hd__tapvpwrvgnd_1
Xtap_29_25 VGND VPWR sky130_fd_sc_hd__tapvpwrvgnd_1
Xtap_29_14 VGND VPWR sky130_fd_sc_hd__tapvpwrvgnd_1
XSLICE_16\[1\].RAM16.SLICE\[0\].RAM8.WORD\[4\].W.BYTE\[1\].B.genblk1.CG SLICE_16\[1\].RAM16.SLICE\[0\].RAM8.WORD\[4\].W.BYTE\[1\].B.CLK_B
+ SLICE_16\[1\].RAM16.SLICE\[0\].RAM8.WORD\[4\].W.BYTE\[1\].B.WE0_WIRE VGND VGND VPWR
+ VPWR SLICE_16\[1\].RAM16.SLICE\[0\].RAM8.WORD\[4\].W.BYTE\[1\].B.GCLK sky130_fd_sc_hd__dlclkp_1
Xfill_17_68 VGND VPWR sky130_fd_sc_hd__tapvpwrvgnd_1
Xfill_17_57 VGND VPWR sky130_fd_sc_hd__tapvpwrvgnd_1
Xfill_17_46 VGND VGND VPWR VPWR sky130_fd_sc_hd__decap_12
Xfill_17_35 VGND VGND VPWR VPWR sky130_fd_sc_hd__decap_12
Xfill_17_24 VGND VPWR sky130_fd_sc_hd__tapvpwrvgnd_1
Xfill_17_13 VGND VGND VPWR VPWR sky130_fd_sc_hd__decap_12
XSLICE_16\[0\].RAM16.SLICE\[1\].RAM8.WORD\[1\].W.BYTE\[1\].B.BIT\[2\].OBUF0 SLICE_16\[0\].RAM16.SLICE\[1\].RAM8.WORD\[1\].W.BYTE\[1\].B.Q_WIRE\[2\]
+ SLICE_16\[0\].RAM16.SLICE\[1\].RAM8.WORD\[1\].W.BYTE\[1\].B.SEL0_B VGND VGND VPWR
+ VPWR SLICE_16\[0\].RAM16.BYTE\[1\].FLOATBUF0\[10\].Z sky130_fd_sc_hd__ebufn_2
XSLICE_16\[1\].RAM16.Do0_REG.OUTREG_BYTE\[2\].Do_FF\[1\] SLICE_16\[1\].RAM16.Do0_REG.CLKBUF\[2\]
+ SLICE_16\[1\].RAM16.BYTE\[2\].FLOATBUF0\[17\].Z VGND VGND VPWR VPWR Do0MUX.A1\[17\]
+ sky130_fd_sc_hd__dfxtp_1
Xfill_44_103 VGND VGND VPWR VPWR sky130_fd_sc_hd__fill_2
XSLICE_16\[1\].RAM16.SLICE\[1\].RAM8.WORD\[7\].W.BYTE\[1\].B.BIT\[5\].genblk1.STORAGE
+ DIBUF\[13\].X SLICE_16\[1\].RAM16.SLICE\[1\].RAM8.WORD\[7\].W.BYTE\[1\].B.GCLK VGND
+ VGND VPWR VPWR SLICE_16\[1\].RAM16.SLICE\[1\].RAM8.WORD\[7\].W.BYTE\[1\].B.Q_WIRE\[5\]
+ sky130_fd_sc_hd__dlxtp_1
XSLICE_16\[1\].RAM16.SLICE\[1\].RAM8.WORD\[1\].W.BYTE\[2\].B.BIT\[6\].genblk1.STORAGE
+ DIBUF\[22\].X SLICE_16\[1\].RAM16.SLICE\[1\].RAM8.WORD\[1\].W.BYTE\[2\].B.GCLK VGND
+ VGND VPWR VPWR SLICE_16\[1\].RAM16.SLICE\[1\].RAM8.WORD\[1\].W.BYTE\[2\].B.Q_WIRE\[6\]
+ sky130_fd_sc_hd__dlxtp_1
XSLICE_16\[1\].RAM16.SLICE\[0\].RAM8.WORD\[6\].W.BYTE\[1\].B.BIT\[0\].genblk1.STORAGE
+ DIBUF\[8\].X SLICE_16\[1\].RAM16.SLICE\[0\].RAM8.WORD\[6\].W.BYTE\[1\].B.GCLK VGND
+ VGND VPWR VPWR SLICE_16\[1\].RAM16.SLICE\[0\].RAM8.WORD\[6\].W.BYTE\[1\].B.Q_WIRE\[0\]
+ sky130_fd_sc_hd__dlxtp_1
XSLICE_16\[1\].RAM16.SLICE\[0\].RAM8.WORD\[0\].W.BYTE\[2\].B.BIT\[1\].genblk1.STORAGE
+ DIBUF\[17\].X SLICE_16\[1\].RAM16.SLICE\[0\].RAM8.WORD\[0\].W.BYTE\[2\].B.GCLK VGND
+ VGND VPWR VPWR SLICE_16\[1\].RAM16.SLICE\[0\].RAM8.WORD\[0\].W.BYTE\[2\].B.Q_WIRE\[1\]
+ sky130_fd_sc_hd__dlxtp_1
XSLICE_16\[0\].RAM16.SLICE\[0\].RAM8.WORD\[0\].W.BYTE\[3\].B.BIT\[4\].OBUF0 SLICE_16\[0\].RAM16.SLICE\[0\].RAM8.WORD\[0\].W.BYTE\[3\].B.Q_WIRE\[4\]
+ SLICE_16\[0\].RAM16.SLICE\[0\].RAM8.WORD\[0\].W.BYTE\[3\].B.SEL0_B VGND VGND VPWR
+ VPWR SLICE_16\[0\].RAM16.BYTE\[3\].FLOATBUF0\[28\].Z sky130_fd_sc_hd__ebufn_2
XSLICE_16\[1\].RAM16.SLICE\[1\].RAM8.WORD\[2\].W.BYTE\[3\].B.BIT\[1\].OBUF0 SLICE_16\[1\].RAM16.SLICE\[1\].RAM8.WORD\[2\].W.BYTE\[3\].B.Q_WIRE\[1\]
+ SLICE_16\[1\].RAM16.SLICE\[1\].RAM8.WORD\[2\].W.BYTE\[3\].B.SEL0_B VGND VGND VPWR
+ VPWR SLICE_16\[1\].RAM16.BYTE\[3\].FLOATBUF0\[25\].Z sky130_fd_sc_hd__ebufn_2
XSLICE_16\[0\].RAM16.SLICE\[1\].RAM8.DEC0.ABUF\[2\] SLICE_16\[0\].RAM16.A0BUF\[2\].X
+ VGND VGND VPWR VPWR SLICE_16\[0\].RAM16.SLICE\[1\].RAM8.DEC0.A_buf\[2\] sky130_fd_sc_hd__clkbuf_2
XSLICE_16\[0\].RAM16.SLICE\[1\].RAM8.WORD\[2\].W.BYTE\[2\].B.BIT\[2\].genblk1.STORAGE
+ DIBUF\[18\].X SLICE_16\[0\].RAM16.SLICE\[1\].RAM8.WORD\[2\].W.BYTE\[2\].B.GCLK VGND
+ VGND VPWR VPWR SLICE_16\[0\].RAM16.SLICE\[1\].RAM8.WORD\[2\].W.BYTE\[2\].B.Q_WIRE\[2\]
+ sky130_fd_sc_hd__dlxtp_1
Xtap_15_27 VGND VPWR sky130_fd_sc_hd__tapvpwrvgnd_1
Xtap_15_16 VGND VPWR sky130_fd_sc_hd__tapvpwrvgnd_1
XSLICE_16\[0\].RAM16.SLICE\[1\].RAM8.WORD\[0\].W.BYTE\[0\].B.BIT\[1\].genblk1.STORAGE
+ DIBUF\[1\].X SLICE_16\[0\].RAM16.SLICE\[1\].RAM8.WORD\[0\].W.BYTE\[0\].B.GCLK VGND
+ VGND VPWR VPWR SLICE_16\[0\].RAM16.SLICE\[1\].RAM8.WORD\[0\].W.BYTE\[0\].B.Q_WIRE\[1\]
+ sky130_fd_sc_hd__dlxtp_1
Xtap_31_37 VGND VPWR sky130_fd_sc_hd__tapvpwrvgnd_1
Xtap_31_26 VGND VPWR sky130_fd_sc_hd__tapvpwrvgnd_1
Xtap_31_15 VGND VPWR sky130_fd_sc_hd__tapvpwrvgnd_1
Xtap_37_4 VGND VPWR sky130_fd_sc_hd__tapvpwrvgnd_1
XSLICE_16\[1\].RAM16.SLICE\[0\].RAM8.WORD\[7\].W.BYTE\[0\].B.BIT\[3\].OBUF0 SLICE_16\[1\].RAM16.SLICE\[0\].RAM8.WORD\[7\].W.BYTE\[0\].B.Q_WIRE\[3\]
+ SLICE_16\[1\].RAM16.SLICE\[0\].RAM8.WORD\[7\].W.BYTE\[0\].B.SEL0_B VGND VGND VPWR
+ VPWR SLICE_16\[1\].RAM16.BYTE\[0\].FLOATBUF0\[3\].Z sky130_fd_sc_hd__ebufn_2
XSLICE_16\[1\].RAM16.SLICE\[0\].RAM8.WORD\[2\].W.BYTE\[2\].B.genblk1.CLKINV SLICE_16\[1\].RAM16.SLICE\[0\].RAM8.WORD\[2\].W.BYTE\[0\].B.CLK
+ VGND VGND VPWR VPWR SLICE_16\[1\].RAM16.SLICE\[0\].RAM8.WORD\[2\].W.BYTE\[2\].B.CLK_B
+ sky130_fd_sc_hd__inv_1
XSLICE_16\[0\].RAM16.SLICE\[1\].RAM8.WORD\[4\].W.BYTE\[2\].B.BIT\[2\].OBUF0 SLICE_16\[0\].RAM16.SLICE\[1\].RAM8.WORD\[4\].W.BYTE\[2\].B.Q_WIRE\[2\]
+ SLICE_16\[0\].RAM16.SLICE\[1\].RAM8.WORD\[4\].W.BYTE\[2\].B.SEL0_B VGND VGND VPWR
+ VPWR SLICE_16\[0\].RAM16.BYTE\[2\].FLOATBUF0\[18\].Z sky130_fd_sc_hd__ebufn_2
Xtap_2_30 VGND VPWR sky130_fd_sc_hd__tapvpwrvgnd_1
XSLICE_16\[0\].RAM16.SLICE\[0\].RAM8.WORD\[5\].W.BYTE\[1\].B.BIT\[7\].genblk1.STORAGE
+ DIBUF\[15\].X SLICE_16\[0\].RAM16.SLICE\[0\].RAM8.WORD\[5\].W.BYTE\[1\].B.GCLK VGND
+ VGND VPWR VPWR SLICE_16\[0\].RAM16.SLICE\[0\].RAM8.WORD\[5\].W.BYTE\[1\].B.Q_WIRE\[7\]
+ sky130_fd_sc_hd__dlxtp_1
Xfill_44_88 VGND VGND VPWR VPWR sky130_fd_sc_hd__decap_12
Xfill_44_77 VGND VGND VPWR VPWR sky130_fd_sc_hd__decap_12
Xfill_44_66 VGND VPWR sky130_fd_sc_hd__tapvpwrvgnd_1
Xfill_44_55 VGND VGND VPWR VPWR sky130_fd_sc_hd__decap_12
Xfill_44_44 VGND VGND VPWR VPWR sky130_fd_sc_hd__decap_12
Xfill_44_33 VGND VPWR sky130_fd_sc_hd__tapvpwrvgnd_1
Xfill_44_22 VGND VGND VPWR VPWR sky130_fd_sc_hd__decap_12
Xfill_44_11 VGND VGND VPWR VPWR sky130_fd_sc_hd__decap_12
XSLICE_16\[0\].RAM16.TIE0\[2\].__cell__ VGND VGND VPWR VPWR SLICE_16\[0\].RAM16.TIE0\[2\].__cell__/HI
+ SLICE_16\[0\].RAM16.BYTE\[2\].FLOATBUF0\[16\].A sky130_fd_sc_hd__conb_1
Xfill_44_99 VGND VPWR sky130_fd_sc_hd__tapvpwrvgnd_1
XSLICE_16\[1\].RAM16.SLICE\[0\].RAM8.WORD\[6\].W.BYTE\[2\].B.SEL0INV SLICE_16\[1\].RAM16.SLICE\[0\].RAM8.WORD\[6\].W.BYTE\[0\].B.SEL0
+ VGND VGND VPWR VPWR SLICE_16\[1\].RAM16.SLICE\[0\].RAM8.WORD\[6\].W.BYTE\[2\].B.SEL0_B
+ sky130_fd_sc_hd__inv_1
XSLICE_16\[1\].RAM16.SLICE\[1\].RAM8.WORD\[2\].W.BYTE\[1\].B.BIT\[6\].OBUF0 SLICE_16\[1\].RAM16.SLICE\[1\].RAM8.WORD\[2\].W.BYTE\[1\].B.Q_WIRE\[6\]
+ SLICE_16\[1\].RAM16.SLICE\[1\].RAM8.WORD\[2\].W.BYTE\[1\].B.SEL0_B VGND VGND VPWR
+ VPWR SLICE_16\[1\].RAM16.BYTE\[1\].FLOATBUF0\[14\].Z sky130_fd_sc_hd__ebufn_2
XSLICE_16\[1\].RAM16.SLICE\[0\].RAM8.WORD\[0\].W.BYTE\[3\].B.BIT\[0\].OBUF0 SLICE_16\[1\].RAM16.SLICE\[0\].RAM8.WORD\[0\].W.BYTE\[3\].B.Q_WIRE\[0\]
+ SLICE_16\[1\].RAM16.SLICE\[0\].RAM8.WORD\[0\].W.BYTE\[3\].B.SEL0_B VGND VGND VPWR
+ VPWR SLICE_16\[1\].RAM16.BYTE\[3\].FLOATBUF0\[24\].Z sky130_fd_sc_hd__ebufn_2
XSLICE_16\[0\].RAM16.SLICE\[1\].RAM8.WORD\[7\].W.BYTE\[3\].B.BIT\[2\].OBUF0 SLICE_16\[0\].RAM16.SLICE\[1\].RAM8.WORD\[7\].W.BYTE\[3\].B.Q_WIRE\[2\]
+ SLICE_16\[0\].RAM16.SLICE\[1\].RAM8.WORD\[7\].W.BYTE\[3\].B.SEL0_B VGND VGND VPWR
+ VPWR SLICE_16\[0\].RAM16.BYTE\[3\].FLOATBUF0\[26\].Z sky130_fd_sc_hd__ebufn_2
Xtap_7_19 VGND VPWR sky130_fd_sc_hd__tapvpwrvgnd_1
Xfill_6_6 VGND VGND VPWR VPWR sky130_fd_sc_hd__decap_4
XSLICE_16\[1\].RAM16.SLICE\[1\].RAM8.WORD\[4\].W.BYTE\[3\].B.BIT\[6\].genblk1.STORAGE
+ DIBUF\[30\].X SLICE_16\[1\].RAM16.SLICE\[1\].RAM8.WORD\[4\].W.BYTE\[3\].B.GCLK VGND
+ VGND VPWR VPWR SLICE_16\[1\].RAM16.SLICE\[1\].RAM8.WORD\[4\].W.BYTE\[3\].B.Q_WIRE\[6\]
+ sky130_fd_sc_hd__dlxtp_1
XSLICE_16\[1\].RAM16.SLICE\[0\].RAM8.WORD\[5\].W.BYTE\[3\].B.genblk1.CLKINV SLICE_16\[1\].RAM16.SLICE\[0\].RAM8.WORD\[5\].W.BYTE\[0\].B.CLK
+ VGND VGND VPWR VPWR SLICE_16\[1\].RAM16.SLICE\[0\].RAM8.WORD\[5\].W.BYTE\[3\].B.CLK_B
+ sky130_fd_sc_hd__inv_1
XSLICE_16\[0\].RAM16.Do0_REG.OUTREG_BYTE\[1\].DIODE\[1\] SLICE_16\[0\].RAM16.BYTE\[1\].FLOATBUF0\[9\].Z
+ VGND VGND VPWR VPWR sky130_fd_sc_hd__diode_2
XSLICE_16\[1\].RAM16.SLICE\[1\].RAM8.WORD\[2\].W.BYTE\[1\].B.BIT\[5\].genblk1.STORAGE
+ DIBUF\[13\].X SLICE_16\[1\].RAM16.SLICE\[1\].RAM8.WORD\[2\].W.BYTE\[1\].B.GCLK VGND
+ VGND VPWR VPWR SLICE_16\[1\].RAM16.SLICE\[1\].RAM8.WORD\[2\].W.BYTE\[1\].B.Q_WIRE\[5\]
+ sky130_fd_sc_hd__dlxtp_1
Xtap_26_26 VGND VPWR sky130_fd_sc_hd__tapvpwrvgnd_1
Xtap_26_15 VGND VPWR sky130_fd_sc_hd__tapvpwrvgnd_1
Xtap_16_9 VGND VPWR sky130_fd_sc_hd__tapvpwrvgnd_1
XSLICE_16\[1\].RAM16.SLICE\[0\].RAM8.WORD\[3\].W.BYTE\[3\].B.BIT\[1\].genblk1.STORAGE
+ DIBUF\[25\].X SLICE_16\[1\].RAM16.SLICE\[0\].RAM8.WORD\[3\].W.BYTE\[3\].B.GCLK VGND
+ VGND VPWR VPWR SLICE_16\[1\].RAM16.SLICE\[0\].RAM8.WORD\[3\].W.BYTE\[3\].B.Q_WIRE\[1\]
+ sky130_fd_sc_hd__dlxtp_1
XSLICE_16\[0\].RAM16.SLICE\[1\].RAM8.WORD\[4\].W.BYTE\[0\].B.BIT\[7\].OBUF0 SLICE_16\[0\].RAM16.SLICE\[1\].RAM8.WORD\[4\].W.BYTE\[0\].B.Q_WIRE\[7\]
+ SLICE_16\[0\].RAM16.SLICE\[1\].RAM8.WORD\[4\].W.BYTE\[0\].B.SEL0_B VGND VGND VPWR
+ VPWR SLICE_16\[0\].RAM16.BYTE\[0\].FLOATBUF0\[7\].Z sky130_fd_sc_hd__ebufn_2
XSLICE_16\[0\].RAM16.SLICE\[0\].RAM8.WORD\[0\].W.BYTE\[0\].B.DIODE_CLK SLICE_16\[0\].RAM16.SLICE\[0\].RAM8.WORD\[0\].W.BYTE\[0\].B.CLK
+ VGND VGND VPWR VPWR sky130_fd_sc_hd__diode_2
XSLICE_16\[0\].RAM16.SLICE\[0\].RAM8.WORD\[2\].W.BYTE\[2\].B.BIT\[1\].OBUF0 SLICE_16\[0\].RAM16.SLICE\[0\].RAM8.WORD\[2\].W.BYTE\[2\].B.Q_WIRE\[1\]
+ SLICE_16\[0\].RAM16.SLICE\[0\].RAM8.WORD\[2\].W.BYTE\[2\].B.SEL0_B VGND VGND VPWR
+ VPWR SLICE_16\[0\].RAM16.BYTE\[2\].FLOATBUF0\[17\].Z sky130_fd_sc_hd__ebufn_2
Xtap_9_8 VGND VPWR sky130_fd_sc_hd__tapvpwrvgnd_1
XSLICE_16\[1\].RAM16.SLICE\[0\].RAM8.WORD\[1\].W.BYTE\[1\].B.BIT\[0\].genblk1.STORAGE
+ DIBUF\[8\].X SLICE_16\[1\].RAM16.SLICE\[0\].RAM8.WORD\[1\].W.BYTE\[1\].B.GCLK VGND
+ VGND VPWR VPWR SLICE_16\[1\].RAM16.SLICE\[0\].RAM8.WORD\[1\].W.BYTE\[1\].B.Q_WIRE\[0\]
+ sky130_fd_sc_hd__dlxtp_1
XSLICE_16\[0\].RAM16.SLICE\[1\].RAM8.WORD\[5\].W.BYTE\[3\].B.BIT\[2\].genblk1.STORAGE
+ DIBUF\[26\].X SLICE_16\[0\].RAM16.SLICE\[1\].RAM8.WORD\[5\].W.BYTE\[3\].B.GCLK VGND
+ VGND VPWR VPWR SLICE_16\[0\].RAM16.SLICE\[1\].RAM8.WORD\[5\].W.BYTE\[3\].B.Q_WIRE\[2\]
+ sky130_fd_sc_hd__dlxtp_1
XDo0MUX.M\[0\].DIODE_A1MUX\[4\] Do0MUX.A1\[4\] VGND VGND VPWR VPWR sky130_fd_sc_hd__diode_2
Xfill_39_33 VGND VPWR sky130_fd_sc_hd__tapvpwrvgnd_1
Xfill_39_22 VGND VGND VPWR VPWR sky130_fd_sc_hd__decap_12
Xfill_39_11 VGND VGND VPWR VPWR sky130_fd_sc_hd__decap_12
Xtap_35_1 VGND VPWR sky130_fd_sc_hd__tapvpwrvgnd_1
Xtap_28_0 VGND VPWR sky130_fd_sc_hd__tapvpwrvgnd_1
XSLICE_16\[1\].RAM16.DIODE_A0\[3\].__cell__ A0BUF\[3\].X VGND VGND VPWR VPWR sky130_fd_sc_hd__diode_2
XSLICE_16\[0\].RAM16.SLICE\[1\].RAM8.WORD\[3\].W.BYTE\[1\].B.BIT\[1\].genblk1.STORAGE
+ DIBUF\[9\].X SLICE_16\[0\].RAM16.SLICE\[1\].RAM8.WORD\[3\].W.BYTE\[1\].B.GCLK VGND
+ VGND VPWR VPWR SLICE_16\[0\].RAM16.SLICE\[1\].RAM8.WORD\[3\].W.BYTE\[1\].B.Q_WIRE\[1\]
+ sky130_fd_sc_hd__dlxtp_1
XSLICE_16\[0\].RAM16.SLICE\[0\].RAM8.WORD\[4\].W.BYTE\[3\].B.SEL0INV SLICE_16\[0\].RAM16.SLICE\[0\].RAM8.WORD\[4\].W.BYTE\[0\].B.SEL0
+ VGND VGND VPWR VPWR SLICE_16\[0\].RAM16.SLICE\[0\].RAM8.WORD\[4\].W.BYTE\[3\].B.SEL0_B
+ sky130_fd_sc_hd__inv_1
XDo0MUX.M\[3\].DIODE_A1MUX\[31\] Do0MUX.A1\[31\] VGND VGND VPWR VPWR sky130_fd_sc_hd__diode_2
Xfill_39_66 VGND VPWR sky130_fd_sc_hd__tapvpwrvgnd_1
Xfill_39_55 VGND VGND VPWR VPWR sky130_fd_sc_hd__decap_12
Xfill_39_44 VGND VGND VPWR VPWR sky130_fd_sc_hd__decap_12
XSLICE_16\[1\].RAM16.SLICE\[1\].RAM8.WORD\[5\].W.BYTE\[2\].B.BIT\[6\].OBUF0 SLICE_16\[1\].RAM16.SLICE\[1\].RAM8.WORD\[5\].W.BYTE\[2\].B.Q_WIRE\[6\]
+ SLICE_16\[1\].RAM16.SLICE\[1\].RAM8.WORD\[5\].W.BYTE\[2\].B.SEL0_B VGND VGND VPWR
+ VPWR SLICE_16\[1\].RAM16.BYTE\[2\].FLOATBUF0\[22\].Z sky130_fd_sc_hd__ebufn_2
Xfill_20_90 VGND VPWR sky130_fd_sc_hd__tapvpwrvgnd_1
XSLICE_16\[0\].RAM16.SLICE\[1\].RAM8.WORD\[7\].W.BYTE\[1\].B.BIT\[7\].OBUF0 SLICE_16\[0\].RAM16.SLICE\[1\].RAM8.WORD\[7\].W.BYTE\[1\].B.Q_WIRE\[7\]
+ SLICE_16\[0\].RAM16.SLICE\[1\].RAM8.WORD\[7\].W.BYTE\[1\].B.SEL0_B VGND VGND VPWR
+ VPWR SLICE_16\[0\].RAM16.BYTE\[1\].FLOATBUF0\[15\].Z sky130_fd_sc_hd__ebufn_2
XSLICE_16\[0\].RAM16.SLICE\[0\].RAM8.WORD\[0\].W.BYTE\[1\].B.BIT\[7\].genblk1.STORAGE
+ DIBUF\[15\].X SLICE_16\[0\].RAM16.SLICE\[0\].RAM8.WORD\[0\].W.BYTE\[1\].B.GCLK VGND
+ VGND VPWR VPWR SLICE_16\[0\].RAM16.SLICE\[0\].RAM8.WORD\[0\].W.BYTE\[1\].B.Q_WIRE\[7\]
+ sky130_fd_sc_hd__dlxtp_1
XSLICE_16\[0\].RAM16.SLICE\[0\].RAM8.WORD\[6\].W.BYTE\[0\].B.BIT\[6\].genblk1.STORAGE
+ DIBUF\[6\].X SLICE_16\[0\].RAM16.SLICE\[0\].RAM8.WORD\[6\].W.BYTE\[0\].B.GCLK VGND
+ VGND VPWR VPWR SLICE_16\[0\].RAM16.SLICE\[0\].RAM8.WORD\[6\].W.BYTE\[0\].B.Q_WIRE\[6\]
+ sky130_fd_sc_hd__dlxtp_1
XSLICE_16\[1\].RAM16.SLICE\[0\].RAM8.WORD\[0\].W.BYTE\[1\].B.BIT\[5\].OBUF0 SLICE_16\[1\].RAM16.SLICE\[0\].RAM8.WORD\[0\].W.BYTE\[1\].B.Q_WIRE\[5\]
+ SLICE_16\[1\].RAM16.SLICE\[0\].RAM8.WORD\[0\].W.BYTE\[1\].B.SEL0_B VGND VGND VPWR
+ VPWR SLICE_16\[1\].RAM16.BYTE\[1\].FLOATBUF0\[13\].Z sky130_fd_sc_hd__ebufn_2
Xfill_4_3 VGND VPWR sky130_fd_sc_hd__tapvpwrvgnd_1
XSLICE_16\[0\].RAM16.SLICE\[0\].RAM8.WORD\[5\].W.BYTE\[3\].B.BIT\[1\].OBUF0 SLICE_16\[0\].RAM16.SLICE\[0\].RAM8.WORD\[5\].W.BYTE\[3\].B.Q_WIRE\[1\]
+ SLICE_16\[0\].RAM16.SLICE\[0\].RAM8.WORD\[5\].W.BYTE\[3\].B.SEL0_B VGND VGND VPWR
+ VPWR SLICE_16\[0\].RAM16.BYTE\[3\].FLOATBUF0\[25\].Z sky130_fd_sc_hd__ebufn_2
XSLICE_16\[0\].RAM16.Do0_REG.OUTREG_BYTE\[0\].Do_FF\[2\] SLICE_16\[0\].RAM16.Do0_REG.CLKBUF\[0\]
+ SLICE_16\[0\].RAM16.BYTE\[0\].FLOATBUF0\[2\].Z VGND VGND VPWR VPWR Do0MUX.A0\[2\]
+ sky130_fd_sc_hd__dfxtp_1
Xtap_12_28 VGND VPWR sky130_fd_sc_hd__tapvpwrvgnd_1
Xtap_12_17 VGND VPWR sky130_fd_sc_hd__tapvpwrvgnd_1
Xtap_37_25 VGND VPWR sky130_fd_sc_hd__tapvpwrvgnd_1
Xtap_37_14 VGND VPWR sky130_fd_sc_hd__tapvpwrvgnd_1
XSLICE_16\[0\].RAM16.SLICE\[0\].RAM8.WORD\[2\].W.BYTE\[0\].B.BIT\[6\].OBUF0 SLICE_16\[0\].RAM16.SLICE\[0\].RAM8.WORD\[2\].W.BYTE\[0\].B.Q_WIRE\[6\]
+ SLICE_16\[0\].RAM16.SLICE\[0\].RAM8.WORD\[2\].W.BYTE\[0\].B.SEL0_B VGND VGND VPWR
+ VPWR SLICE_16\[0\].RAM16.BYTE\[0\].FLOATBUF0\[6\].Z sky130_fd_sc_hd__ebufn_2
Xtap_37_36 VGND VPWR sky130_fd_sc_hd__tapvpwrvgnd_1
XSLICE_16\[1\].RAM16.SLICE\[1\].RAM8.WORD\[4\].W.BYTE\[0\].B.BIT\[3\].OBUF0 SLICE_16\[1\].RAM16.SLICE\[1\].RAM8.WORD\[4\].W.BYTE\[0\].B.Q_WIRE\[3\]
+ SLICE_16\[1\].RAM16.SLICE\[1\].RAM8.WORD\[4\].W.BYTE\[0\].B.SEL0_B VGND VGND VPWR
+ VPWR SLICE_16\[1\].RAM16.BYTE\[0\].FLOATBUF0\[3\].Z sky130_fd_sc_hd__ebufn_2
Xtap_14_6 VGND VPWR sky130_fd_sc_hd__tapvpwrvgnd_1
Xtap_7_5 VGND VPWR sky130_fd_sc_hd__tapvpwrvgnd_1
XSLICE_16\[0\].RAM16.SLICE\[0\].RAM8.WORD\[3\].W.BYTE\[1\].B.genblk1.CG SLICE_16\[0\].RAM16.SLICE\[0\].RAM8.WORD\[3\].W.BYTE\[1\].B.CLK_B
+ SLICE_16\[0\].RAM16.SLICE\[0\].RAM8.WORD\[3\].W.BYTE\[1\].B.WE0_WIRE VGND VGND VPWR
+ VPWR SLICE_16\[0\].RAM16.SLICE\[0\].RAM8.WORD\[3\].W.BYTE\[1\].B.GCLK sky130_fd_sc_hd__dlclkp_1
Xfill_41_89 VGND VGND VPWR VPWR sky130_fd_sc_hd__decap_12
Xfill_41_78 VGND VPWR sky130_fd_sc_hd__tapvpwrvgnd_1
Xfill_41_67 VGND VGND VPWR VPWR sky130_fd_sc_hd__decap_12
Xfill_41_56 VGND VGND VPWR VPWR sky130_fd_sc_hd__decap_12
Xfill_41_45 VGND VPWR sky130_fd_sc_hd__tapvpwrvgnd_1
Xfill_41_34 VGND VGND VPWR VPWR sky130_fd_sc_hd__decap_12
Xfill_41_23 VGND VGND VPWR VPWR sky130_fd_sc_hd__decap_12
Xfill_41_12 VGND VPWR sky130_fd_sc_hd__tapvpwrvgnd_1
XSLICE_16\[1\].RAM16.SLICE\[1\].RAM8.WORD\[5\].W.BYTE\[2\].B.BIT\[5\].genblk1.STORAGE
+ DIBUF\[21\].X SLICE_16\[1\].RAM16.SLICE\[1\].RAM8.WORD\[5\].W.BYTE\[2\].B.GCLK VGND
+ VGND VPWR VPWR SLICE_16\[1\].RAM16.SLICE\[1\].RAM8.WORD\[5\].W.BYTE\[2\].B.Q_WIRE\[5\]
+ sky130_fd_sc_hd__dlxtp_1
XSLICE_16\[0\].RAM16.SLICE\[0\].RAM8.WORD\[3\].W.BYTE\[3\].B.DIODE_CLK SLICE_16\[0\].RAM16.SLICE\[0\].RAM8.WORD\[3\].W.BYTE\[0\].B.CLK
+ VGND VGND VPWR VPWR sky130_fd_sc_hd__diode_2
XSLICE_16\[1\].RAM16.SLICE\[1\].RAM8.WORD\[3\].W.BYTE\[0\].B.BIT\[4\].genblk1.STORAGE
+ DIBUF\[4\].X SLICE_16\[1\].RAM16.SLICE\[1\].RAM8.WORD\[3\].W.BYTE\[0\].B.GCLK VGND
+ VGND VPWR VPWR SLICE_16\[1\].RAM16.SLICE\[1\].RAM8.WORD\[3\].W.BYTE\[0\].B.Q_WIRE\[4\]
+ sky130_fd_sc_hd__dlxtp_1
XSLICE_16\[1\].RAM16.SLICE\[0\].RAM8.WORD\[3\].W.BYTE\[2\].B.BIT\[5\].OBUF0 SLICE_16\[1\].RAM16.SLICE\[0\].RAM8.WORD\[3\].W.BYTE\[2\].B.Q_WIRE\[5\]
+ SLICE_16\[1\].RAM16.SLICE\[0\].RAM8.WORD\[3\].W.BYTE\[2\].B.SEL0_B VGND VGND VPWR
+ VPWR SLICE_16\[1\].RAM16.BYTE\[2\].FLOATBUF0\[21\].Z sky130_fd_sc_hd__ebufn_2
XSLICE_16\[1\].RAM16.SLICE\[0\].RAM8.WORD\[5\].W.BYTE\[0\].B.DIODE_CLK SLICE_16\[1\].RAM16.SLICE\[0\].RAM8.WORD\[5\].W.BYTE\[0\].B.CLK
+ VGND VGND VPWR VPWR sky130_fd_sc_hd__diode_2
XSLICE_16\[1\].RAM16.SLICE\[0\].RAM8.WORD\[4\].W.BYTE\[2\].B.BIT\[0\].genblk1.STORAGE
+ DIBUF\[16\].X SLICE_16\[1\].RAM16.SLICE\[0\].RAM8.WORD\[4\].W.BYTE\[2\].B.GCLK VGND
+ VGND VPWR VPWR SLICE_16\[1\].RAM16.SLICE\[0\].RAM8.WORD\[4\].W.BYTE\[2\].B.Q_WIRE\[0\]
+ sky130_fd_sc_hd__dlxtp_1
XSLICE_16\[0\].RAM16.SLICE\[1\].RAM8.WORD\[6\].W.BYTE\[2\].B.BIT\[1\].genblk1.STORAGE
+ DIBUF\[17\].X SLICE_16\[0\].RAM16.SLICE\[1\].RAM8.WORD\[6\].W.BYTE\[2\].B.GCLK VGND
+ VGND VPWR VPWR SLICE_16\[0\].RAM16.SLICE\[1\].RAM8.WORD\[6\].W.BYTE\[2\].B.Q_WIRE\[1\]
+ sky130_fd_sc_hd__dlxtp_1
XSLICE_16\[1\].RAM16.SLICE\[1\].RAM8.DEC0.ENBUF SLICE_16\[1\].RAM16.DEC0.SEL\[1\]
+ VGND VGND VPWR VPWR SLICE_16\[1\].RAM16.SLICE\[1\].RAM8.DEC0.EN_buf sky130_fd_sc_hd__clkbuf_2
XSLICE_16\[0\].RAM16.SLICE\[1\].RAM8.WORD\[4\].W.BYTE\[0\].B.BIT\[0\].genblk1.STORAGE
+ DIBUF\[0\].X SLICE_16\[0\].RAM16.SLICE\[1\].RAM8.WORD\[4\].W.BYTE\[0\].B.GCLK VGND
+ VGND VPWR VPWR SLICE_16\[0\].RAM16.SLICE\[1\].RAM8.WORD\[4\].W.BYTE\[0\].B.Q_WIRE\[0\]
+ sky130_fd_sc_hd__dlxtp_1
XSLICE_16\[0\].RAM16.SLICE\[1\].RAM8.WORD\[0\].W.BYTE\[3\].B.BIT\[2\].genblk1.STORAGE
+ DIBUF\[26\].X SLICE_16\[0\].RAM16.SLICE\[1\].RAM8.WORD\[0\].W.BYTE\[3\].B.GCLK VGND
+ VGND VPWR VPWR SLICE_16\[0\].RAM16.SLICE\[1\].RAM8.WORD\[0\].W.BYTE\[3\].B.Q_WIRE\[2\]
+ sky130_fd_sc_hd__dlxtp_1
XSLICE_16\[0\].RAM16.SLICE\[0\].RAM8.WORD\[5\].W.BYTE\[1\].B.BIT\[6\].OBUF0 SLICE_16\[0\].RAM16.SLICE\[0\].RAM8.WORD\[5\].W.BYTE\[1\].B.Q_WIRE\[6\]
+ SLICE_16\[0\].RAM16.SLICE\[0\].RAM8.WORD\[5\].W.BYTE\[1\].B.SEL0_B VGND VGND VPWR
+ VPWR SLICE_16\[0\].RAM16.BYTE\[1\].FLOATBUF0\[14\].Z sky130_fd_sc_hd__ebufn_2
Xfill_47_0 VGND VPWR sky130_fd_sc_hd__tapvpwrvgnd_1
XSLICE_16\[1\].RAM16.SLICE\[1\].RAM8.WORD\[7\].W.BYTE\[1\].B.BIT\[3\].OBUF0 SLICE_16\[1\].RAM16.SLICE\[1\].RAM8.WORD\[7\].W.BYTE\[1\].B.Q_WIRE\[3\]
+ SLICE_16\[1\].RAM16.SLICE\[1\].RAM8.WORD\[7\].W.BYTE\[1\].B.SEL0_B VGND VGND VPWR
+ VPWR SLICE_16\[1\].RAM16.BYTE\[1\].FLOATBUF0\[11\].Z sky130_fd_sc_hd__ebufn_2
XSLICE_16\[1\].RAM16.SLICE\[0\].RAM8.WORD\[0\].W.BYTE\[0\].B.genblk1.CG SLICE_16\[1\].RAM16.SLICE\[0\].RAM8.WORD\[0\].W.BYTE\[0\].B.CLK_B
+ SLICE_16\[1\].RAM16.SLICE\[0\].RAM8.WORD\[0\].W.BYTE\[0\].B.WE0_WIRE VGND VGND VPWR
+ VPWR SLICE_16\[1\].RAM16.SLICE\[0\].RAM8.WORD\[0\].W.BYTE\[0\].B.GCLK sky130_fd_sc_hd__dlclkp_1
XSLICE_16\[0\].RAM16.SLICE\[1\].RAM8.WORD\[2\].W.BYTE\[0\].B.DIODE_CLK SLICE_16\[0\].RAM16.SLICE\[1\].RAM8.WORD\[2\].W.BYTE\[0\].B.CLK
+ VGND VGND VPWR VPWR sky130_fd_sc_hd__diode_2
XSLICE_16\[1\].RAM16.SLICE\[1\].RAM8.WORD\[2\].W.BYTE\[3\].B.genblk1.CLKINV SLICE_16\[1\].RAM16.SLICE\[1\].RAM8.WORD\[2\].W.BYTE\[0\].B.CLK
+ VGND VGND VPWR VPWR SLICE_16\[1\].RAM16.SLICE\[1\].RAM8.WORD\[2\].W.BYTE\[3\].B.CLK_B
+ sky130_fd_sc_hd__inv_1
Xtap_23_27 VGND VPWR sky130_fd_sc_hd__tapvpwrvgnd_1
Xtap_23_16 VGND VPWR sky130_fd_sc_hd__tapvpwrvgnd_1
Xfill_2_0 VGND VPWR sky130_fd_sc_hd__tapvpwrvgnd_1
XSLICE_16\[1\].RAM16.SLICE\[0\].RAM8.WORD\[5\].W.BYTE\[2\].B.CGAND SLICE_16\[1\].RAM16.SLICE\[0\].RAM8.WORD\[5\].W.BYTE\[0\].B.SEL0
+ SLICE_16\[1\].RAM16.SLICE\[0\].RAM8.WE0_buf\[2\] VGND VGND VPWR VPWR SLICE_16\[1\].RAM16.SLICE\[0\].RAM8.WORD\[5\].W.BYTE\[2\].B.WE0_WIRE
+ sky130_fd_sc_hd__and2_1
XSLICE_16\[1\].RAM16.SLICE\[0\].RAM8.WORD\[2\].W.BYTE\[0\].B.BIT\[2\].OBUF0 SLICE_16\[1\].RAM16.SLICE\[0\].RAM8.WORD\[2\].W.BYTE\[0\].B.Q_WIRE\[2\]
+ SLICE_16\[1\].RAM16.SLICE\[0\].RAM8.WORD\[2\].W.BYTE\[0\].B.SEL0_B VGND VGND VPWR
+ VPWR SLICE_16\[1\].RAM16.BYTE\[0\].FLOATBUF0\[2\].Z sky130_fd_sc_hd__ebufn_2
XSLICE_16\[0\].RAM16.SLICE\[0\].RAM8.WORD\[3\].W.BYTE\[2\].B.BIT\[7\].genblk1.STORAGE
+ DIBUF\[23\].X SLICE_16\[0\].RAM16.SLICE\[0\].RAM8.WORD\[3\].W.BYTE\[2\].B.GCLK VGND
+ VGND VPWR VPWR SLICE_16\[0\].RAM16.SLICE\[0\].RAM8.WORD\[3\].W.BYTE\[2\].B.Q_WIRE\[7\]
+ sky130_fd_sc_hd__dlxtp_1
XSLICE_16\[1\].RAM16.SLICE\[0\].RAM8.WORD\[6\].W.BYTE\[3\].B.BIT\[5\].OBUF0 SLICE_16\[1\].RAM16.SLICE\[0\].RAM8.WORD\[6\].W.BYTE\[3\].B.Q_WIRE\[5\]
+ SLICE_16\[1\].RAM16.SLICE\[0\].RAM8.WORD\[6\].W.BYTE\[3\].B.SEL0_B VGND VGND VPWR
+ VPWR SLICE_16\[1\].RAM16.BYTE\[3\].FLOATBUF0\[29\].Z sky130_fd_sc_hd__ebufn_2
Xtap_12_3 VGND VPWR sky130_fd_sc_hd__tapvpwrvgnd_1
XSLICE_16\[0\].RAM16.SLICE\[0\].RAM8.WORD\[1\].W.BYTE\[0\].B.BIT\[6\].genblk1.STORAGE
+ DIBUF\[6\].X SLICE_16\[0\].RAM16.SLICE\[0\].RAM8.WORD\[1\].W.BYTE\[0\].B.GCLK VGND
+ VGND VPWR VPWR SLICE_16\[0\].RAM16.SLICE\[0\].RAM8.WORD\[1\].W.BYTE\[0\].B.Q_WIRE\[6\]
+ sky130_fd_sc_hd__dlxtp_1
Xtap_5_2 VGND VPWR sky130_fd_sc_hd__tapvpwrvgnd_1
XSLICE_16\[1\].RAM16.SLICE\[0\].RAM8.WORD\[2\].W.BYTE\[3\].B.SEL0INV SLICE_16\[1\].RAM16.SLICE\[0\].RAM8.WORD\[2\].W.BYTE\[0\].B.SEL0
+ VGND VGND VPWR VPWR SLICE_16\[1\].RAM16.SLICE\[0\].RAM8.WORD\[2\].W.BYTE\[3\].B.SEL0_B
+ sky130_fd_sc_hd__inv_1
Xfill_40_7 VGND VGND VPWR VPWR sky130_fd_sc_hd__decap_12
Xfill_26_5 VGND VPWR sky130_fd_sc_hd__tapvpwrvgnd_1
Xfill_19_4 VGND VGND VPWR VPWR sky130_fd_sc_hd__decap_12
XSLICE_16\[1\].RAM16.SLICE\[1\].RAM8.WORD\[6\].W.BYTE\[1\].B.BIT\[4\].genblk1.STORAGE
+ DIBUF\[12\].X SLICE_16\[1\].RAM16.SLICE\[1\].RAM8.WORD\[6\].W.BYTE\[1\].B.GCLK VGND
+ VGND VPWR VPWR SLICE_16\[1\].RAM16.SLICE\[1\].RAM8.WORD\[6\].W.BYTE\[1\].B.Q_WIRE\[4\]
+ sky130_fd_sc_hd__dlxtp_1
XSLICE_16\[1\].RAM16.SLICE\[1\].RAM8.WORD\[0\].W.BYTE\[2\].B.BIT\[5\].genblk1.STORAGE
+ DIBUF\[21\].X SLICE_16\[1\].RAM16.SLICE\[1\].RAM8.WORD\[0\].W.BYTE\[2\].B.GCLK VGND
+ VGND VPWR VPWR SLICE_16\[1\].RAM16.SLICE\[1\].RAM8.WORD\[0\].W.BYTE\[2\].B.Q_WIRE\[5\]
+ sky130_fd_sc_hd__dlxtp_1
XSLICE_16\[1\].RAM16.SLICE\[0\].RAM8.WORD\[7\].W.BYTE\[3\].B.BIT\[0\].genblk1.STORAGE
+ DIBUF\[24\].X SLICE_16\[1\].RAM16.SLICE\[0\].RAM8.WORD\[7\].W.BYTE\[3\].B.GCLK VGND
+ VGND VPWR VPWR SLICE_16\[1\].RAM16.SLICE\[0\].RAM8.WORD\[7\].W.BYTE\[3\].B.Q_WIRE\[0\]
+ sky130_fd_sc_hd__dlxtp_1
XSLICE_16\[1\].RAM16.SLICE\[0\].RAM8.WORD\[5\].W.BYTE\[1\].B.BIT\[2\].OBUF0 SLICE_16\[1\].RAM16.SLICE\[0\].RAM8.WORD\[5\].W.BYTE\[1\].B.Q_WIRE\[2\]
+ SLICE_16\[1\].RAM16.SLICE\[0\].RAM8.WORD\[5\].W.BYTE\[1\].B.SEL0_B VGND VGND VPWR
+ VPWR SLICE_16\[1\].RAM16.BYTE\[1\].FLOATBUF0\[10\].Z sky130_fd_sc_hd__ebufn_2
XSLICE_16\[0\].RAM16.SLICE\[1\].RAM8.WORD\[2\].W.BYTE\[3\].B.BIT\[1\].OBUF0 SLICE_16\[0\].RAM16.SLICE\[1\].RAM8.WORD\[2\].W.BYTE\[3\].B.Q_WIRE\[1\]
+ SLICE_16\[0\].RAM16.SLICE\[1\].RAM8.WORD\[2\].W.BYTE\[3\].B.SEL0_B VGND VGND VPWR
+ VPWR SLICE_16\[0\].RAM16.BYTE\[3\].FLOATBUF0\[25\].Z sky130_fd_sc_hd__ebufn_2
Xtap_18_27 VGND VPWR sky130_fd_sc_hd__tapvpwrvgnd_1
Xtap_18_16 VGND VPWR sky130_fd_sc_hd__tapvpwrvgnd_1
Xtap_34_26 VGND VPWR sky130_fd_sc_hd__tapvpwrvgnd_1
Xtap_34_15 VGND VPWR sky130_fd_sc_hd__tapvpwrvgnd_1
XSLICE_16\[0\].RAM16.SLICE\[1\].RAM8.WORD\[7\].W.BYTE\[1\].B.BIT\[0\].genblk1.STORAGE
+ DIBUF\[8\].X SLICE_16\[0\].RAM16.SLICE\[1\].RAM8.WORD\[7\].W.BYTE\[1\].B.GCLK VGND
+ VGND VPWR VPWR SLICE_16\[0\].RAM16.SLICE\[1\].RAM8.WORD\[7\].W.BYTE\[1\].B.Q_WIRE\[0\]
+ sky130_fd_sc_hd__dlxtp_1
XSLICE_16\[0\].RAM16.SLICE\[0\].RAM8.WORD\[7\].W.BYTE\[0\].B.BIT\[3\].OBUF0 SLICE_16\[0\].RAM16.SLICE\[0\].RAM8.WORD\[7\].W.BYTE\[0\].B.Q_WIRE\[3\]
+ SLICE_16\[0\].RAM16.SLICE\[0\].RAM8.WORD\[7\].W.BYTE\[0\].B.SEL0_B VGND VGND VPWR
+ VPWR SLICE_16\[0\].RAM16.BYTE\[0\].FLOATBUF0\[3\].Z sky130_fd_sc_hd__ebufn_2
XSLICE_16\[0\].RAM16.SLICE\[1\].RAM8.WORD\[1\].W.BYTE\[2\].B.BIT\[1\].genblk1.STORAGE
+ DIBUF\[17\].X SLICE_16\[0\].RAM16.SLICE\[1\].RAM8.WORD\[1\].W.BYTE\[2\].B.GCLK VGND
+ VGND VPWR VPWR SLICE_16\[0\].RAM16.SLICE\[1\].RAM8.WORD\[1\].W.BYTE\[2\].B.Q_WIRE\[1\]
+ sky130_fd_sc_hd__dlxtp_1
Xfill_22_25 VGND VGND VPWR VPWR sky130_fd_sc_hd__decap_12
Xfill_22_14 VGND VGND VPWR VPWR sky130_fd_sc_hd__decap_12
XSLICE_16\[0\].RAM16.Do0_REG.Root_CLKBUF SLICE_16\[0\].RAM16.CLKBUF.X VGND VGND VPWR
+ VPWR SLICE_16\[0\].RAM16.Do0_REG.CLK_buf sky130_fd_sc_hd__clkbuf_4
XSLICE_16\[0\].RAM16.SLICE\[1\].RAM8.WORD\[5\].W.BYTE\[3\].B.DIODE_CLK SLICE_16\[0\].RAM16.SLICE\[1\].RAM8.WORD\[5\].W.BYTE\[0\].B.CLK
+ VGND VGND VPWR VPWR sky130_fd_sc_hd__diode_2
XSLICE_16\[0\].RAM16.SLICE\[0\].RAM8.WORD\[2\].W.BYTE\[2\].B.genblk1.CLKINV SLICE_16\[0\].RAM16.SLICE\[0\].RAM8.WORD\[2\].W.BYTE\[0\].B.CLK
+ VGND VGND VPWR VPWR SLICE_16\[0\].RAM16.SLICE\[0\].RAM8.WORD\[2\].W.BYTE\[2\].B.CLK_B
+ sky130_fd_sc_hd__inv_1
XSLICE_16\[1\].RAM16.SLICE\[1\].RAM8.WORD\[6\].W.BYTE\[1\].B.CGAND SLICE_16\[1\].RAM16.SLICE\[1\].RAM8.WORD\[6\].W.BYTE\[0\].B.SEL0
+ SLICE_16\[1\].RAM16.SLICE\[1\].RAM8.WE0_buf\[1\] VGND VGND VPWR VPWR SLICE_16\[1\].RAM16.SLICE\[1\].RAM8.WORD\[6\].W.BYTE\[1\].B.WE0_WIRE
+ sky130_fd_sc_hd__and2_1
XSLICE_16\[1\].RAM16.SLICE\[1\].RAM8.WORD\[5\].W.BYTE\[0\].B.genblk1.CG SLICE_16\[1\].RAM16.SLICE\[1\].RAM8.WORD\[5\].W.BYTE\[0\].B.CLK_B
+ SLICE_16\[1\].RAM16.SLICE\[1\].RAM8.WORD\[5\].W.BYTE\[0\].B.WE0_WIRE VGND VGND VPWR
+ VPWR SLICE_16\[1\].RAM16.SLICE\[1\].RAM8.WORD\[5\].W.BYTE\[0\].B.GCLK sky130_fd_sc_hd__dlclkp_1
XSLICE_16\[1\].RAM16.SLICE\[1\].RAM8.WEBUF\[1\].__cell__ SLICE_16\[1\].RAM16.SLICE\[0\].RAM8.WE0\[1\]
+ VGND VGND VPWR VPWR SLICE_16\[1\].RAM16.SLICE\[1\].RAM8.WE0_buf\[1\] sky130_fd_sc_hd__clkbuf_2
Xfill_22_69 VGND VPWR sky130_fd_sc_hd__tapvpwrvgnd_1
Xfill_22_58 VGND VGND VPWR VPWR sky130_fd_sc_hd__decap_12
Xfill_22_47 VGND VGND VPWR VPWR sky130_fd_sc_hd__decap_12
Xfill_22_36 VGND VPWR sky130_fd_sc_hd__tapvpwrvgnd_1
Xtap_5_30 VGND VPWR sky130_fd_sc_hd__tapvpwrvgnd_1
Xfill_47_66 VGND VGND VPWR VPWR sky130_fd_sc_hd__decap_6
Xfill_47_55 VGND VGND VPWR VPWR sky130_fd_sc_hd__decap_12
Xfill_47_44 VGND VGND VPWR VPWR sky130_fd_sc_hd__decap_12
Xfill_47_33 VGND VPWR sky130_fd_sc_hd__tapvpwrvgnd_1
Xfill_47_22 VGND VGND VPWR VPWR sky130_fd_sc_hd__decap_12
Xfill_47_11 VGND VGND VPWR VPWR sky130_fd_sc_hd__decap_12
XSLICE_16\[1\].RAM16.SLICE\[1\].RAM8.WORD\[7\].W.BYTE\[0\].B.DIODE_CLK SLICE_16\[1\].RAM16.SLICE\[1\].RAM8.WORD\[7\].W.BYTE\[0\].B.CLK
+ VGND VGND VPWR VPWR sky130_fd_sc_hd__diode_2
XSLICE_16\[1\].RAM16.SLICE\[1\].RAM8.WORD\[6\].W.CLKBUF SLICE_16\[1\].RAM16.SLICE\[1\].RAM8.CLKBUF.X
+ VGND VGND VPWR VPWR SLICE_16\[1\].RAM16.SLICE\[1\].RAM8.WORD\[6\].W.BYTE\[0\].B.CLK
+ sky130_fd_sc_hd__clkbuf_4
XSLICE_16\[0\].RAM16.SLICE\[0\].RAM8.WORD\[6\].W.BYTE\[3\].B.BIT\[7\].genblk1.STORAGE
+ DIBUF\[31\].X SLICE_16\[0\].RAM16.SLICE\[0\].RAM8.WORD\[6\].W.BYTE\[3\].B.GCLK VGND
+ VGND VPWR VPWR SLICE_16\[0\].RAM16.SLICE\[0\].RAM8.WORD\[6\].W.BYTE\[3\].B.Q_WIRE\[7\]
+ sky130_fd_sc_hd__dlxtp_1
Xtap_10_0 VGND VPWR sky130_fd_sc_hd__tapvpwrvgnd_1
XSLICE_16\[0\].RAM16.SLICE\[0\].RAM8.WORD\[4\].W.BYTE\[1\].B.BIT\[6\].genblk1.STORAGE
+ DIBUF\[14\].X SLICE_16\[0\].RAM16.SLICE\[0\].RAM8.WORD\[4\].W.BYTE\[1\].B.GCLK VGND
+ VGND VPWR VPWR SLICE_16\[0\].RAM16.SLICE\[0\].RAM8.WORD\[4\].W.BYTE\[1\].B.Q_WIRE\[6\]
+ sky130_fd_sc_hd__dlxtp_1
XSLICE_16\[1\].RAM16.SLICE\[1\].RAM8.WORD\[0\].W.BYTE\[2\].B.BIT\[5\].OBUF0 SLICE_16\[1\].RAM16.SLICE\[1\].RAM8.WORD\[0\].W.BYTE\[2\].B.Q_WIRE\[5\]
+ SLICE_16\[1\].RAM16.SLICE\[1\].RAM8.WORD\[0\].W.BYTE\[2\].B.SEL0_B VGND VGND VPWR
+ VPWR SLICE_16\[1\].RAM16.BYTE\[2\].FLOATBUF0\[21\].Z sky130_fd_sc_hd__ebufn_2
XSLICE_16\[0\].RAM16.Do0_REG.Do_CLKBUF\[2\] SLICE_16\[0\].RAM16.Do0_REG.CLK_buf VGND
+ VGND VPWR VPWR SLICE_16\[0\].RAM16.Do0_REG.CLKBUF\[2\] sky130_fd_sc_hd__clkbuf_4
Xfill_31_3 VGND VGND VPWR VPWR sky130_fd_sc_hd__decap_6
Xfill_24_2 VGND VPWR sky130_fd_sc_hd__tapvpwrvgnd_1
XSLICE_16\[0\].RAM16.SLICE\[0\].RAM8.WORD\[0\].W.BYTE\[3\].B.BIT\[0\].OBUF0 SLICE_16\[0\].RAM16.SLICE\[0\].RAM8.WORD\[0\].W.BYTE\[3\].B.Q_WIRE\[0\]
+ SLICE_16\[0\].RAM16.SLICE\[0\].RAM8.WORD\[0\].W.BYTE\[3\].B.SEL0_B VGND VGND VPWR
+ VPWR SLICE_16\[0\].RAM16.BYTE\[3\].FLOATBUF0\[24\].Z sky130_fd_sc_hd__ebufn_2
XSLICE_16\[0\].RAM16.SLICE\[1\].RAM8.WORD\[2\].W.BYTE\[1\].B.BIT\[6\].OBUF0 SLICE_16\[0\].RAM16.SLICE\[1\].RAM8.WORD\[2\].W.BYTE\[1\].B.Q_WIRE\[6\]
+ SLICE_16\[0\].RAM16.SLICE\[1\].RAM8.WORD\[2\].W.BYTE\[1\].B.SEL0_B VGND VGND VPWR
+ VPWR SLICE_16\[0\].RAM16.BYTE\[1\].FLOATBUF0\[14\].Z sky130_fd_sc_hd__ebufn_2
Xfill_17_1 VGND VGND VPWR VPWR sky130_fd_sc_hd__decap_12
XSLICE_16\[0\].RAM16.SLICE\[0\].RAM8.WORD\[5\].W.BYTE\[3\].B.genblk1.CLKINV SLICE_16\[0\].RAM16.SLICE\[0\].RAM8.WORD\[5\].W.BYTE\[0\].B.CLK
+ VGND VGND VPWR VPWR SLICE_16\[0\].RAM16.SLICE\[0\].RAM8.WORD\[5\].W.BYTE\[3\].B.CLK_B
+ sky130_fd_sc_hd__inv_1
Xtap_39_8 VGND VPWR sky130_fd_sc_hd__tapvpwrvgnd_1
Xtap_29_26 VGND VPWR sky130_fd_sc_hd__tapvpwrvgnd_1
Xtap_29_15 VGND VPWR sky130_fd_sc_hd__tapvpwrvgnd_1
XSLICE_16\[1\].RAM16.SLICE\[1\].RAM8.WORD\[7\].W.BYTE\[0\].B.BIT\[3\].genblk1.STORAGE
+ DIBUF\[3\].X SLICE_16\[1\].RAM16.SLICE\[1\].RAM8.WORD\[7\].W.BYTE\[0\].B.GCLK VGND
+ VGND VPWR VPWR SLICE_16\[1\].RAM16.SLICE\[1\].RAM8.WORD\[7\].W.BYTE\[0\].B.Q_WIRE\[3\]
+ sky130_fd_sc_hd__dlxtp_1
XSLICE_16\[1\].RAM16.SLICE\[1\].RAM8.WORD\[3\].W.BYTE\[3\].B.BIT\[5\].genblk1.STORAGE
+ DIBUF\[29\].X SLICE_16\[1\].RAM16.SLICE\[1\].RAM8.WORD\[3\].W.BYTE\[3\].B.GCLK VGND
+ VGND VPWR VPWR SLICE_16\[1\].RAM16.SLICE\[1\].RAM8.WORD\[3\].W.BYTE\[3\].B.Q_WIRE\[5\]
+ sky130_fd_sc_hd__dlxtp_1
Xfill_17_69 VGND VGND VPWR VPWR sky130_fd_sc_hd__decap_6
Xfill_17_58 VGND VGND VPWR VPWR sky130_fd_sc_hd__decap_12
Xfill_17_47 VGND VGND VPWR VPWR sky130_fd_sc_hd__decap_12
Xfill_17_36 VGND VPWR sky130_fd_sc_hd__tapvpwrvgnd_1
Xfill_17_25 VGND VGND VPWR VPWR sky130_fd_sc_hd__decap_12
Xfill_17_14 VGND VGND VPWR VPWR sky130_fd_sc_hd__decap_12
XSLICE_16\[1\].RAM16.Do0_REG.OUTREG_BYTE\[3\].Do_FF\[5\] SLICE_16\[1\].RAM16.Do0_REG.CLKBUF\[3\]
+ SLICE_16\[1\].RAM16.BYTE\[3\].FLOATBUF0\[29\].Z VGND VGND VPWR VPWR Do0MUX.A1\[29\]
+ sky130_fd_sc_hd__dfxtp_1
XSLICE_16\[1\].RAM16.SLICE\[1\].RAM8.WORD\[3\].W.BYTE\[3\].B.BIT\[5\].OBUF0 SLICE_16\[1\].RAM16.SLICE\[1\].RAM8.WORD\[3\].W.BYTE\[3\].B.Q_WIRE\[5\]
+ SLICE_16\[1\].RAM16.SLICE\[1\].RAM8.WORD\[3\].W.BYTE\[3\].B.SEL0_B VGND VGND VPWR
+ VPWR SLICE_16\[1\].RAM16.BYTE\[3\].FLOATBUF0\[29\].Z sky130_fd_sc_hd__ebufn_2
XSLICE_16\[1\].RAM16.SLICE\[1\].RAM8.WORD\[1\].W.BYTE\[1\].B.BIT\[4\].genblk1.STORAGE
+ DIBUF\[12\].X SLICE_16\[1\].RAM16.SLICE\[1\].RAM8.WORD\[1\].W.BYTE\[1\].B.GCLK VGND
+ VGND VPWR VPWR SLICE_16\[1\].RAM16.SLICE\[1\].RAM8.WORD\[1\].W.BYTE\[1\].B.Q_WIRE\[4\]
+ sky130_fd_sc_hd__dlxtp_1
XSLICE_16\[1\].RAM16.SLICE\[0\].RAM8.WORD\[2\].W.BYTE\[3\].B.BIT\[0\].genblk1.STORAGE
+ DIBUF\[24\].X SLICE_16\[1\].RAM16.SLICE\[0\].RAM8.WORD\[2\].W.BYTE\[3\].B.GCLK VGND
+ VGND VPWR VPWR SLICE_16\[1\].RAM16.SLICE\[0\].RAM8.WORD\[2\].W.BYTE\[3\].B.Q_WIRE\[0\]
+ sky130_fd_sc_hd__dlxtp_1
XSLICE_16\[0\].RAM16.SLICE\[1\].RAM8.WORD\[4\].W.BYTE\[3\].B.BIT\[1\].genblk1.STORAGE
+ DIBUF\[25\].X SLICE_16\[0\].RAM16.SLICE\[1\].RAM8.WORD\[4\].W.BYTE\[3\].B.GCLK VGND
+ VGND VPWR VPWR SLICE_16\[0\].RAM16.SLICE\[1\].RAM8.WORD\[4\].W.BYTE\[3\].B.Q_WIRE\[1\]
+ sky130_fd_sc_hd__dlxtp_1
XSLICE_16\[1\].RAM16.SLICE\[0\].RAM8.WORD\[6\].W.BYTE\[1\].B.SEL0INV SLICE_16\[1\].RAM16.SLICE\[0\].RAM8.WORD\[6\].W.BYTE\[0\].B.SEL0
+ VGND VGND VPWR VPWR SLICE_16\[1\].RAM16.SLICE\[0\].RAM8.WORD\[6\].W.BYTE\[1\].B.SEL0_B
+ sky130_fd_sc_hd__inv_1
XSLICE_16\[1\].RAM16.SLICE\[0\].RAM8.WEBUF\[3\].__cell__ SLICE_16\[1\].RAM16.SLICE\[0\].RAM8.WE0\[3\]
+ VGND VGND VPWR VPWR SLICE_16\[1\].RAM16.SLICE\[0\].RAM8.WE0_buf\[3\] sky130_fd_sc_hd__clkbuf_2
XSLICE_16\[0\].RAM16.SLICE\[1\].RAM8.WORD\[5\].W.BYTE\[2\].B.BIT\[6\].OBUF0 SLICE_16\[0\].RAM16.SLICE\[1\].RAM8.WORD\[5\].W.BYTE\[2\].B.Q_WIRE\[6\]
+ SLICE_16\[0\].RAM16.SLICE\[1\].RAM8.WORD\[5\].W.BYTE\[2\].B.SEL0_B VGND VGND VPWR
+ VPWR SLICE_16\[0\].RAM16.BYTE\[2\].FLOATBUF0\[22\].Z sky130_fd_sc_hd__ebufn_2
XSLICE_16\[0\].RAM16.SLICE\[1\].RAM8.WORD\[2\].W.BYTE\[1\].B.BIT\[0\].genblk1.STORAGE
+ DIBUF\[8\].X SLICE_16\[0\].RAM16.SLICE\[1\].RAM8.WORD\[2\].W.BYTE\[1\].B.GCLK VGND
+ VGND VPWR VPWR SLICE_16\[0\].RAM16.SLICE\[1\].RAM8.WORD\[2\].W.BYTE\[1\].B.Q_WIRE\[0\]
+ sky130_fd_sc_hd__dlxtp_1
XSLICE_16\[0\].RAM16.SLICE\[0\].RAM8.WORD\[0\].W.BYTE\[1\].B.BIT\[5\].OBUF0 SLICE_16\[0\].RAM16.SLICE\[0\].RAM8.WORD\[0\].W.BYTE\[1\].B.Q_WIRE\[5\]
+ SLICE_16\[0\].RAM16.SLICE\[0\].RAM8.WORD\[0\].W.BYTE\[1\].B.SEL0_B VGND VGND VPWR
+ VPWR SLICE_16\[0\].RAM16.BYTE\[1\].FLOATBUF0\[13\].Z sky130_fd_sc_hd__ebufn_2
XSLICE_16\[1\].RAM16.SLICE\[1\].RAM8.WORD\[2\].W.BYTE\[1\].B.BIT\[2\].OBUF0 SLICE_16\[1\].RAM16.SLICE\[1\].RAM8.WORD\[2\].W.BYTE\[1\].B.Q_WIRE\[2\]
+ SLICE_16\[1\].RAM16.SLICE\[1\].RAM8.WORD\[2\].W.BYTE\[1\].B.SEL0_B VGND VGND VPWR
+ VPWR SLICE_16\[1\].RAM16.BYTE\[1\].FLOATBUF0\[10\].Z sky130_fd_sc_hd__ebufn_2
XSLICE_16\[1\].RAM16.SLICE\[0\].RAM8.WORD\[1\].W.BYTE\[1\].B.CGAND SLICE_16\[1\].RAM16.SLICE\[0\].RAM8.WORD\[1\].W.BYTE\[0\].B.SEL0
+ SLICE_16\[1\].RAM16.SLICE\[0\].RAM8.WE0_buf\[1\] VGND VGND VPWR VPWR SLICE_16\[1\].RAM16.SLICE\[0\].RAM8.WORD\[1\].W.BYTE\[1\].B.WE0_WIRE
+ sky130_fd_sc_hd__and2_1
XSLICE_16\[0\].RAM16.SLICE\[0\].RAM8.WORD\[1\].W.BYTE\[3\].B.BIT\[7\].genblk1.STORAGE
+ DIBUF\[31\].X SLICE_16\[0\].RAM16.SLICE\[0\].RAM8.WORD\[1\].W.BYTE\[3\].B.GCLK VGND
+ VGND VPWR VPWR SLICE_16\[0\].RAM16.SLICE\[0\].RAM8.WORD\[1\].W.BYTE\[3\].B.Q_WIRE\[7\]
+ sky130_fd_sc_hd__dlxtp_1
XSLICE_16\[0\].RAM16.SLICE\[0\].RAM8.WORD\[7\].W.BYTE\[2\].B.BIT\[6\].genblk1.STORAGE
+ DIBUF\[22\].X SLICE_16\[0\].RAM16.SLICE\[0\].RAM8.WORD\[7\].W.BYTE\[2\].B.GCLK VGND
+ VGND VPWR VPWR SLICE_16\[0\].RAM16.SLICE\[0\].RAM8.WORD\[7\].W.BYTE\[2\].B.Q_WIRE\[6\]
+ sky130_fd_sc_hd__dlxtp_1
XDo0MUX.M\[1\].MUX\[1\] Do0MUX.A0\[9\] Do0MUX.A1\[9\] Do0MUX.SEL\[1\] VGND VGND VPWR
+ VPWR Do0[9] sky130_fd_sc_hd__mux2_1
Xtap_15_28 VGND VPWR sky130_fd_sc_hd__tapvpwrvgnd_1
Xtap_15_17 VGND VPWR sky130_fd_sc_hd__tapvpwrvgnd_1
XSLICE_16\[0\].RAM16.SLICE\[0\].RAM8.WORD\[5\].W.BYTE\[0\].B.BIT\[5\].genblk1.STORAGE
+ DIBUF\[5\].X SLICE_16\[0\].RAM16.SLICE\[0\].RAM8.WORD\[5\].W.BYTE\[0\].B.GCLK VGND
+ VGND VPWR VPWR SLICE_16\[0\].RAM16.SLICE\[0\].RAM8.WORD\[5\].W.BYTE\[0\].B.Q_WIRE\[5\]
+ sky130_fd_sc_hd__dlxtp_1
Xtap_31_27 VGND VPWR sky130_fd_sc_hd__tapvpwrvgnd_1
Xtap_31_16 VGND VPWR sky130_fd_sc_hd__tapvpwrvgnd_1
Xtap_37_5 VGND VPWR sky130_fd_sc_hd__tapvpwrvgnd_1
XSLICE_16\[0\].RAM16.SLICE\[1\].RAM8.WORD\[4\].W.BYTE\[0\].B.BIT\[3\].OBUF0 SLICE_16\[0\].RAM16.SLICE\[1\].RAM8.WORD\[4\].W.BYTE\[0\].B.Q_WIRE\[3\]
+ SLICE_16\[0\].RAM16.SLICE\[1\].RAM8.WORD\[4\].W.BYTE\[0\].B.SEL0_B VGND VGND VPWR
+ VPWR SLICE_16\[0\].RAM16.BYTE\[0\].FLOATBUF0\[3\].Z sky130_fd_sc_hd__ebufn_2
Xtap_2_31 VGND VPWR sky130_fd_sc_hd__tapvpwrvgnd_1
Xtap_2_20 VGND VPWR sky130_fd_sc_hd__tapvpwrvgnd_1
XSLICE_16\[0\].RAM16.SLICE\[0\].RAM8.WORD\[4\].W.BYTE\[2\].B.SEL0INV SLICE_16\[0\].RAM16.SLICE\[0\].RAM8.WORD\[4\].W.BYTE\[0\].B.SEL0
+ VGND VGND VPWR VPWR SLICE_16\[0\].RAM16.SLICE\[0\].RAM8.WORD\[4\].W.BYTE\[2\].B.SEL0_B
+ sky130_fd_sc_hd__inv_1
XSLICE_16\[1\].RAM16.SLICE\[0\].RAM8.WORD\[1\].W.BYTE\[3\].B.genblk1.CG SLICE_16\[1\].RAM16.SLICE\[0\].RAM8.WORD\[1\].W.BYTE\[3\].B.CLK_B
+ SLICE_16\[1\].RAM16.SLICE\[0\].RAM8.WORD\[1\].W.BYTE\[3\].B.WE0_WIRE VGND VGND VPWR
+ VPWR SLICE_16\[1\].RAM16.SLICE\[0\].RAM8.WORD\[1\].W.BYTE\[3\].B.GCLK sky130_fd_sc_hd__dlclkp_1
XSLICE_16\[1\].RAM16.SLICE\[0\].RAM8.WORD\[1\].W.BYTE\[3\].B.BIT\[4\].OBUF0 SLICE_16\[1\].RAM16.SLICE\[0\].RAM8.WORD\[1\].W.BYTE\[3\].B.Q_WIRE\[4\]
+ SLICE_16\[1\].RAM16.SLICE\[0\].RAM8.WORD\[1\].W.BYTE\[3\].B.SEL0_B VGND VGND VPWR
+ VPWR SLICE_16\[1\].RAM16.BYTE\[3\].FLOATBUF0\[28\].Z sky130_fd_sc_hd__ebufn_2
Xfill_44_89 VGND VGND VPWR VPWR sky130_fd_sc_hd__decap_12
Xfill_44_78 VGND VPWR sky130_fd_sc_hd__tapvpwrvgnd_1
Xfill_44_67 VGND VGND VPWR VPWR sky130_fd_sc_hd__decap_12
Xfill_44_56 VGND VGND VPWR VPWR sky130_fd_sc_hd__decap_12
Xfill_44_45 VGND VPWR sky130_fd_sc_hd__tapvpwrvgnd_1
Xfill_44_34 VGND VGND VPWR VPWR sky130_fd_sc_hd__decap_12
Xfill_44_23 VGND VGND VPWR VPWR sky130_fd_sc_hd__decap_12
Xfill_44_12 VGND VPWR sky130_fd_sc_hd__tapvpwrvgnd_1
XSLICE_16\[0\].RAM16.SLICE\[0\].RAM8.WORD\[3\].W.BYTE\[2\].B.BIT\[5\].OBUF0 SLICE_16\[0\].RAM16.SLICE\[0\].RAM8.WORD\[3\].W.BYTE\[2\].B.Q_WIRE\[5\]
+ SLICE_16\[0\].RAM16.SLICE\[0\].RAM8.WORD\[3\].W.BYTE\[2\].B.SEL0_B VGND VGND VPWR
+ VPWR SLICE_16\[0\].RAM16.BYTE\[2\].FLOATBUF0\[21\].Z sky130_fd_sc_hd__ebufn_2
XDo0MUX.M\[0\].MUX\[3\] Do0MUX.A0\[3\] Do0MUX.A1\[3\] Do0MUX.SEL\[0\] VGND VGND VPWR
+ VPWR Do0[3] sky130_fd_sc_hd__mux2_1
XSLICE_16\[1\].RAM16.SLICE\[1\].RAM8.WORD\[5\].W.BYTE\[2\].B.BIT\[2\].OBUF0 SLICE_16\[1\].RAM16.SLICE\[1\].RAM8.WORD\[5\].W.BYTE\[2\].B.Q_WIRE\[2\]
+ SLICE_16\[1\].RAM16.SLICE\[1\].RAM8.WORD\[5\].W.BYTE\[2\].B.SEL0_B VGND VGND VPWR
+ VPWR SLICE_16\[1\].RAM16.BYTE\[2\].FLOATBUF0\[18\].Z sky130_fd_sc_hd__ebufn_2
XSLICE_16\[1\].RAM16.SLICE\[1\].RAM8.WORD\[4\].W.BYTE\[2\].B.BIT\[4\].genblk1.STORAGE
+ DIBUF\[20\].X SLICE_16\[1\].RAM16.SLICE\[1\].RAM8.WORD\[4\].W.BYTE\[2\].B.GCLK VGND
+ VGND VPWR VPWR SLICE_16\[1\].RAM16.SLICE\[1\].RAM8.WORD\[4\].W.BYTE\[2\].B.Q_WIRE\[4\]
+ sky130_fd_sc_hd__dlxtp_1
XSLICE_16\[0\].RAM16.SLICE\[0\].RAM8.WORD\[3\].W.BYTE\[3\].B.CGAND SLICE_16\[0\].RAM16.SLICE\[0\].RAM8.WORD\[3\].W.BYTE\[0\].B.SEL0
+ SLICE_16\[0\].RAM16.SLICE\[0\].RAM8.WE0_buf\[3\] VGND VGND VPWR VPWR SLICE_16\[0\].RAM16.SLICE\[0\].RAM8.WORD\[3\].W.BYTE\[3\].B.WE0_WIRE
+ sky130_fd_sc_hd__and2_1
XSLICE_16\[1\].RAM16.SLICE\[1\].RAM8.WORD\[2\].W.BYTE\[0\].B.BIT\[3\].genblk1.STORAGE
+ DIBUF\[3\].X SLICE_16\[1\].RAM16.SLICE\[1\].RAM8.WORD\[2\].W.BYTE\[0\].B.GCLK VGND
+ VGND VPWR VPWR SLICE_16\[1\].RAM16.SLICE\[1\].RAM8.WORD\[2\].W.BYTE\[0\].B.Q_WIRE\[3\]
+ sky130_fd_sc_hd__dlxtp_1
XSLICE_16\[0\].RAM16.Do0_REG.OUTREG_BYTE\[2\].DIODE\[5\] SLICE_16\[0\].RAM16.BYTE\[2\].FLOATBUF0\[21\].Z
+ VGND VGND VPWR VPWR sky130_fd_sc_hd__diode_2
Xfill_6_7 VGND VPWR sky130_fd_sc_hd__tapvpwrvgnd_1
XSLICE_16\[1\].RAM16.SLICE\[0\].RAM8.WORD\[0\].W.BYTE\[1\].B.BIT\[1\].OBUF0 SLICE_16\[1\].RAM16.SLICE\[0\].RAM8.WORD\[0\].W.BYTE\[1\].B.Q_WIRE\[1\]
+ SLICE_16\[1\].RAM16.SLICE\[0\].RAM8.WORD\[0\].W.BYTE\[1\].B.SEL0_B VGND VGND VPWR
+ VPWR SLICE_16\[1\].RAM16.BYTE\[1\].FLOATBUF0\[9\].Z sky130_fd_sc_hd__ebufn_2
XSLICE_16\[0\].RAM16.SLICE\[1\].RAM8.WORD\[7\].W.BYTE\[1\].B.BIT\[3\].OBUF0 SLICE_16\[0\].RAM16.SLICE\[1\].RAM8.WORD\[7\].W.BYTE\[1\].B.Q_WIRE\[3\]
+ SLICE_16\[0\].RAM16.SLICE\[1\].RAM8.WORD\[7\].W.BYTE\[1\].B.SEL0_B VGND VGND VPWR
+ VPWR SLICE_16\[0\].RAM16.BYTE\[1\].FLOATBUF0\[11\].Z sky130_fd_sc_hd__ebufn_2
XDo0MUX.M\[2\].DIODE_A1MUX\[20\] Do0MUX.A1\[20\] VGND VGND VPWR VPWR sky130_fd_sc_hd__diode_2
XSLICE_16\[0\].RAM16.SLICE\[1\].RAM8.WORD\[5\].W.BYTE\[2\].B.BIT\[0\].genblk1.STORAGE
+ DIBUF\[16\].X SLICE_16\[0\].RAM16.SLICE\[1\].RAM8.WORD\[5\].W.BYTE\[2\].B.GCLK VGND
+ VGND VPWR VPWR SLICE_16\[0\].RAM16.SLICE\[1\].RAM8.WORD\[5\].W.BYTE\[2\].B.Q_WIRE\[0\]
+ sky130_fd_sc_hd__dlxtp_1
XSLICE_16\[0\].RAM16.SLICE\[1\].RAM8.WORD\[2\].W.BYTE\[3\].B.genblk1.CLKINV SLICE_16\[0\].RAM16.SLICE\[1\].RAM8.WORD\[2\].W.BYTE\[0\].B.CLK
+ VGND VGND VPWR VPWR SLICE_16\[0\].RAM16.SLICE\[1\].RAM8.WORD\[2\].W.BYTE\[3\].B.CLK_B
+ sky130_fd_sc_hd__inv_1
XSLICE_16\[1\].RAM16.SLICE\[1\].RAM8.WORD\[2\].W.BYTE\[0\].B.CGAND SLICE_16\[1\].RAM16.SLICE\[1\].RAM8.WORD\[2\].W.BYTE\[0\].B.SEL0
+ SLICE_16\[1\].RAM16.SLICE\[1\].RAM8.WE0_buf\[0\] VGND VGND VPWR VPWR SLICE_16\[1\].RAM16.SLICE\[1\].RAM8.WORD\[2\].W.BYTE\[0\].B.WE0_WIRE
+ sky130_fd_sc_hd__and2_1
Xtap_26_27 VGND VPWR sky130_fd_sc_hd__tapvpwrvgnd_1
Xtap_26_16 VGND VPWR sky130_fd_sc_hd__tapvpwrvgnd_1
Xtap_9_9 VGND VPWR sky130_fd_sc_hd__tapvpwrvgnd_1
XSLICE_16\[0\].RAM16.SLICE\[0\].RAM8.WORD\[2\].W.BYTE\[0\].B.BIT\[2\].OBUF0 SLICE_16\[0\].RAM16.SLICE\[0\].RAM8.WORD\[2\].W.BYTE\[0\].B.Q_WIRE\[2\]
+ SLICE_16\[0\].RAM16.SLICE\[0\].RAM8.WORD\[2\].W.BYTE\[0\].B.SEL0_B VGND VGND VPWR
+ VPWR SLICE_16\[0\].RAM16.BYTE\[0\].FLOATBUF0\[2\].Z sky130_fd_sc_hd__ebufn_2
XSLICE_16\[0\].RAM16.SLICE\[0\].RAM8.WORD\[6\].W.BYTE\[3\].B.BIT\[5\].OBUF0 SLICE_16\[0\].RAM16.SLICE\[0\].RAM8.WORD\[6\].W.BYTE\[3\].B.Q_WIRE\[5\]
+ SLICE_16\[0\].RAM16.SLICE\[0\].RAM8.WORD\[6\].W.BYTE\[3\].B.SEL0_B VGND VGND VPWR
+ VPWR SLICE_16\[0\].RAM16.BYTE\[3\].FLOATBUF0\[29\].Z sky130_fd_sc_hd__ebufn_2
Xfill_39_67 VGND VGND VPWR VPWR sky130_fd_sc_hd__decap_4
Xfill_39_56 VGND VGND VPWR VPWR sky130_fd_sc_hd__decap_12
Xfill_39_45 VGND VPWR sky130_fd_sc_hd__tapvpwrvgnd_1
Xfill_39_34 VGND VGND VPWR VPWR sky130_fd_sc_hd__decap_12
Xfill_39_23 VGND VGND VPWR VPWR sky130_fd_sc_hd__decap_12
Xfill_39_12 VGND VPWR sky130_fd_sc_hd__tapvpwrvgnd_1
Xtap_35_2 VGND VPWR sky130_fd_sc_hd__tapvpwrvgnd_1
Xtap_28_1 VGND VPWR sky130_fd_sc_hd__tapvpwrvgnd_1
XSLICE_16\[0\].RAM16.SLICE\[0\].RAM8.WORD\[2\].W.BYTE\[2\].B.BIT\[6\].genblk1.STORAGE
+ DIBUF\[22\].X SLICE_16\[0\].RAM16.SLICE\[0\].RAM8.WORD\[2\].W.BYTE\[2\].B.GCLK VGND
+ VGND VPWR VPWR SLICE_16\[0\].RAM16.SLICE\[0\].RAM8.WORD\[2\].W.BYTE\[2\].B.Q_WIRE\[6\]
+ sky130_fd_sc_hd__dlxtp_1
XDo0MUX.M\[3\].DIODE_A1MUX\[24\] Do0MUX.A1\[24\] VGND VGND VPWR VPWR sky130_fd_sc_hd__diode_2
XSLICE_16\[0\].RAM16.SLICE\[1\].RAM8.WORD\[4\].W.BYTE\[0\].B.genblk1.CG SLICE_16\[0\].RAM16.SLICE\[1\].RAM8.WORD\[4\].W.BYTE\[0\].B.CLK_B
+ SLICE_16\[0\].RAM16.SLICE\[1\].RAM8.WORD\[4\].W.BYTE\[0\].B.WE0_WIRE VGND VGND VPWR
+ VPWR SLICE_16\[0\].RAM16.SLICE\[1\].RAM8.WORD\[4\].W.BYTE\[0\].B.GCLK sky130_fd_sc_hd__dlclkp_1
XSLICE_16\[0\].RAM16.SLICE\[0\].RAM8.WORD\[0\].W.BYTE\[0\].B.BIT\[5\].genblk1.STORAGE
+ DIBUF\[5\].X SLICE_16\[0\].RAM16.SLICE\[0\].RAM8.WORD\[0\].W.BYTE\[0\].B.GCLK VGND
+ VGND VPWR VPWR SLICE_16\[0\].RAM16.SLICE\[0\].RAM8.WORD\[0\].W.BYTE\[0\].B.Q_WIRE\[5\]
+ sky130_fd_sc_hd__dlxtp_1
XSLICE_16\[1\].RAM16.SLICE\[1\].RAM8.WORD\[5\].W.BYTE\[0\].B.BIT\[7\].OBUF0 SLICE_16\[1\].RAM16.SLICE\[1\].RAM8.WORD\[5\].W.BYTE\[0\].B.Q_WIRE\[7\]
+ SLICE_16\[1\].RAM16.SLICE\[1\].RAM8.WORD\[5\].W.BYTE\[0\].B.SEL0_B VGND VGND VPWR
+ VPWR SLICE_16\[1\].RAM16.BYTE\[0\].FLOATBUF0\[7\].Z sky130_fd_sc_hd__ebufn_2
XSLICE_16\[1\].RAM16.SLICE\[0\].RAM8.WORD\[3\].W.BYTE\[2\].B.BIT\[1\].OBUF0 SLICE_16\[1\].RAM16.SLICE\[0\].RAM8.WORD\[3\].W.BYTE\[2\].B.Q_WIRE\[1\]
+ SLICE_16\[1\].RAM16.SLICE\[0\].RAM8.WORD\[3\].W.BYTE\[2\].B.SEL0_B VGND VGND VPWR
+ VPWR SLICE_16\[1\].RAM16.BYTE\[2\].FLOATBUF0\[17\].Z sky130_fd_sc_hd__ebufn_2
XSLICE_16\[1\].RAM16.SLICE\[1\].RAM8.WORD\[6\].W.BYTE\[3\].B.genblk1.CG SLICE_16\[1\].RAM16.SLICE\[1\].RAM8.WORD\[6\].W.BYTE\[3\].B.CLK_B
+ SLICE_16\[1\].RAM16.SLICE\[1\].RAM8.WORD\[6\].W.BYTE\[3\].B.WE0_WIRE VGND VGND VPWR
+ VPWR SLICE_16\[1\].RAM16.SLICE\[1\].RAM8.WORD\[6\].W.BYTE\[3\].B.GCLK sky130_fd_sc_hd__dlclkp_1
Xfill_20_80 VGND VGND VPWR VPWR sky130_fd_sc_hd__decap_12
Xfill_20_91 VGND VGND VPWR VPWR sky130_fd_sc_hd__decap_12
XSLICE_16\[0\].RAM16.Do0_REG.OUTREG_BYTE\[1\].Do_FF\[6\] SLICE_16\[0\].RAM16.Do0_REG.CLKBUF\[1\]
+ SLICE_16\[0\].RAM16.BYTE\[1\].FLOATBUF0\[14\].Z VGND VGND VPWR VPWR Do0MUX.A0\[14\]
+ sky130_fd_sc_hd__dfxtp_1
XSLICE_16\[0\].RAM16.SLICE\[1\].RAM8.WORD\[4\].W.BYTE\[2\].B.CGAND SLICE_16\[0\].RAM16.SLICE\[1\].RAM8.WORD\[4\].W.BYTE\[0\].B.SEL0
+ SLICE_16\[0\].RAM16.SLICE\[1\].RAM8.WE0_buf\[2\] VGND VGND VPWR VPWR SLICE_16\[0\].RAM16.SLICE\[1\].RAM8.WORD\[4\].W.BYTE\[2\].B.WE0_WIRE
+ sky130_fd_sc_hd__and2_1
Xtap_12_18 VGND VPWR sky130_fd_sc_hd__tapvpwrvgnd_1
Xfill_4_4 VGND VGND VPWR VPWR sky130_fd_sc_hd__decap_4
XSLICE_16\[0\].RAM16.SLICE\[0\].RAM8.WORD\[5\].W.BYTE\[1\].B.BIT\[2\].OBUF0 SLICE_16\[0\].RAM16.SLICE\[0\].RAM8.WORD\[5\].W.BYTE\[1\].B.Q_WIRE\[2\]
+ SLICE_16\[0\].RAM16.SLICE\[0\].RAM8.WORD\[5\].W.BYTE\[1\].B.SEL0_B VGND VGND VPWR
+ VPWR SLICE_16\[0\].RAM16.BYTE\[1\].FLOATBUF0\[10\].Z sky130_fd_sc_hd__ebufn_2
XSLICE_16\[1\].RAM16.SLICE\[1\].RAM8.WORD\[7\].W.BYTE\[3\].B.BIT\[4\].genblk1.STORAGE
+ DIBUF\[28\].X SLICE_16\[1\].RAM16.SLICE\[1\].RAM8.WORD\[7\].W.BYTE\[3\].B.GCLK VGND
+ VGND VPWR VPWR SLICE_16\[1\].RAM16.SLICE\[1\].RAM8.WORD\[7\].W.BYTE\[3\].B.Q_WIRE\[4\]
+ sky130_fd_sc_hd__dlxtp_1
XSLICE_16\[1\].RAM16.SLICE\[1\].RAM8.WORD\[6\].W.BYTE\[3\].B.SEL0INV SLICE_16\[1\].RAM16.SLICE\[1\].RAM8.WORD\[6\].W.BYTE\[0\].B.SEL0
+ VGND VGND VPWR VPWR SLICE_16\[1\].RAM16.SLICE\[1\].RAM8.WORD\[6\].W.BYTE\[3\].B.SEL0_B
+ sky130_fd_sc_hd__inv_1
Xtap_12_29 VGND VPWR sky130_fd_sc_hd__tapvpwrvgnd_1
Xtap_37_26 VGND VPWR sky130_fd_sc_hd__tapvpwrvgnd_1
Xtap_37_15 VGND VPWR sky130_fd_sc_hd__tapvpwrvgnd_1
XSLICE_16\[1\].RAM16.SLICE\[1\].RAM8.WORD\[5\].W.BYTE\[1\].B.BIT\[3\].genblk1.STORAGE
+ DIBUF\[11\].X SLICE_16\[1\].RAM16.SLICE\[1\].RAM8.WORD\[5\].W.BYTE\[1\].B.GCLK VGND
+ VGND VPWR VPWR SLICE_16\[1\].RAM16.SLICE\[1\].RAM8.WORD\[5\].W.BYTE\[1\].B.Q_WIRE\[3\]
+ sky130_fd_sc_hd__dlxtp_1
Xtap_14_7 VGND VPWR sky130_fd_sc_hd__tapvpwrvgnd_1
Xtap_7_6 VGND VPWR sky130_fd_sc_hd__tapvpwrvgnd_1
Xfill_41_24 VGND VPWR sky130_fd_sc_hd__tapvpwrvgnd_1
Xfill_41_13 VGND VGND VPWR VPWR sky130_fd_sc_hd__decap_12
XSLICE_16\[1\].RAM16.SLICE\[0\].RAM8.WORD\[6\].W.BYTE\[3\].B.BIT\[1\].OBUF0 SLICE_16\[1\].RAM16.SLICE\[0\].RAM8.WORD\[6\].W.BYTE\[3\].B.Q_WIRE\[1\]
+ SLICE_16\[1\].RAM16.SLICE\[0\].RAM8.WORD\[6\].W.BYTE\[3\].B.SEL0_B VGND VGND VPWR
+ VPWR SLICE_16\[1\].RAM16.BYTE\[3\].FLOATBUF0\[25\].Z sky130_fd_sc_hd__ebufn_2
XSLICE_16\[1\].RAM16.SLICE\[0\].RAM8.WORD\[2\].W.BYTE\[2\].B.SEL0INV SLICE_16\[1\].RAM16.SLICE\[0\].RAM8.WORD\[2\].W.BYTE\[0\].B.SEL0
+ VGND VGND VPWR VPWR SLICE_16\[1\].RAM16.SLICE\[0\].RAM8.WORD\[2\].W.BYTE\[2\].B.SEL0_B
+ sky130_fd_sc_hd__inv_1
XSLICE_16\[0\].RAM16.A0BUF\[1\].__cell__ A0BUF\[1\].X VGND VGND VPWR VPWR SLICE_16\[0\].RAM16.A0BUF\[1\].X
+ sky130_fd_sc_hd__clkbuf_2
Xtap_8_30 VGND VPWR sky130_fd_sc_hd__tapvpwrvgnd_1
Xfill_41_79 VGND VGND VPWR VPWR sky130_fd_sc_hd__decap_12
Xfill_41_68 VGND VGND VPWR VPWR sky130_fd_sc_hd__decap_12
Xfill_41_57 VGND VPWR sky130_fd_sc_hd__tapvpwrvgnd_1
Xfill_41_46 VGND VGND VPWR VPWR sky130_fd_sc_hd__decap_12
Xfill_41_35 VGND VGND VPWR VPWR sky130_fd_sc_hd__decap_12
Xtap_40_0 VGND VPWR sky130_fd_sc_hd__tapvpwrvgnd_1
XSLICE_16\[0\].RAM16.SLICE\[1\].RAM8.WORD\[0\].W.BYTE\[2\].B.BIT\[0\].genblk1.STORAGE
+ DIBUF\[16\].X SLICE_16\[0\].RAM16.SLICE\[1\].RAM8.WORD\[0\].W.BYTE\[2\].B.GCLK VGND
+ VGND VPWR VPWR SLICE_16\[0\].RAM16.SLICE\[1\].RAM8.WORD\[0\].W.BYTE\[2\].B.Q_WIRE\[0\]
+ sky130_fd_sc_hd__dlxtp_1
XSLICE_16\[1\].RAM16.SLICE\[0\].RAM8.WORD\[3\].W.BYTE\[0\].B.BIT\[6\].OBUF0 SLICE_16\[1\].RAM16.SLICE\[0\].RAM8.WORD\[3\].W.BYTE\[0\].B.Q_WIRE\[6\]
+ SLICE_16\[1\].RAM16.SLICE\[0\].RAM8.WORD\[3\].W.BYTE\[0\].B.SEL0_B VGND VGND VPWR
+ VPWR SLICE_16\[1\].RAM16.BYTE\[0\].FLOATBUF0\[6\].Z sky130_fd_sc_hd__ebufn_2
XSLICE_16\[0\].RAM16.SLICE\[1\].RAM8.WORD\[0\].W.BYTE\[2\].B.BIT\[5\].OBUF0 SLICE_16\[0\].RAM16.SLICE\[1\].RAM8.WORD\[0\].W.BYTE\[2\].B.Q_WIRE\[5\]
+ SLICE_16\[0\].RAM16.SLICE\[1\].RAM8.WORD\[0\].W.BYTE\[2\].B.SEL0_B VGND VGND VPWR
+ VPWR SLICE_16\[0\].RAM16.BYTE\[2\].FLOATBUF0\[21\].Z sky130_fd_sc_hd__ebufn_2
XSLICE_16\[0\].RAM16.SLICE\[0\].RAM8.WORD\[5\].W.BYTE\[3\].B.BIT\[6\].genblk1.STORAGE
+ DIBUF\[30\].X SLICE_16\[0\].RAM16.SLICE\[0\].RAM8.WORD\[5\].W.BYTE\[3\].B.GCLK VGND
+ VGND VPWR VPWR SLICE_16\[0\].RAM16.SLICE\[0\].RAM8.WORD\[5\].W.BYTE\[3\].B.Q_WIRE\[6\]
+ sky130_fd_sc_hd__dlxtp_1
XSLICE_16\[0\].RAM16.SLICE\[0\].RAM8.WORD\[3\].W.BYTE\[1\].B.BIT\[5\].genblk1.STORAGE
+ DIBUF\[13\].X SLICE_16\[0\].RAM16.SLICE\[0\].RAM8.WORD\[3\].W.BYTE\[1\].B.GCLK VGND
+ VGND VPWR VPWR SLICE_16\[0\].RAM16.SLICE\[0\].RAM8.WORD\[3\].W.BYTE\[1\].B.Q_WIRE\[5\]
+ sky130_fd_sc_hd__dlxtp_1
XSLICE_16\[0\].RAM16.DEC0.AND0 SLICE_16\[0\].RAM16.A0BUF\[3\].X SLICE_16\[0\].RAM16.DEC0.EN
+ VGND VGND VPWR VPWR SLICE_16\[0\].RAM16.DEC0.SEL\[0\] sky130_fd_sc_hd__and2b_2
Xfill_47_1 VGND VGND VPWR VPWR sky130_fd_sc_hd__decap_12
XSLICE_16\[0\].RAM16.SLICE\[0\].RAM8.WORD\[0\].W.BYTE\[3\].B.SEL0INV SLICE_16\[0\].RAM16.SLICE\[0\].RAM8.WORD\[0\].W.BYTE\[0\].B.SEL0
+ VGND VGND VPWR VPWR SLICE_16\[0\].RAM16.SLICE\[0\].RAM8.WORD\[0\].W.BYTE\[3\].B.SEL0_B
+ sky130_fd_sc_hd__inv_1
XSLICE_16\[1\].RAM16.Do0_REG.OUTREG_BYTE\[1\].DIODE\[1\] SLICE_16\[1\].RAM16.BYTE\[1\].FLOATBUF0\[9\].Z
+ VGND VGND VPWR VPWR sky130_fd_sc_hd__diode_2
Xtap_23_28 VGND VPWR sky130_fd_sc_hd__tapvpwrvgnd_1
Xtap_23_17 VGND VPWR sky130_fd_sc_hd__tapvpwrvgnd_1
Xfill_2_1 VGND VPWR sky130_fd_sc_hd__tapvpwrvgnd_1
XSLICE_16\[1\].RAM16.SLICE\[0\].RAM8.WORD\[6\].W.BYTE\[1\].B.BIT\[6\].OBUF0 SLICE_16\[1\].RAM16.SLICE\[0\].RAM8.WORD\[6\].W.BYTE\[1\].B.Q_WIRE\[6\]
+ SLICE_16\[1\].RAM16.SLICE\[0\].RAM8.WORD\[6\].W.BYTE\[1\].B.SEL0_B VGND VGND VPWR
+ VPWR SLICE_16\[1\].RAM16.BYTE\[1\].FLOATBUF0\[14\].Z sky130_fd_sc_hd__ebufn_2
XSLICE_16\[0\].RAM16.SLICE\[1\].RAM8.WORD\[3\].W.BYTE\[3\].B.BIT\[5\].OBUF0 SLICE_16\[0\].RAM16.SLICE\[1\].RAM8.WORD\[3\].W.BYTE\[3\].B.Q_WIRE\[5\]
+ SLICE_16\[0\].RAM16.SLICE\[1\].RAM8.WORD\[3\].W.BYTE\[3\].B.SEL0_B VGND VGND VPWR
+ VPWR SLICE_16\[0\].RAM16.BYTE\[3\].FLOATBUF0\[29\].Z sky130_fd_sc_hd__ebufn_2
Xtap_12_4 VGND VPWR sky130_fd_sc_hd__tapvpwrvgnd_1
XDIBUF\[27\].__cell__ Di0[27] VGND VGND VPWR VPWR DIBUF\[27\].X sky130_fd_sc_hd__clkbuf_16
Xtap_5_3 VGND VPWR sky130_fd_sc_hd__tapvpwrvgnd_1
XSLICE_16\[1\].RAM16.SLICE\[1\].RAM8.WORD\[2\].W.BYTE\[3\].B.BIT\[4\].genblk1.STORAGE
+ DIBUF\[28\].X SLICE_16\[1\].RAM16.SLICE\[1\].RAM8.WORD\[2\].W.BYTE\[3\].B.GCLK VGND
+ VGND VPWR VPWR SLICE_16\[1\].RAM16.SLICE\[1\].RAM8.WORD\[2\].W.BYTE\[3\].B.Q_WIRE\[4\]
+ sky130_fd_sc_hd__dlxtp_1
XSLICE_16\[0\].RAM16.SLICE\[0\].RAM8.WORD\[0\].W.BYTE\[3\].B.genblk1.CG SLICE_16\[0\].RAM16.SLICE\[0\].RAM8.WORD\[0\].W.BYTE\[3\].B.CLK_B
+ SLICE_16\[0\].RAM16.SLICE\[0\].RAM8.WORD\[0\].W.BYTE\[3\].B.WE0_WIRE VGND VGND VPWR
+ VPWR SLICE_16\[0\].RAM16.SLICE\[0\].RAM8.WORD\[0\].W.BYTE\[3\].B.GCLK sky130_fd_sc_hd__dlclkp_1
XSLICE_16\[1\].RAM16.SLICE\[1\].RAM8.WORD\[6\].W.BYTE\[0\].B.BIT\[2\].genblk1.STORAGE
+ DIBUF\[2\].X SLICE_16\[1\].RAM16.SLICE\[1\].RAM8.WORD\[6\].W.BYTE\[0\].B.GCLK VGND
+ VGND VPWR VPWR SLICE_16\[1\].RAM16.SLICE\[1\].RAM8.WORD\[6\].W.BYTE\[0\].B.Q_WIRE\[2\]
+ sky130_fd_sc_hd__dlxtp_1
XSLICE_16\[1\].RAM16.SLICE\[1\].RAM8.WORD\[0\].W.BYTE\[1\].B.BIT\[3\].genblk1.STORAGE
+ DIBUF\[11\].X SLICE_16\[1\].RAM16.SLICE\[1\].RAM8.WORD\[0\].W.BYTE\[1\].B.GCLK VGND
+ VGND VPWR VPWR SLICE_16\[1\].RAM16.SLICE\[1\].RAM8.WORD\[0\].W.BYTE\[1\].B.Q_WIRE\[3\]
+ sky130_fd_sc_hd__dlxtp_1
Xfill_40_8 VGND VGND VPWR VPWR sky130_fd_sc_hd__decap_12
XSLICE_16\[1\].RAM16.SLICE\[1\].RAM8.WORD\[0\].W.BYTE\[2\].B.BIT\[1\].OBUF0 SLICE_16\[1\].RAM16.SLICE\[1\].RAM8.WORD\[0\].W.BYTE\[2\].B.Q_WIRE\[1\]
+ SLICE_16\[1\].RAM16.SLICE\[1\].RAM8.WORD\[0\].W.BYTE\[2\].B.SEL0_B VGND VGND VPWR
+ VPWR SLICE_16\[1\].RAM16.BYTE\[2\].FLOATBUF0\[17\].Z sky130_fd_sc_hd__ebufn_2
Xfill_26_6 VGND VGND VPWR VPWR sky130_fd_sc_hd__decap_6
XSLICE_16\[0\].RAM16.SLICE\[1\].RAM8.WORD\[3\].W.BYTE\[3\].B.BIT\[0\].genblk1.STORAGE
+ DIBUF\[24\].X SLICE_16\[0\].RAM16.SLICE\[1\].RAM8.WORD\[3\].W.BYTE\[3\].B.GCLK VGND
+ VGND VPWR VPWR SLICE_16\[0\].RAM16.SLICE\[1\].RAM8.WORD\[3\].W.BYTE\[3\].B.Q_WIRE\[0\]
+ sky130_fd_sc_hd__dlxtp_1
Xfill_19_5 VGND VGND VPWR VPWR sky130_fd_sc_hd__decap_12
XSLICE_16\[0\].RAM16.SLICE\[0\].RAM8.WORD\[2\].W.BYTE\[1\].B.DIODE_CLK SLICE_16\[0\].RAM16.SLICE\[0\].RAM8.WORD\[2\].W.BYTE\[0\].B.CLK
+ VGND VGND VPWR VPWR sky130_fd_sc_hd__diode_2
XSLICE_16\[0\].RAM16.SLICE\[1\].RAM8.WORD\[2\].W.BYTE\[1\].B.BIT\[2\].OBUF0 SLICE_16\[0\].RAM16.SLICE\[1\].RAM8.WORD\[2\].W.BYTE\[1\].B.Q_WIRE\[2\]
+ SLICE_16\[0\].RAM16.SLICE\[1\].RAM8.WORD\[2\].W.BYTE\[1\].B.SEL0_B VGND VGND VPWR
+ VPWR SLICE_16\[0\].RAM16.BYTE\[1\].FLOATBUF0\[10\].Z sky130_fd_sc_hd__ebufn_2
XSLICE_16\[1\].RAM16.SLICE\[0\].RAM8.WORD\[0\].W.BYTE\[1\].B.genblk1.CLKINV SLICE_16\[1\].RAM16.SLICE\[0\].RAM8.WORD\[0\].W.BYTE\[0\].B.CLK
+ VGND VGND VPWR VPWR SLICE_16\[1\].RAM16.SLICE\[0\].RAM8.WORD\[0\].W.BYTE\[1\].B.CLK_B
+ sky130_fd_sc_hd__inv_1
Xtap_18_28 VGND VPWR sky130_fd_sc_hd__tapvpwrvgnd_1
Xtap_18_17 VGND VPWR sky130_fd_sc_hd__tapvpwrvgnd_1
XSLICE_16\[1\].RAM16.Do0_REG.OUTREG_BYTE\[0\].Do_FF\[2\] SLICE_16\[1\].RAM16.Do0_REG.CLKBUF\[0\]
+ SLICE_16\[1\].RAM16.BYTE\[0\].FLOATBUF0\[2\].Z VGND VGND VPWR VPWR Do0MUX.A1\[2\]
+ sky130_fd_sc_hd__dfxtp_1
Xtap_34_27 VGND VPWR sky130_fd_sc_hd__tapvpwrvgnd_1
Xtap_34_16 VGND VPWR sky130_fd_sc_hd__tapvpwrvgnd_1
XSLICE_16\[0\].RAM16.SLICE\[0\].RAM8.WORD\[6\].W.BYTE\[2\].B.BIT\[5\].genblk1.STORAGE
+ DIBUF\[21\].X SLICE_16\[0\].RAM16.SLICE\[0\].RAM8.WORD\[6\].W.BYTE\[2\].B.GCLK VGND
+ VGND VPWR VPWR SLICE_16\[0\].RAM16.SLICE\[0\].RAM8.WORD\[6\].W.BYTE\[2\].B.Q_WIRE\[5\]
+ sky130_fd_sc_hd__dlxtp_1
Xfill_22_59 VGND VGND VPWR VPWR sky130_fd_sc_hd__decap_12
Xfill_22_48 VGND VPWR sky130_fd_sc_hd__tapvpwrvgnd_1
Xfill_22_37 VGND VGND VPWR VPWR sky130_fd_sc_hd__decap_12
Xfill_22_26 VGND VGND VPWR VPWR sky130_fd_sc_hd__decap_12
Xfill_22_15 VGND VPWR sky130_fd_sc_hd__tapvpwrvgnd_1
XSLICE_16\[0\].RAM16.SLICE\[0\].RAM8.WORD\[1\].W.BYTE\[3\].B.BIT\[4\].OBUF0 SLICE_16\[0\].RAM16.SLICE\[0\].RAM8.WORD\[1\].W.BYTE\[3\].B.Q_WIRE\[4\]
+ SLICE_16\[0\].RAM16.SLICE\[0\].RAM8.WORD\[1\].W.BYTE\[3\].B.SEL0_B VGND VGND VPWR
+ VPWR SLICE_16\[0\].RAM16.BYTE\[3\].FLOATBUF0\[28\].Z sky130_fd_sc_hd__ebufn_2
XSLICE_16\[0\].RAM16.SLICE\[0\].RAM8.WORD\[0\].W.BYTE\[3\].B.BIT\[6\].genblk1.STORAGE
+ DIBUF\[30\].X SLICE_16\[0\].RAM16.SLICE\[0\].RAM8.WORD\[0\].W.BYTE\[3\].B.GCLK VGND
+ VGND VPWR VPWR SLICE_16\[0\].RAM16.SLICE\[0\].RAM8.WORD\[0\].W.BYTE\[3\].B.Q_WIRE\[6\]
+ sky130_fd_sc_hd__dlxtp_1
XSLICE_16\[0\].RAM16.SLICE\[0\].RAM8.WORD\[4\].W.BYTE\[0\].B.BIT\[4\].genblk1.STORAGE
+ DIBUF\[4\].X SLICE_16\[0\].RAM16.SLICE\[0\].RAM8.WORD\[4\].W.BYTE\[0\].B.GCLK VGND
+ VGND VPWR VPWR SLICE_16\[0\].RAM16.SLICE\[0\].RAM8.WORD\[4\].W.BYTE\[0\].B.Q_WIRE\[4\]
+ sky130_fd_sc_hd__dlxtp_1
Xtap_5_20 VGND VPWR sky130_fd_sc_hd__tapvpwrvgnd_1
XSLICE_16\[1\].RAM16.SLICE\[1\].RAM8.WORD\[3\].W.BYTE\[3\].B.BIT\[1\].OBUF0 SLICE_16\[1\].RAM16.SLICE\[1\].RAM8.WORD\[3\].W.BYTE\[3\].B.Q_WIRE\[1\]
+ SLICE_16\[1\].RAM16.SLICE\[1\].RAM8.WORD\[3\].W.BYTE\[3\].B.SEL0_B VGND VGND VPWR
+ VPWR SLICE_16\[1\].RAM16.BYTE\[3\].FLOATBUF0\[25\].Z sky130_fd_sc_hd__ebufn_2
Xtap_5_31 VGND VPWR sky130_fd_sc_hd__tapvpwrvgnd_1
Xfill_47_56 VGND VGND VPWR VPWR sky130_fd_sc_hd__decap_12
Xfill_47_45 VGND VPWR sky130_fd_sc_hd__tapvpwrvgnd_1
Xfill_47_34 VGND VGND VPWR VPWR sky130_fd_sc_hd__decap_12
Xfill_47_23 VGND VGND VPWR VPWR sky130_fd_sc_hd__decap_12
Xfill_47_12 VGND VPWR sky130_fd_sc_hd__tapvpwrvgnd_1
XSLICE_16\[1\].RAM16.SLICE\[0\].RAM8.WORD\[6\].W.BYTE\[0\].B.SEL0INV SLICE_16\[1\].RAM16.SLICE\[0\].RAM8.WORD\[6\].W.BYTE\[0\].B.SEL0
+ VGND VGND VPWR VPWR SLICE_16\[1\].RAM16.SLICE\[0\].RAM8.WORD\[6\].W.BYTE\[0\].B.SEL0_B
+ sky130_fd_sc_hd__inv_1
Xtap_3_0 VGND VPWR sky130_fd_sc_hd__tapvpwrvgnd_1
Xtap_10_1 VGND VPWR sky130_fd_sc_hd__tapvpwrvgnd_1
XSLICE_16\[0\].RAM16.DIODE_A0\[2\].__cell__ A0BUF\[2\].X VGND VGND VPWR VPWR sky130_fd_sc_hd__diode_2
XSLICE_16\[1\].RAM16.SLICE\[1\].RAM8.WORD\[0\].W.BYTE\[0\].B.BIT\[6\].OBUF0 SLICE_16\[1\].RAM16.SLICE\[1\].RAM8.WORD\[0\].W.BYTE\[0\].B.Q_WIRE\[6\]
+ SLICE_16\[1\].RAM16.SLICE\[1\].RAM8.WORD\[0\].W.BYTE\[0\].B.SEL0_B VGND VGND VPWR
+ VPWR SLICE_16\[1\].RAM16.BYTE\[0\].FLOATBUF0\[6\].Z sky130_fd_sc_hd__ebufn_2
XSLICE_16\[1\].RAM16.SLICE\[0\].RAM8.WORD\[3\].W.BYTE\[2\].B.genblk1.CLKINV SLICE_16\[1\].RAM16.SLICE\[0\].RAM8.WORD\[3\].W.BYTE\[0\].B.CLK
+ VGND VGND VPWR VPWR SLICE_16\[1\].RAM16.SLICE\[0\].RAM8.WORD\[3\].W.BYTE\[2\].B.CLK_B
+ sky130_fd_sc_hd__inv_1
XSLICE_16\[0\].RAM16.SLICE\[1\].RAM8.WORD\[5\].W.BYTE\[2\].B.BIT\[2\].OBUF0 SLICE_16\[0\].RAM16.SLICE\[1\].RAM8.WORD\[5\].W.BYTE\[2\].B.Q_WIRE\[2\]
+ SLICE_16\[0\].RAM16.SLICE\[1\].RAM8.WORD\[5\].W.BYTE\[2\].B.SEL0_B VGND VGND VPWR
+ VPWR SLICE_16\[0\].RAM16.BYTE\[2\].FLOATBUF0\[18\].Z sky130_fd_sc_hd__ebufn_2
XSLICE_16\[0\].RAM16.SLICE\[1\].RAM8.WORD\[0\].W.BYTE\[1\].B.CGAND SLICE_16\[0\].RAM16.SLICE\[1\].RAM8.WORD\[0\].W.BYTE\[0\].B.SEL0
+ SLICE_16\[0\].RAM16.SLICE\[1\].RAM8.WE0_buf\[1\] VGND VGND VPWR VPWR SLICE_16\[0\].RAM16.SLICE\[1\].RAM8.WORD\[0\].W.BYTE\[1\].B.WE0_WIRE
+ sky130_fd_sc_hd__and2_1
Xfill_24_3 VGND VPWR sky130_fd_sc_hd__tapvpwrvgnd_1
Xfill_17_2 VGND VGND VPWR VPWR sky130_fd_sc_hd__decap_12
XSLICE_16\[0\].RAM16.SLICE\[1\].RAM8.WORD\[5\].W.BYTE\[3\].B.genblk1.CG SLICE_16\[0\].RAM16.SLICE\[1\].RAM8.WORD\[5\].W.BYTE\[3\].B.CLK_B
+ SLICE_16\[0\].RAM16.SLICE\[1\].RAM8.WORD\[5\].W.BYTE\[3\].B.WE0_WIRE VGND VGND VPWR
+ VPWR SLICE_16\[0\].RAM16.SLICE\[1\].RAM8.WORD\[5\].W.BYTE\[3\].B.GCLK sky130_fd_sc_hd__dlclkp_1
XSLICE_16\[0\].RAM16.SLICE\[0\].RAM8.WORD\[0\].W.BYTE\[1\].B.BIT\[1\].OBUF0 SLICE_16\[0\].RAM16.SLICE\[0\].RAM8.WORD\[0\].W.BYTE\[1\].B.Q_WIRE\[1\]
+ SLICE_16\[0\].RAM16.SLICE\[0\].RAM8.WORD\[0\].W.BYTE\[1\].B.SEL0_B VGND VGND VPWR
+ VPWR SLICE_16\[0\].RAM16.BYTE\[1\].FLOATBUF0\[9\].Z sky130_fd_sc_hd__ebufn_2
XSLICE_16\[1\].RAM16.SLICE\[1\].RAM8.WORD\[3\].W.BYTE\[2\].B.BIT\[3\].genblk1.STORAGE
+ DIBUF\[19\].X SLICE_16\[1\].RAM16.SLICE\[1\].RAM8.WORD\[3\].W.BYTE\[2\].B.GCLK VGND
+ VGND VPWR VPWR SLICE_16\[1\].RAM16.SLICE\[1\].RAM8.WORD\[3\].W.BYTE\[2\].B.Q_WIRE\[3\]
+ sky130_fd_sc_hd__dlxtp_1
XSLICE_16\[1\].RAM16.SLICE\[1\].RAM8.WORD\[1\].W.BYTE\[0\].B.BIT\[2\].genblk1.STORAGE
+ DIBUF\[2\].X SLICE_16\[1\].RAM16.SLICE\[1\].RAM8.WORD\[1\].W.BYTE\[0\].B.GCLK VGND
+ VGND VPWR VPWR SLICE_16\[1\].RAM16.SLICE\[1\].RAM8.WORD\[1\].W.BYTE\[0\].B.Q_WIRE\[2\]
+ sky130_fd_sc_hd__dlxtp_1
XDIBUF\[0\].__cell__ Di0[0] VGND VGND VPWR VPWR DIBUF\[0\].X sky130_fd_sc_hd__clkbuf_16
Xtap_39_9 VGND VPWR sky130_fd_sc_hd__tapvpwrvgnd_1
Xtap_29_27 VGND VPWR sky130_fd_sc_hd__tapvpwrvgnd_1
Xtap_29_16 VGND VPWR sky130_fd_sc_hd__tapvpwrvgnd_1
XSLICE_16\[0\].RAM16.SLICE\[0\].RAM8.WORD\[4\].W.BYTE\[1\].B.SEL0INV SLICE_16\[0\].RAM16.SLICE\[0\].RAM8.WORD\[4\].W.BYTE\[0\].B.SEL0
+ VGND VGND VPWR VPWR SLICE_16\[0\].RAM16.SLICE\[0\].RAM8.WORD\[4\].W.BYTE\[1\].B.SEL0_B
+ sky130_fd_sc_hd__inv_1
Xfill_17_15 VGND VPWR sky130_fd_sc_hd__tapvpwrvgnd_1
XSLICE_16\[1\].RAM16.BYTE\[3\].FLOATBUF0\[24\].__cell__ SLICE_16\[1\].RAM16.BYTE\[3\].FLOATBUF0\[24\].A
+ SLICE_16\[1\].RAM16.BYTE\[3\].FLOATBUF0\[24\].TE_B VGND VGND VPWR VPWR SLICE_16\[1\].RAM16.BYTE\[3\].FLOATBUF0\[24\].Z
+ sky130_fd_sc_hd__ebufn_2
XSLICE_16\[1\].RAM16.SLICE\[1\].RAM8.WORD\[3\].W.BYTE\[1\].B.BIT\[6\].OBUF0 SLICE_16\[1\].RAM16.SLICE\[1\].RAM8.WORD\[3\].W.BYTE\[1\].B.Q_WIRE\[6\]
+ SLICE_16\[1\].RAM16.SLICE\[1\].RAM8.WORD\[3\].W.BYTE\[1\].B.SEL0_B VGND VGND VPWR
+ VPWR SLICE_16\[1\].RAM16.BYTE\[1\].FLOATBUF0\[14\].Z sky130_fd_sc_hd__ebufn_2
XSLICE_16\[1\].RAM16.SLICE\[1\].RAM8.WORD\[1\].W.BYTE\[2\].B.DIODE_CLK SLICE_16\[1\].RAM16.SLICE\[1\].RAM8.WORD\[1\].W.BYTE\[0\].B.CLK
+ VGND VGND VPWR VPWR sky130_fd_sc_hd__diode_2
XSLICE_16\[1\].RAM16.SLICE\[0\].RAM8.WORD\[7\].W.BYTE\[1\].B.DIODE_CLK SLICE_16\[1\].RAM16.SLICE\[0\].RAM8.WORD\[7\].W.BYTE\[0\].B.CLK
+ VGND VGND VPWR VPWR sky130_fd_sc_hd__diode_2
Xfill_17_59 VGND VGND VPWR VPWR sky130_fd_sc_hd__decap_12
Xfill_17_48 VGND VPWR sky130_fd_sc_hd__tapvpwrvgnd_1
Xfill_17_37 VGND VGND VPWR VPWR sky130_fd_sc_hd__decap_12
Xfill_17_26 VGND VGND VPWR VPWR sky130_fd_sc_hd__decap_12
XSLICE_16\[1\].RAM16.SLICE\[0\].RAM8.WORD\[6\].W.BYTE\[3\].B.genblk1.CLKINV SLICE_16\[1\].RAM16.SLICE\[0\].RAM8.WORD\[6\].W.BYTE\[0\].B.CLK
+ VGND VGND VPWR VPWR SLICE_16\[1\].RAM16.SLICE\[0\].RAM8.WORD\[6\].W.BYTE\[3\].B.CLK_B
+ sky130_fd_sc_hd__inv_1
XSLICE_16\[1\].RAM16.SLICE\[0\].RAM8.WORD\[1\].W.BYTE\[3\].B.BIT\[0\].OBUF0 SLICE_16\[1\].RAM16.SLICE\[0\].RAM8.WORD\[1\].W.BYTE\[3\].B.Q_WIRE\[0\]
+ SLICE_16\[1\].RAM16.SLICE\[0\].RAM8.WORD\[1\].W.BYTE\[3\].B.SEL0_B VGND VGND VPWR
+ VPWR SLICE_16\[1\].RAM16.BYTE\[3\].FLOATBUF0\[24\].Z sky130_fd_sc_hd__ebufn_2
XSLICE_16\[1\].RAM16.SLICE\[1\].RAM8.WORD\[2\].W.BYTE\[2\].B.genblk1.CG SLICE_16\[1\].RAM16.SLICE\[1\].RAM8.WORD\[2\].W.BYTE\[2\].B.CLK_B
+ SLICE_16\[1\].RAM16.SLICE\[1\].RAM8.WORD\[2\].W.BYTE\[2\].B.WE0_WIRE VGND VGND VPWR
+ VPWR SLICE_16\[1\].RAM16.SLICE\[1\].RAM8.WORD\[2\].W.BYTE\[2\].B.GCLK sky130_fd_sc_hd__dlclkp_1
XSLICE_16\[0\].RAM16.SLICE\[1\].RAM8.WORD\[4\].W.BYTE\[1\].B.DIODE_CLK SLICE_16\[0\].RAM16.SLICE\[1\].RAM8.WORD\[4\].W.BYTE\[0\].B.CLK
+ VGND VGND VPWR VPWR sky130_fd_sc_hd__diode_2
XSLICE_16\[0\].RAM16.SLICE\[1\].RAM8.WORD\[5\].W.BYTE\[0\].B.BIT\[7\].OBUF0 SLICE_16\[0\].RAM16.SLICE\[1\].RAM8.WORD\[5\].W.BYTE\[0\].B.Q_WIRE\[7\]
+ SLICE_16\[0\].RAM16.SLICE\[1\].RAM8.WORD\[5\].W.BYTE\[0\].B.SEL0_B VGND VGND VPWR
+ VPWR SLICE_16\[0\].RAM16.BYTE\[0\].FLOATBUF0\[7\].Z sky130_fd_sc_hd__ebufn_2
XSLICE_16\[0\].RAM16.SLICE\[0\].RAM8.WORD\[1\].W.BYTE\[2\].B.BIT\[5\].genblk1.STORAGE
+ DIBUF\[21\].X SLICE_16\[0\].RAM16.SLICE\[0\].RAM8.WORD\[1\].W.BYTE\[2\].B.GCLK VGND
+ VGND VPWR VPWR SLICE_16\[0\].RAM16.SLICE\[0\].RAM8.WORD\[1\].W.BYTE\[2\].B.Q_WIRE\[5\]
+ sky130_fd_sc_hd__dlxtp_1
XSLICE_16\[0\].RAM16.SLICE\[0\].RAM8.WORD\[3\].W.BYTE\[2\].B.BIT\[1\].OBUF0 SLICE_16\[0\].RAM16.SLICE\[0\].RAM8.WORD\[3\].W.BYTE\[2\].B.Q_WIRE\[1\]
+ SLICE_16\[0\].RAM16.SLICE\[0\].RAM8.WORD\[3\].W.BYTE\[2\].B.SEL0_B VGND VGND VPWR
+ VPWR SLICE_16\[0\].RAM16.BYTE\[2\].FLOATBUF0\[17\].Z sky130_fd_sc_hd__ebufn_2
XSLICE_16\[0\].RAM16.SLICE\[0\].RAM8.WORD\[7\].W.BYTE\[1\].B.BIT\[4\].genblk1.STORAGE
+ DIBUF\[12\].X SLICE_16\[0\].RAM16.SLICE\[0\].RAM8.WORD\[7\].W.BYTE\[1\].B.GCLK VGND
+ VGND VPWR VPWR SLICE_16\[0\].RAM16.SLICE\[0\].RAM8.WORD\[7\].W.BYTE\[1\].B.Q_WIRE\[4\]
+ sky130_fd_sc_hd__dlxtp_1
XSLICE_16\[1\].RAM16.SLICE\[1\].RAM8.WORD\[6\].W.BYTE\[2\].B.BIT\[6\].OBUF0 SLICE_16\[1\].RAM16.SLICE\[1\].RAM8.WORD\[6\].W.BYTE\[2\].B.Q_WIRE\[6\]
+ SLICE_16\[1\].RAM16.SLICE\[1\].RAM8.WORD\[6\].W.BYTE\[2\].B.SEL0_B VGND VGND VPWR
+ VPWR SLICE_16\[1\].RAM16.BYTE\[2\].FLOATBUF0\[22\].Z sky130_fd_sc_hd__ebufn_2
XSLICE_16\[1\].RAM16.SLICE\[1\].RAM8.DEC0.ABUF\[2\] SLICE_16\[1\].RAM16.A0BUF\[2\].X
+ VGND VGND VPWR VPWR SLICE_16\[1\].RAM16.SLICE\[1\].RAM8.DEC0.A_buf\[2\] sky130_fd_sc_hd__clkbuf_2
Xtap_31_17 VGND VPWR sky130_fd_sc_hd__tapvpwrvgnd_1
Xfill_22_0 VGND VPWR sky130_fd_sc_hd__tapvpwrvgnd_1
Xtap_15_29 VGND VPWR sky130_fd_sc_hd__tapvpwrvgnd_1
Xtap_15_18 VGND VPWR sky130_fd_sc_hd__tapvpwrvgnd_1
Xtap_31_28 VGND VPWR sky130_fd_sc_hd__tapvpwrvgnd_1
XSLICE_16\[1\].RAM16.SLICE\[1\].RAM8.WORD\[6\].W.BYTE\[3\].B.BIT\[3\].genblk1.STORAGE
+ DIBUF\[27\].X SLICE_16\[1\].RAM16.SLICE\[1\].RAM8.WORD\[6\].W.BYTE\[3\].B.GCLK VGND
+ VGND VPWR VPWR SLICE_16\[1\].RAM16.SLICE\[1\].RAM8.WORD\[6\].W.BYTE\[3\].B.Q_WIRE\[3\]
+ sky130_fd_sc_hd__dlxtp_1
Xtap_37_6 VGND VPWR sky130_fd_sc_hd__tapvpwrvgnd_1
Xtap_2_32 VGND VPWR sky130_fd_sc_hd__tapvpwrvgnd_1
Xtap_2_21 VGND VPWR sky130_fd_sc_hd__tapvpwrvgnd_1
Xtap_2_10 VGND VPWR sky130_fd_sc_hd__tapvpwrvgnd_1
XSLICE_16\[1\].RAM16.SLICE\[1\].RAM8.WORD\[4\].W.BYTE\[1\].B.BIT\[2\].genblk1.STORAGE
+ DIBUF\[10\].X SLICE_16\[1\].RAM16.SLICE\[1\].RAM8.WORD\[4\].W.BYTE\[1\].B.GCLK VGND
+ VGND VPWR VPWR SLICE_16\[1\].RAM16.SLICE\[1\].RAM8.WORD\[4\].W.BYTE\[1\].B.Q_WIRE\[2\]
+ sky130_fd_sc_hd__dlxtp_1
XSLICE_16\[1\].RAM16.SLICE\[0\].RAM8.WORD\[1\].W.BYTE\[1\].B.BIT\[5\].OBUF0 SLICE_16\[1\].RAM16.SLICE\[0\].RAM8.WORD\[1\].W.BYTE\[1\].B.Q_WIRE\[5\]
+ SLICE_16\[1\].RAM16.SLICE\[0\].RAM8.WORD\[1\].W.BYTE\[1\].B.SEL0_B VGND VGND VPWR
+ VPWR SLICE_16\[1\].RAM16.BYTE\[1\].FLOATBUF0\[13\].Z sky130_fd_sc_hd__ebufn_2
XSLICE_16\[0\].RAM16.SLICE\[0\].RAM8.WORD\[6\].W.BYTE\[3\].B.BIT\[1\].OBUF0 SLICE_16\[0\].RAM16.SLICE\[0\].RAM8.WORD\[6\].W.BYTE\[3\].B.Q_WIRE\[1\]
+ SLICE_16\[0\].RAM16.SLICE\[0\].RAM8.WORD\[6\].W.BYTE\[3\].B.SEL0_B VGND VGND VPWR
+ VPWR SLICE_16\[0\].RAM16.BYTE\[3\].FLOATBUF0\[25\].Z sky130_fd_sc_hd__ebufn_2
Xfill_44_79 VGND VGND VPWR VPWR sky130_fd_sc_hd__decap_12
Xfill_44_68 VGND VGND VPWR VPWR sky130_fd_sc_hd__decap_12
Xfill_44_57 VGND VPWR sky130_fd_sc_hd__tapvpwrvgnd_1
Xfill_44_46 VGND VGND VPWR VPWR sky130_fd_sc_hd__decap_12
Xfill_44_35 VGND VGND VPWR VPWR sky130_fd_sc_hd__decap_12
Xfill_44_24 VGND VPWR sky130_fd_sc_hd__tapvpwrvgnd_1
Xfill_44_13 VGND VGND VPWR VPWR sky130_fd_sc_hd__decap_12
XSLICE_16\[0\].RAM16.SLICE\[0\].RAM8.WORD\[3\].W.BYTE\[0\].B.BIT\[6\].OBUF0 SLICE_16\[0\].RAM16.SLICE\[0\].RAM8.WORD\[3\].W.BYTE\[0\].B.Q_WIRE\[6\]
+ SLICE_16\[0\].RAM16.SLICE\[0\].RAM8.WORD\[3\].W.BYTE\[0\].B.SEL0_B VGND VGND VPWR
+ VPWR SLICE_16\[0\].RAM16.BYTE\[0\].FLOATBUF0\[6\].Z sky130_fd_sc_hd__ebufn_2
XSLICE_16\[1\].RAM16.SLICE\[1\].RAM8.WORD\[5\].W.BYTE\[0\].B.BIT\[3\].OBUF0 SLICE_16\[1\].RAM16.SLICE\[1\].RAM8.WORD\[5\].W.BYTE\[0\].B.Q_WIRE\[3\]
+ SLICE_16\[1\].RAM16.SLICE\[1\].RAM8.WORD\[5\].W.BYTE\[0\].B.SEL0_B VGND VGND VPWR
+ VPWR SLICE_16\[1\].RAM16.BYTE\[0\].FLOATBUF0\[3\].Z sky130_fd_sc_hd__ebufn_2
XSLICE_16\[1\].RAM16.SLICE\[1\].RAM8.WORD\[6\].W.BYTE\[2\].B.SEL0INV SLICE_16\[1\].RAM16.SLICE\[1\].RAM8.WORD\[6\].W.BYTE\[0\].B.SEL0
+ VGND VGND VPWR VPWR SLICE_16\[1\].RAM16.SLICE\[1\].RAM8.WORD\[6\].W.BYTE\[2\].B.SEL0_B
+ sky130_fd_sc_hd__inv_1
XSLICE_16\[1\].RAM16.SLICE\[1\].RAM8.WORD\[0\].W.BYTE\[2\].B.genblk1.CLKINV SLICE_16\[1\].RAM16.SLICE\[1\].RAM8.WORD\[0\].W.BYTE\[0\].B.CLK
+ VGND VGND VPWR VPWR SLICE_16\[1\].RAM16.SLICE\[1\].RAM8.WORD\[0\].W.BYTE\[2\].B.CLK_B
+ sky130_fd_sc_hd__inv_1
XSLICE_16\[1\].RAM16.SLICE\[0\].RAM8.WORD\[7\].W.BYTE\[0\].B.BIT\[7\].genblk1.STORAGE
+ DIBUF\[7\].X SLICE_16\[1\].RAM16.SLICE\[0\].RAM8.WORD\[7\].W.BYTE\[0\].B.GCLK VGND
+ VGND VPWR VPWR SLICE_16\[1\].RAM16.SLICE\[0\].RAM8.WORD\[7\].W.BYTE\[0\].B.Q_WIRE\[7\]
+ sky130_fd_sc_hd__dlxtp_1
Xfill_6_8 VGND VGND VPWR VPWR sky130_fd_sc_hd__decap_6
XSLICE_16\[1\].RAM16.SLICE\[0\].RAM8.WORD\[4\].W.BYTE\[2\].B.BIT\[5\].OBUF0 SLICE_16\[1\].RAM16.SLICE\[0\].RAM8.WORD\[4\].W.BYTE\[2\].B.Q_WIRE\[5\]
+ SLICE_16\[1\].RAM16.SLICE\[0\].RAM8.WORD\[4\].W.BYTE\[2\].B.SEL0_B VGND VGND VPWR
+ VPWR SLICE_16\[1\].RAM16.BYTE\[2\].FLOATBUF0\[21\].Z sky130_fd_sc_hd__ebufn_2
XSLICE_16\[0\].RAM16.SLICE\[1\].RAM8.WORD\[3\].W.CLKBUF SLICE_16\[0\].RAM16.SLICE\[1\].RAM8.CLKBUF.X
+ VGND VGND VPWR VPWR SLICE_16\[0\].RAM16.SLICE\[1\].RAM8.WORD\[3\].W.BYTE\[0\].B.CLK
+ sky130_fd_sc_hd__clkbuf_4
XSLICE_16\[0\].RAM16.SLICE\[0\].RAM8.WORD\[4\].W.BYTE\[3\].B.BIT\[5\].genblk1.STORAGE
+ DIBUF\[29\].X SLICE_16\[0\].RAM16.SLICE\[0\].RAM8.WORD\[4\].W.BYTE\[3\].B.GCLK VGND
+ VGND VPWR VPWR SLICE_16\[0\].RAM16.SLICE\[0\].RAM8.WORD\[4\].W.BYTE\[3\].B.Q_WIRE\[5\]
+ sky130_fd_sc_hd__dlxtp_1
Xtap_26_28 VGND VPWR sky130_fd_sc_hd__tapvpwrvgnd_1
Xtap_26_17 VGND VPWR sky130_fd_sc_hd__tapvpwrvgnd_1
XSLICE_16\[0\].RAM16.SLICE\[0\].RAM8.WORD\[2\].W.BYTE\[1\].B.BIT\[4\].genblk1.STORAGE
+ DIBUF\[12\].X SLICE_16\[0\].RAM16.SLICE\[0\].RAM8.WORD\[2\].W.BYTE\[1\].B.GCLK VGND
+ VGND VPWR VPWR SLICE_16\[0\].RAM16.SLICE\[0\].RAM8.WORD\[2\].W.BYTE\[1\].B.Q_WIRE\[4\]
+ sky130_fd_sc_hd__dlxtp_1
XSLICE_16\[1\].RAM16.SLICE\[0\].RAM8.WORD\[2\].W.BYTE\[1\].B.SEL0INV SLICE_16\[1\].RAM16.SLICE\[0\].RAM8.WORD\[2\].W.BYTE\[0\].B.SEL0
+ VGND VGND VPWR VPWR SLICE_16\[1\].RAM16.SLICE\[0\].RAM8.WORD\[2\].W.BYTE\[1\].B.SEL0_B
+ sky130_fd_sc_hd__inv_1
Xtap_35_3 VGND VPWR sky130_fd_sc_hd__tapvpwrvgnd_1
XSLICE_16\[0\].RAM16.SLICE\[0\].RAM8.WORD\[6\].W.BYTE\[1\].B.BIT\[6\].OBUF0 SLICE_16\[0\].RAM16.SLICE\[0\].RAM8.WORD\[6\].W.BYTE\[1\].B.Q_WIRE\[6\]
+ SLICE_16\[0\].RAM16.SLICE\[0\].RAM8.WORD\[6\].W.BYTE\[1\].B.SEL0_B VGND VGND VPWR
+ VPWR SLICE_16\[0\].RAM16.BYTE\[1\].FLOATBUF0\[14\].Z sky130_fd_sc_hd__ebufn_2
Xfill_39_68 VGND VPWR sky130_fd_sc_hd__tapvpwrvgnd_1
Xfill_39_57 VGND VPWR sky130_fd_sc_hd__tapvpwrvgnd_1
Xfill_39_46 VGND VGND VPWR VPWR sky130_fd_sc_hd__decap_12
Xfill_39_35 VGND VGND VPWR VPWR sky130_fd_sc_hd__decap_12
Xfill_39_24 VGND VPWR sky130_fd_sc_hd__tapvpwrvgnd_1
Xfill_39_13 VGND VGND VPWR VPWR sky130_fd_sc_hd__decap_12
Xtap_28_2 VGND VPWR sky130_fd_sc_hd__tapvpwrvgnd_1
XSLICE_16\[1\].RAM16.SLICE\[1\].RAM8.WORD\[3\].W.BYTE\[3\].B.genblk1.CLKINV SLICE_16\[1\].RAM16.SLICE\[1\].RAM8.WORD\[3\].W.BYTE\[0\].B.CLK
+ VGND VGND VPWR VPWR SLICE_16\[1\].RAM16.SLICE\[1\].RAM8.WORD\[3\].W.BYTE\[3\].B.CLK_B
+ sky130_fd_sc_hd__inv_1
XSLICE_16\[0\].RAM16.SLICE\[1\].RAM8.WORD\[4\].W.BYTE\[3\].B.SEL0INV SLICE_16\[0\].RAM16.SLICE\[1\].RAM8.WORD\[4\].W.BYTE\[0\].B.SEL0
+ VGND VGND VPWR VPWR SLICE_16\[0\].RAM16.SLICE\[1\].RAM8.WORD\[4\].W.BYTE\[3\].B.SEL0_B
+ sky130_fd_sc_hd__inv_1
XSLICE_16\[1\].RAM16.SLICE\[0\].RAM8.WORD\[3\].W.BYTE\[0\].B.BIT\[2\].OBUF0 SLICE_16\[1\].RAM16.SLICE\[0\].RAM8.WORD\[3\].W.BYTE\[0\].B.Q_WIRE\[2\]
+ SLICE_16\[1\].RAM16.SLICE\[0\].RAM8.WORD\[3\].W.BYTE\[0\].B.SEL0_B VGND VGND VPWR
+ VPWR SLICE_16\[1\].RAM16.BYTE\[0\].FLOATBUF0\[2\].Z sky130_fd_sc_hd__ebufn_2
XSLICE_16\[0\].RAM16.SLICE\[1\].RAM8.WORD\[0\].W.BYTE\[2\].B.BIT\[1\].OBUF0 SLICE_16\[0\].RAM16.SLICE\[1\].RAM8.WORD\[0\].W.BYTE\[2\].B.Q_WIRE\[1\]
+ SLICE_16\[0\].RAM16.SLICE\[1\].RAM8.WORD\[0\].W.BYTE\[2\].B.SEL0_B VGND VGND VPWR
+ VPWR SLICE_16\[0\].RAM16.BYTE\[2\].FLOATBUF0\[17\].Z sky130_fd_sc_hd__ebufn_2
XSLICE_16\[1\].RAM16.SLICE\[1\].RAM8.WORD\[7\].W.BYTE\[2\].B.BIT\[2\].genblk1.STORAGE
+ DIBUF\[18\].X SLICE_16\[1\].RAM16.SLICE\[1\].RAM8.WORD\[7\].W.BYTE\[2\].B.GCLK VGND
+ VGND VPWR VPWR SLICE_16\[1\].RAM16.SLICE\[1\].RAM8.WORD\[7\].W.BYTE\[2\].B.Q_WIRE\[2\]
+ sky130_fd_sc_hd__dlxtp_1
XSLICE_16\[1\].RAM16.SLICE\[1\].RAM8.WORD\[1\].W.BYTE\[3\].B.BIT\[3\].genblk1.STORAGE
+ DIBUF\[27\].X SLICE_16\[1\].RAM16.SLICE\[1\].RAM8.WORD\[1\].W.BYTE\[3\].B.GCLK VGND
+ VGND VPWR VPWR SLICE_16\[1\].RAM16.SLICE\[1\].RAM8.WORD\[1\].W.BYTE\[3\].B.Q_WIRE\[3\]
+ sky130_fd_sc_hd__dlxtp_1
XSLICE_16\[1\].RAM16.SLICE\[0\].RAM8.WORD\[7\].W.BYTE\[3\].B.BIT\[5\].OBUF0 SLICE_16\[1\].RAM16.SLICE\[0\].RAM8.WORD\[7\].W.BYTE\[3\].B.Q_WIRE\[5\]
+ SLICE_16\[1\].RAM16.SLICE\[0\].RAM8.WORD\[7\].W.BYTE\[3\].B.SEL0_B VGND VGND VPWR
+ VPWR SLICE_16\[1\].RAM16.BYTE\[3\].FLOATBUF0\[29\].Z sky130_fd_sc_hd__ebufn_2
Xfill_20_92 VGND VGND VPWR VPWR sky130_fd_sc_hd__decap_12
Xfill_20_81 VGND VPWR sky130_fd_sc_hd__tapvpwrvgnd_1
Xfill_20_70 VGND VGND VPWR VPWR sky130_fd_sc_hd__decap_12
XSLICE_16\[1\].RAM16.SLICE\[1\].RAM8.WORD\[5\].W.BYTE\[0\].B.BIT\[1\].genblk1.STORAGE
+ DIBUF\[1\].X SLICE_16\[1\].RAM16.SLICE\[1\].RAM8.WORD\[5\].W.BYTE\[0\].B.GCLK VGND
+ VGND VPWR VPWR SLICE_16\[1\].RAM16.SLICE\[1\].RAM8.WORD\[5\].W.BYTE\[0\].B.Q_WIRE\[1\]
+ sky130_fd_sc_hd__dlxtp_1
XSLICE_16\[0\].RAM16.SLICE\[0\].RAM8.WORD\[0\].W.BYTE\[2\].B.SEL0INV SLICE_16\[0\].RAM16.SLICE\[0\].RAM8.WORD\[0\].W.BYTE\[0\].B.SEL0
+ VGND VGND VPWR VPWR SLICE_16\[0\].RAM16.SLICE\[0\].RAM8.WORD\[0\].W.BYTE\[2\].B.SEL0_B
+ sky130_fd_sc_hd__inv_1
Xtap_12_19 VGND VPWR sky130_fd_sc_hd__tapvpwrvgnd_1
XSLICE_16\[0\].RAM16.SLICE\[0\].RAM8.WORD\[0\].W.BYTE\[1\].B.genblk1.CLKINV SLICE_16\[0\].RAM16.SLICE\[0\].RAM8.WORD\[0\].W.BYTE\[0\].B.CLK
+ VGND VGND VPWR VPWR SLICE_16\[0\].RAM16.SLICE\[0\].RAM8.WORD\[0\].W.BYTE\[1\].B.CLK_B
+ sky130_fd_sc_hd__inv_1
Xfill_4_5 VGND VPWR sky130_fd_sc_hd__tapvpwrvgnd_1
XSLICE_16\[1\].RAM16.SLICE\[0\].RAM8.WORD\[6\].W.BYTE\[1\].B.CGAND SLICE_16\[1\].RAM16.SLICE\[0\].RAM8.WORD\[6\].W.BYTE\[0\].B.SEL0
+ SLICE_16\[1\].RAM16.SLICE\[0\].RAM8.WE0_buf\[1\] VGND VGND VPWR VPWR SLICE_16\[1\].RAM16.SLICE\[0\].RAM8.WORD\[6\].W.BYTE\[1\].B.WE0_WIRE
+ sky130_fd_sc_hd__and2_1
Xtap_37_27 VGND VPWR sky130_fd_sc_hd__tapvpwrvgnd_1
Xtap_37_16 VGND VPWR sky130_fd_sc_hd__tapvpwrvgnd_1
Xtap_14_8 VGND VPWR sky130_fd_sc_hd__tapvpwrvgnd_1
XDIBUF\[17\].__cell__ Di0[17] VGND VGND VPWR VPWR DIBUF\[17\].X sky130_fd_sc_hd__clkbuf_16
XSLICE_16\[1\].RAM16.SLICE\[0\].RAM8.WORD\[2\].W.BYTE\[0\].B.BIT\[7\].genblk1.STORAGE
+ DIBUF\[7\].X SLICE_16\[1\].RAM16.SLICE\[0\].RAM8.WORD\[2\].W.BYTE\[0\].B.GCLK VGND
+ VGND VPWR VPWR SLICE_16\[1\].RAM16.SLICE\[0\].RAM8.WORD\[2\].W.BYTE\[0\].B.Q_WIRE\[7\]
+ sky130_fd_sc_hd__dlxtp_1
Xtap_7_7 VGND VPWR sky130_fd_sc_hd__tapvpwrvgnd_1
Xfill_41_58 VGND VGND VPWR VPWR sky130_fd_sc_hd__decap_12
Xfill_41_47 VGND VGND VPWR VPWR sky130_fd_sc_hd__decap_12
Xfill_41_36 VGND VPWR sky130_fd_sc_hd__tapvpwrvgnd_1
Xfill_41_25 VGND VGND VPWR VPWR sky130_fd_sc_hd__decap_12
Xfill_41_14 VGND VGND VPWR VPWR sky130_fd_sc_hd__decap_12
XSLICE_16\[1\].RAM16.SLICE\[0\].RAM8.WORD\[6\].W.BYTE\[1\].B.BIT\[2\].OBUF0 SLICE_16\[1\].RAM16.SLICE\[0\].RAM8.WORD\[6\].W.BYTE\[1\].B.Q_WIRE\[2\]
+ SLICE_16\[1\].RAM16.SLICE\[0\].RAM8.WORD\[6\].W.BYTE\[1\].B.SEL0_B VGND VGND VPWR
+ VPWR SLICE_16\[1\].RAM16.BYTE\[1\].FLOATBUF0\[10\].Z sky130_fd_sc_hd__ebufn_2
XSLICE_16\[0\].RAM16.SLICE\[1\].RAM8.WORD\[3\].W.BYTE\[3\].B.BIT\[1\].OBUF0 SLICE_16\[0\].RAM16.SLICE\[1\].RAM8.WORD\[3\].W.BYTE\[3\].B.Q_WIRE\[1\]
+ SLICE_16\[0\].RAM16.SLICE\[1\].RAM8.WORD\[3\].W.BYTE\[3\].B.SEL0_B VGND VGND VPWR
+ VPWR SLICE_16\[0\].RAM16.BYTE\[3\].FLOATBUF0\[25\].Z sky130_fd_sc_hd__ebufn_2
Xtap_8_20 VGND VPWR sky130_fd_sc_hd__tapvpwrvgnd_1
Xtap_8_31 VGND VPWR sky130_fd_sc_hd__tapvpwrvgnd_1
Xfill_41_69 VGND VPWR sky130_fd_sc_hd__tapvpwrvgnd_1
Xtap_40_1 VGND VPWR sky130_fd_sc_hd__tapvpwrvgnd_1
Xtap_33_0 VGND VPWR sky130_fd_sc_hd__tapvpwrvgnd_1
XSLICE_16\[0\].RAM16.SLICE\[0\].RAM8.WORD\[3\].W.BYTE\[0\].B.BIT\[3\].genblk1.STORAGE
+ DIBUF\[3\].X SLICE_16\[0\].RAM16.SLICE\[0\].RAM8.WORD\[3\].W.BYTE\[0\].B.GCLK VGND
+ VGND VPWR VPWR SLICE_16\[0\].RAM16.SLICE\[0\].RAM8.WORD\[3\].W.BYTE\[0\].B.Q_WIRE\[3\]
+ sky130_fd_sc_hd__dlxtp_1
XSLICE_16\[0\].RAM16.SLICE\[0\].RAM8.WORD\[5\].W.BYTE\[2\].B.BIT\[4\].genblk1.STORAGE
+ DIBUF\[20\].X SLICE_16\[0\].RAM16.SLICE\[0\].RAM8.WORD\[5\].W.BYTE\[2\].B.GCLK VGND
+ VGND VPWR VPWR SLICE_16\[0\].RAM16.SLICE\[0\].RAM8.WORD\[5\].W.BYTE\[2\].B.Q_WIRE\[4\]
+ sky130_fd_sc_hd__dlxtp_1
XSLICE_16\[0\].RAM16.SLICE\[1\].RAM8.WORD\[0\].W.BYTE\[0\].B.BIT\[6\].OBUF0 SLICE_16\[0\].RAM16.SLICE\[1\].RAM8.WORD\[0\].W.BYTE\[0\].B.Q_WIRE\[6\]
+ SLICE_16\[0\].RAM16.SLICE\[1\].RAM8.WORD\[0\].W.BYTE\[0\].B.SEL0_B VGND VGND VPWR
+ VPWR SLICE_16\[0\].RAM16.BYTE\[0\].FLOATBUF0\[6\].Z sky130_fd_sc_hd__ebufn_2
XSLICE_16\[0\].RAM16.SLICE\[0\].RAM8.WORD\[3\].W.BYTE\[2\].B.genblk1.CLKINV SLICE_16\[0\].RAM16.SLICE\[0\].RAM8.WORD\[3\].W.BYTE\[0\].B.CLK
+ VGND VGND VPWR VPWR SLICE_16\[0\].RAM16.SLICE\[0\].RAM8.WORD\[3\].W.BYTE\[2\].B.CLK_B
+ sky130_fd_sc_hd__inv_1
XSLICE_16\[0\].RAM16.SLICE\[1\].RAM8.WORD\[1\].W.BYTE\[2\].B.genblk1.CG SLICE_16\[0\].RAM16.SLICE\[1\].RAM8.WORD\[1\].W.BYTE\[2\].B.CLK_B
+ SLICE_16\[0\].RAM16.SLICE\[1\].RAM8.WORD\[1\].W.BYTE\[2\].B.WE0_WIRE VGND VGND VPWR
+ VPWR SLICE_16\[0\].RAM16.SLICE\[1\].RAM8.WORD\[1\].W.BYTE\[2\].B.GCLK sky130_fd_sc_hd__dlclkp_1
XSLICE_16\[1\].RAM16.Do0_REG.OUTREG_BYTE\[2\].DIODE\[5\] SLICE_16\[1\].RAM16.BYTE\[2\].FLOATBUF0\[21\].Z
+ VGND VGND VPWR VPWR sky130_fd_sc_hd__diode_2
XSLICE_16\[0\].RAM16.DEC0.AND1 SLICE_16\[0\].RAM16.A0BUF\[3\].X SLICE_16\[0\].RAM16.DEC0.EN
+ VGND VGND VPWR VPWR SLICE_16\[0\].RAM16.DEC0.SEL\[1\] sky130_fd_sc_hd__and2_2
Xfill_47_2 VGND VGND VPWR VPWR sky130_fd_sc_hd__decap_12
Xtap_23_29 VGND VPWR sky130_fd_sc_hd__tapvpwrvgnd_1
Xtap_23_18 VGND VPWR sky130_fd_sc_hd__tapvpwrvgnd_1
XSLICE_16\[0\].RAM16.BYTE\[3\].FLOATBUF0\[31\].__cell__ SLICE_16\[0\].RAM16.BYTE\[3\].FLOATBUF0\[24\].A
+ SLICE_16\[0\].RAM16.BYTE\[3\].FLOATBUF0\[24\].TE_B VGND VGND VPWR VPWR SLICE_16\[0\].RAM16.BYTE\[3\].FLOATBUF0\[31\].Z
+ sky130_fd_sc_hd__ebufn_2
Xfill_2_2 VGND VPWR sky130_fd_sc_hd__tapvpwrvgnd_1
XSLICE_16\[1\].RAM16.SLICE\[1\].RAM8.WORD\[1\].W.BYTE\[2\].B.BIT\[5\].OBUF0 SLICE_16\[1\].RAM16.SLICE\[1\].RAM8.WORD\[1\].W.BYTE\[2\].B.Q_WIRE\[5\]
+ SLICE_16\[1\].RAM16.SLICE\[1\].RAM8.WORD\[1\].W.BYTE\[2\].B.SEL0_B VGND VGND VPWR
+ VPWR SLICE_16\[1\].RAM16.BYTE\[2\].FLOATBUF0\[21\].Z sky130_fd_sc_hd__ebufn_2
XSLICE_16\[1\].RAM16.Do0_REG.Do_CLKBUF\[2\] SLICE_16\[1\].RAM16.Do0_REG.CLK_buf VGND
+ VGND VPWR VPWR SLICE_16\[1\].RAM16.Do0_REG.CLKBUF\[2\] sky130_fd_sc_hd__clkbuf_4
XSLICE_16\[1\].RAM16.SLICE\[1\].RAM8.WORD\[7\].W.BYTE\[0\].B.CGAND SLICE_16\[1\].RAM16.SLICE\[1\].RAM8.WORD\[7\].W.BYTE\[0\].B.SEL0
+ SLICE_16\[1\].RAM16.SLICE\[1\].RAM8.WE0_buf\[0\] VGND VGND VPWR VPWR SLICE_16\[1\].RAM16.SLICE\[1\].RAM8.WORD\[7\].W.BYTE\[0\].B.WE0_WIRE
+ sky130_fd_sc_hd__and2_1
XSLICE_16\[1\].RAM16.SLICE\[1\].RAM8.WORD\[2\].W.BYTE\[2\].B.BIT\[2\].genblk1.STORAGE
+ DIBUF\[18\].X SLICE_16\[1\].RAM16.SLICE\[1\].RAM8.WORD\[2\].W.BYTE\[2\].B.GCLK VGND
+ VGND VPWR VPWR SLICE_16\[1\].RAM16.SLICE\[1\].RAM8.WORD\[2\].W.BYTE\[2\].B.Q_WIRE\[2\]
+ sky130_fd_sc_hd__dlxtp_1
XSLICE_16\[1\].RAM16.SLICE\[1\].RAM8.WORD\[0\].W.BYTE\[0\].B.BIT\[1\].genblk1.STORAGE
+ DIBUF\[1\].X SLICE_16\[1\].RAM16.SLICE\[1\].RAM8.WORD\[0\].W.BYTE\[0\].B.GCLK VGND
+ VGND VPWR VPWR SLICE_16\[1\].RAM16.SLICE\[1\].RAM8.WORD\[0\].W.BYTE\[0\].B.Q_WIRE\[1\]
+ sky130_fd_sc_hd__dlxtp_1
XSLICE_16\[0\].RAM16.SLICE\[1\].RAM8.WORD\[3\].W.BYTE\[1\].B.BIT\[6\].OBUF0 SLICE_16\[0\].RAM16.SLICE\[1\].RAM8.WORD\[3\].W.BYTE\[1\].B.Q_WIRE\[6\]
+ SLICE_16\[0\].RAM16.SLICE\[1\].RAM8.WORD\[3\].W.BYTE\[1\].B.SEL0_B VGND VGND VPWR
+ VPWR SLICE_16\[0\].RAM16.BYTE\[1\].FLOATBUF0\[14\].Z sky130_fd_sc_hd__ebufn_2
Xtap_12_5 VGND VPWR sky130_fd_sc_hd__tapvpwrvgnd_1
XSLICE_16\[0\].RAM16.SLICE\[0\].RAM8.WORD\[1\].W.BYTE\[3\].B.BIT\[0\].OBUF0 SLICE_16\[0\].RAM16.SLICE\[0\].RAM8.WORD\[1\].W.BYTE\[3\].B.Q_WIRE\[0\]
+ SLICE_16\[0\].RAM16.SLICE\[0\].RAM8.WORD\[1\].W.BYTE\[3\].B.SEL0_B VGND VGND VPWR
+ VPWR SLICE_16\[0\].RAM16.BYTE\[3\].FLOATBUF0\[24\].Z sky130_fd_sc_hd__ebufn_2
Xtap_5_4 VGND VPWR sky130_fd_sc_hd__tapvpwrvgnd_1
XSLICE_16\[0\].RAM16.SLICE\[0\].RAM8.WORD\[6\].W.BYTE\[3\].B.genblk1.CLKINV SLICE_16\[0\].RAM16.SLICE\[0\].RAM8.WORD\[6\].W.BYTE\[0\].B.CLK
+ VGND VGND VPWR VPWR SLICE_16\[0\].RAM16.SLICE\[0\].RAM8.WORD\[6\].W.BYTE\[3\].B.CLK_B
+ sky130_fd_sc_hd__inv_1
XSLICE_16\[1\].RAM16.SLICE\[1\].RAM8.WORD\[2\].W.BYTE\[3\].B.SEL0INV SLICE_16\[1\].RAM16.SLICE\[1\].RAM8.WORD\[2\].W.BYTE\[0\].B.SEL0
+ VGND VGND VPWR VPWR SLICE_16\[1\].RAM16.SLICE\[1\].RAM8.WORD\[2\].W.BYTE\[3\].B.SEL0_B
+ sky130_fd_sc_hd__inv_1
XSLICE_16\[1\].RAM16.SLICE\[0\].RAM8.WORD\[5\].W.BYTE\[1\].B.BIT\[7\].genblk1.STORAGE
+ DIBUF\[15\].X SLICE_16\[1\].RAM16.SLICE\[0\].RAM8.WORD\[5\].W.BYTE\[1\].B.GCLK VGND
+ VGND VPWR VPWR SLICE_16\[1\].RAM16.SLICE\[0\].RAM8.WORD\[5\].W.BYTE\[1\].B.Q_WIRE\[7\]
+ sky130_fd_sc_hd__dlxtp_1
Xfill_40_9 VGND VPWR sky130_fd_sc_hd__tapvpwrvgnd_1
XSLICE_16\[1\].RAM16.SLICE\[1\].RAM8.WORD\[0\].W.BYTE\[0\].B.BIT\[2\].OBUF0 SLICE_16\[1\].RAM16.SLICE\[1\].RAM8.WORD\[0\].W.BYTE\[0\].B.Q_WIRE\[2\]
+ SLICE_16\[1\].RAM16.SLICE\[1\].RAM8.WORD\[0\].W.BYTE\[0\].B.SEL0_B VGND VGND VPWR
+ VPWR SLICE_16\[1\].RAM16.BYTE\[0\].FLOATBUF0\[2\].Z sky130_fd_sc_hd__ebufn_2
XSLICE_16\[1\].RAM16.SLICE\[1\].RAM8.WORD\[4\].W.BYTE\[3\].B.BIT\[5\].OBUF0 SLICE_16\[1\].RAM16.SLICE\[1\].RAM8.WORD\[4\].W.BYTE\[3\].B.Q_WIRE\[5\]
+ SLICE_16\[1\].RAM16.SLICE\[1\].RAM8.WORD\[4\].W.BYTE\[3\].B.SEL0_B VGND VGND VPWR
+ VPWR SLICE_16\[1\].RAM16.BYTE\[3\].FLOATBUF0\[29\].Z sky130_fd_sc_hd__ebufn_2
XSLICE_16\[1\].RAM16.SLICE\[0\].RAM8.WORD\[5\].W.BYTE\[0\].B.genblk1.CG SLICE_16\[1\].RAM16.SLICE\[0\].RAM8.WORD\[5\].W.BYTE\[0\].B.CLK_B
+ SLICE_16\[1\].RAM16.SLICE\[0\].RAM8.WORD\[5\].W.BYTE\[0\].B.WE0_WIRE VGND VGND VPWR
+ VPWR SLICE_16\[1\].RAM16.SLICE\[0\].RAM8.WORD\[5\].W.BYTE\[0\].B.GCLK sky130_fd_sc_hd__dlclkp_1
Xfill_19_6 VGND VPWR sky130_fd_sc_hd__tapvpwrvgnd_1
XSLICE_16\[0\].RAM16.SLICE\[0\].RAM8.WORD\[0\].W.BYTE\[2\].B.BIT\[4\].genblk1.STORAGE
+ DIBUF\[20\].X SLICE_16\[0\].RAM16.SLICE\[0\].RAM8.WORD\[0\].W.BYTE\[2\].B.GCLK VGND
+ VGND VPWR VPWR SLICE_16\[0\].RAM16.SLICE\[0\].RAM8.WORD\[0\].W.BYTE\[2\].B.Q_WIRE\[4\]
+ sky130_fd_sc_hd__dlxtp_1
XSLICE_16\[0\].RAM16.SLICE\[0\].RAM8.WORD\[6\].W.BYTE\[1\].B.BIT\[3\].genblk1.STORAGE
+ DIBUF\[11\].X SLICE_16\[0\].RAM16.SLICE\[0\].RAM8.WORD\[6\].W.BYTE\[1\].B.GCLK VGND
+ VGND VPWR VPWR SLICE_16\[0\].RAM16.SLICE\[0\].RAM8.WORD\[6\].W.BYTE\[1\].B.Q_WIRE\[3\]
+ sky130_fd_sc_hd__dlxtp_1
XSLICE_16\[0\].RAM16.SLICE\[1\].RAM8.WEBUF\[0\].__cell__ SLICE_16\[0\].RAM16.SLICE\[0\].RAM8.WE0\[0\]
+ VGND VGND VPWR VPWR SLICE_16\[0\].RAM16.SLICE\[1\].RAM8.WE0_buf\[0\] sky130_fd_sc_hd__clkbuf_2
Xfill_42_90 VGND VPWR sky130_fd_sc_hd__tapvpwrvgnd_1
XSLICE_16\[1\].RAM16.Do0_REG.OUTREG_BYTE\[1\].Do_FF\[6\] SLICE_16\[1\].RAM16.Do0_REG.CLKBUF\[1\]
+ SLICE_16\[1\].RAM16.BYTE\[1\].FLOATBUF0\[14\].Z VGND VGND VPWR VPWR Do0MUX.A1\[14\]
+ sky130_fd_sc_hd__dfxtp_1
XSLICE_16\[0\].RAM16.SLICE\[0\].RAM8.WORD\[4\].W.BYTE\[0\].B.SEL0INV SLICE_16\[0\].RAM16.SLICE\[0\].RAM8.WORD\[4\].W.BYTE\[0\].B.SEL0
+ VGND VGND VPWR VPWR SLICE_16\[0\].RAM16.SLICE\[0\].RAM8.WORD\[4\].W.BYTE\[0\].B.SEL0_B
+ sky130_fd_sc_hd__inv_1
Xtap_18_29 VGND VPWR sky130_fd_sc_hd__tapvpwrvgnd_1
Xtap_18_18 VGND VPWR sky130_fd_sc_hd__tapvpwrvgnd_1
XSLICE_16\[0\].RAM16.SLICE\[1\].RAM8.WORD\[6\].W.BYTE\[2\].B.BIT\[6\].OBUF0 SLICE_16\[0\].RAM16.SLICE\[1\].RAM8.WORD\[6\].W.BYTE\[2\].B.Q_WIRE\[6\]
+ SLICE_16\[0\].RAM16.SLICE\[1\].RAM8.WORD\[6\].W.BYTE\[2\].B.SEL0_B VGND VGND VPWR
+ VPWR SLICE_16\[0\].RAM16.BYTE\[2\].FLOATBUF0\[22\].Z sky130_fd_sc_hd__ebufn_2
Xtap_34_28 VGND VPWR sky130_fd_sc_hd__tapvpwrvgnd_1
Xtap_34_17 VGND VPWR sky130_fd_sc_hd__tapvpwrvgnd_1
Xfill_22_49 VGND VGND VPWR VPWR sky130_fd_sc_hd__decap_12
Xfill_22_38 VGND VGND VPWR VPWR sky130_fd_sc_hd__decap_12
Xfill_22_27 VGND VPWR sky130_fd_sc_hd__tapvpwrvgnd_1
Xfill_22_16 VGND VGND VPWR VPWR sky130_fd_sc_hd__decap_12
XSLICE_16\[0\].RAM16.SLICE\[0\].RAM8.WORD\[1\].W.BYTE\[1\].B.BIT\[5\].OBUF0 SLICE_16\[0\].RAM16.SLICE\[0\].RAM8.WORD\[1\].W.BYTE\[1\].B.Q_WIRE\[5\]
+ SLICE_16\[0\].RAM16.SLICE\[0\].RAM8.WORD\[1\].W.BYTE\[1\].B.SEL0_B VGND VGND VPWR
+ VPWR SLICE_16\[0\].RAM16.BYTE\[1\].FLOATBUF0\[13\].Z sky130_fd_sc_hd__ebufn_2
Xtap_5_10 VGND VPWR sky130_fd_sc_hd__tapvpwrvgnd_1
Xtap_5_21 VGND VPWR sky130_fd_sc_hd__tapvpwrvgnd_1
Xtap_5_32 VGND VPWR sky130_fd_sc_hd__tapvpwrvgnd_1
XSLICE_16\[1\].RAM16.SLICE\[1\].RAM8.WORD\[3\].W.BYTE\[1\].B.BIT\[2\].OBUF0 SLICE_16\[1\].RAM16.SLICE\[1\].RAM8.WORD\[3\].W.BYTE\[1\].B.Q_WIRE\[2\]
+ SLICE_16\[1\].RAM16.SLICE\[1\].RAM8.WORD\[3\].W.BYTE\[1\].B.SEL0_B VGND VGND VPWR
+ VPWR SLICE_16\[1\].RAM16.BYTE\[1\].FLOATBUF0\[10\].Z sky130_fd_sc_hd__ebufn_2
XSLICE_16\[0\].RAM16.Do0_REG.OUTREG_BYTE\[3\].Do_FF\[3\] SLICE_16\[0\].RAM16.Do0_REG.CLKBUF\[3\]
+ SLICE_16\[0\].RAM16.BYTE\[3\].FLOATBUF0\[27\].Z VGND VGND VPWR VPWR Do0MUX.A0\[27\]
+ sky130_fd_sc_hd__dfxtp_1
Xtap_10_2 VGND VPWR sky130_fd_sc_hd__tapvpwrvgnd_1
Xfill_47_57 VGND VPWR sky130_fd_sc_hd__tapvpwrvgnd_1
Xfill_47_46 VGND VGND VPWR VPWR sky130_fd_sc_hd__decap_12
Xfill_47_35 VGND VGND VPWR VPWR sky130_fd_sc_hd__decap_12
Xfill_47_24 VGND VPWR sky130_fd_sc_hd__tapvpwrvgnd_1
Xfill_47_13 VGND VGND VPWR VPWR sky130_fd_sc_hd__decap_12
Xtap_3_1 VGND VPWR sky130_fd_sc_hd__tapvpwrvgnd_1
XSLICE_16\[1\].RAM16.SLICE\[1\].RAM8.WORD\[5\].W.BYTE\[3\].B.BIT\[2\].genblk1.STORAGE
+ DIBUF\[26\].X SLICE_16\[1\].RAM16.SLICE\[1\].RAM8.WORD\[5\].W.BYTE\[3\].B.GCLK VGND
+ VGND VPWR VPWR SLICE_16\[1\].RAM16.SLICE\[1\].RAM8.WORD\[5\].W.BYTE\[3\].B.Q_WIRE\[2\]
+ sky130_fd_sc_hd__dlxtp_1
XSLICE_16\[1\].RAM16.SLICE\[1\].RAM8.WORD\[3\].W.BYTE\[1\].B.BIT\[1\].genblk1.STORAGE
+ DIBUF\[9\].X SLICE_16\[1\].RAM16.SLICE\[1\].RAM8.WORD\[3\].W.BYTE\[1\].B.GCLK VGND
+ VGND VPWR VPWR SLICE_16\[1\].RAM16.SLICE\[1\].RAM8.WORD\[3\].W.BYTE\[1\].B.Q_WIRE\[1\]
+ sky130_fd_sc_hd__dlxtp_1
XSLICE_16\[0\].RAM16.SLICE\[1\].RAM8.WORD\[5\].W.BYTE\[0\].B.BIT\[3\].OBUF0 SLICE_16\[0\].RAM16.SLICE\[1\].RAM8.WORD\[5\].W.BYTE\[0\].B.Q_WIRE\[3\]
+ SLICE_16\[0\].RAM16.SLICE\[1\].RAM8.WORD\[5\].W.BYTE\[0\].B.SEL0_B VGND VGND VPWR
+ VPWR SLICE_16\[0\].RAM16.BYTE\[0\].FLOATBUF0\[3\].Z sky130_fd_sc_hd__ebufn_2
XSLICE_16\[0\].RAM16.SLICE\[1\].RAM8.WORD\[0\].W.BYTE\[2\].B.genblk1.CLKINV SLICE_16\[0\].RAM16.SLICE\[1\].RAM8.WORD\[0\].W.BYTE\[0\].B.CLK
+ VGND VGND VPWR VPWR SLICE_16\[0\].RAM16.SLICE\[1\].RAM8.WORD\[0\].W.BYTE\[2\].B.CLK_B
+ sky130_fd_sc_hd__inv_1
XSLICE_16\[1\].RAM16.SLICE\[0\].RAM8.WORD\[2\].W.BYTE\[3\].B.BIT\[4\].OBUF0 SLICE_16\[1\].RAM16.SLICE\[0\].RAM8.WORD\[2\].W.BYTE\[3\].B.Q_WIRE\[4\]
+ SLICE_16\[1\].RAM16.SLICE\[0\].RAM8.WORD\[2\].W.BYTE\[3\].B.SEL0_B VGND VGND VPWR
+ VPWR SLICE_16\[1\].RAM16.BYTE\[3\].FLOATBUF0\[28\].Z sky130_fd_sc_hd__ebufn_2
XSLICE_16\[1\].RAM16.SLICE\[0\].RAM8.WORD\[2\].W.BYTE\[0\].B.CGAND SLICE_16\[1\].RAM16.SLICE\[0\].RAM8.WORD\[2\].W.BYTE\[0\].B.SEL0
+ SLICE_16\[1\].RAM16.SLICE\[0\].RAM8.WE0_buf\[0\] VGND VGND VPWR VPWR SLICE_16\[1\].RAM16.SLICE\[0\].RAM8.WORD\[2\].W.BYTE\[0\].B.WE0_WIRE
+ sky130_fd_sc_hd__and2_1
Xfill_24_4 VGND VGND VPWR VPWR sky130_fd_sc_hd__decap_4
Xfill_17_3 VGND VPWR sky130_fd_sc_hd__tapvpwrvgnd_1
XSLICE_16\[0\].RAM16.SLICE\[0\].RAM8.WORD\[4\].W.BYTE\[2\].B.BIT\[5\].OBUF0 SLICE_16\[0\].RAM16.SLICE\[0\].RAM8.WORD\[4\].W.BYTE\[2\].B.Q_WIRE\[5\]
+ SLICE_16\[0\].RAM16.SLICE\[0\].RAM8.WORD\[4\].W.BYTE\[2\].B.SEL0_B VGND VGND VPWR
+ VPWR SLICE_16\[0\].RAM16.BYTE\[2\].FLOATBUF0\[21\].Z sky130_fd_sc_hd__ebufn_2
XSLICE_16\[1\].RAM16.SLICE\[1\].RAM8.WORD\[6\].W.BYTE\[2\].B.BIT\[2\].OBUF0 SLICE_16\[1\].RAM16.SLICE\[1\].RAM8.WORD\[6\].W.BYTE\[2\].B.Q_WIRE\[2\]
+ SLICE_16\[1\].RAM16.SLICE\[1\].RAM8.WORD\[6\].W.BYTE\[2\].B.SEL0_B VGND VGND VPWR
+ VPWR SLICE_16\[1\].RAM16.BYTE\[2\].FLOATBUF0\[18\].Z sky130_fd_sc_hd__ebufn_2
Xtap_29_28 VGND VPWR sky130_fd_sc_hd__tapvpwrvgnd_1
Xtap_29_17 VGND VPWR sky130_fd_sc_hd__tapvpwrvgnd_1
XSLICE_16\[1\].RAM16.SLICE\[0\].RAM8.WORD\[6\].W.BYTE\[0\].B.BIT\[6\].genblk1.STORAGE
+ DIBUF\[6\].X SLICE_16\[1\].RAM16.SLICE\[0\].RAM8.WORD\[6\].W.BYTE\[0\].B.GCLK VGND
+ VGND VPWR VPWR SLICE_16\[1\].RAM16.SLICE\[0\].RAM8.WORD\[6\].W.BYTE\[0\].B.Q_WIRE\[6\]
+ sky130_fd_sc_hd__dlxtp_1
XSLICE_16\[1\].RAM16.SLICE\[0\].RAM8.WORD\[0\].W.BYTE\[1\].B.BIT\[7\].genblk1.STORAGE
+ DIBUF\[15\].X SLICE_16\[1\].RAM16.SLICE\[0\].RAM8.WORD\[0\].W.BYTE\[1\].B.GCLK VGND
+ VGND VPWR VPWR SLICE_16\[1\].RAM16.SLICE\[0\].RAM8.WORD\[0\].W.BYTE\[1\].B.Q_WIRE\[7\]
+ sky130_fd_sc_hd__dlxtp_1
XSLICE_16\[0\].RAM16.SLICE\[0\].RAM8.WEBUF\[2\].__cell__ SLICE_16\[0\].RAM16.SLICE\[0\].RAM8.WE0\[2\]
+ VGND VGND VPWR VPWR SLICE_16\[0\].RAM16.SLICE\[0\].RAM8.WE0_buf\[2\] sky130_fd_sc_hd__clkbuf_2
Xfill_17_38 VGND VGND VPWR VPWR sky130_fd_sc_hd__decap_12
Xfill_17_27 VGND VPWR sky130_fd_sc_hd__tapvpwrvgnd_1
Xfill_17_16 VGND VGND VPWR VPWR sky130_fd_sc_hd__decap_12
XSLICE_16\[0\].RAM16.SLICE\[0\].RAM8.WORD\[3\].W.BYTE\[3\].B.BIT\[4\].genblk1.STORAGE
+ DIBUF\[28\].X SLICE_16\[0\].RAM16.SLICE\[0\].RAM8.WORD\[3\].W.BYTE\[3\].B.GCLK VGND
+ VGND VPWR VPWR SLICE_16\[0\].RAM16.SLICE\[0\].RAM8.WORD\[3\].W.BYTE\[3\].B.Q_WIRE\[4\]
+ sky130_fd_sc_hd__dlxtp_1
XSLICE_16\[0\].RAM16.Do0_REG.OUTREG_BYTE\[0\].DIODE\[6\] SLICE_16\[0\].RAM16.BYTE\[0\].FLOATBUF0\[6\].Z
+ VGND VGND VPWR VPWR sky130_fd_sc_hd__diode_2
Xfill_17_49 VGND VGND VPWR VPWR sky130_fd_sc_hd__decap_12
XSLICE_16\[0\].RAM16.SLICE\[0\].RAM8.WORD\[1\].W.BYTE\[1\].B.BIT\[3\].genblk1.STORAGE
+ DIBUF\[11\].X SLICE_16\[0\].RAM16.SLICE\[0\].RAM8.WORD\[1\].W.BYTE\[1\].B.GCLK VGND
+ VGND VPWR VPWR SLICE_16\[0\].RAM16.SLICE\[0\].RAM8.WORD\[1\].W.BYTE\[1\].B.Q_WIRE\[3\]
+ sky130_fd_sc_hd__dlxtp_1
XSLICE_16\[0\].RAM16.SLICE\[0\].RAM8.WORD\[7\].W.BYTE\[0\].B.BIT\[2\].genblk1.STORAGE
+ DIBUF\[2\].X SLICE_16\[0\].RAM16.SLICE\[0\].RAM8.WORD\[7\].W.BYTE\[0\].B.GCLK VGND
+ VGND VPWR VPWR SLICE_16\[0\].RAM16.SLICE\[0\].RAM8.WORD\[7\].W.BYTE\[0\].B.Q_WIRE\[2\]
+ sky130_fd_sc_hd__dlxtp_1
XSLICE_16\[1\].RAM16.BYTE\[2\].FLOATBUF0\[16\].__cell__ SLICE_16\[1\].RAM16.BYTE\[2\].FLOATBUF0\[16\].A
+ SLICE_16\[1\].RAM16.BYTE\[2\].FLOATBUF0\[16\].TE_B VGND VGND VPWR VPWR SLICE_16\[1\].RAM16.BYTE\[2\].FLOATBUF0\[16\].Z
+ sky130_fd_sc_hd__ebufn_2
XSLICE_16\[1\].RAM16.SLICE\[0\].RAM8.WORD\[1\].W.BYTE\[1\].B.BIT\[1\].OBUF0 SLICE_16\[1\].RAM16.SLICE\[0\].RAM8.WORD\[1\].W.BYTE\[1\].B.Q_WIRE\[1\]
+ SLICE_16\[1\].RAM16.SLICE\[0\].RAM8.WORD\[1\].W.BYTE\[1\].B.SEL0_B VGND VGND VPWR
+ VPWR SLICE_16\[1\].RAM16.BYTE\[1\].FLOATBUF0\[9\].Z sky130_fd_sc_hd__ebufn_2
XSLICE_16\[0\].RAM16.SLICE\[1\].RAM8.WORD\[3\].W.BYTE\[3\].B.genblk1.CLKINV SLICE_16\[0\].RAM16.SLICE\[1\].RAM8.WORD\[3\].W.BYTE\[0\].B.CLK
+ VGND VGND VPWR VPWR SLICE_16\[0\].RAM16.SLICE\[1\].RAM8.WORD\[3\].W.BYTE\[3\].B.CLK_B
+ sky130_fd_sc_hd__inv_1
Xtap_10_30 VGND VPWR sky130_fd_sc_hd__tapvpwrvgnd_1
XSLICE_16\[0\].RAM16.SLICE\[0\].RAM8.WORD\[4\].W.BYTE\[2\].B.CGAND SLICE_16\[0\].RAM16.SLICE\[0\].RAM8.WORD\[4\].W.BYTE\[0\].B.SEL0
+ SLICE_16\[0\].RAM16.SLICE\[0\].RAM8.WE0_buf\[2\] VGND VGND VPWR VPWR SLICE_16\[0\].RAM16.SLICE\[0\].RAM8.WORD\[4\].W.BYTE\[2\].B.WE0_WIRE
+ sky130_fd_sc_hd__and2_1
XSLICE_16\[1\].RAM16.SLICE\[1\].RAM8.WORD\[6\].W.BYTE\[1\].B.SEL0INV SLICE_16\[1\].RAM16.SLICE\[1\].RAM8.WORD\[6\].W.BYTE\[0\].B.SEL0
+ VGND VGND VPWR VPWR SLICE_16\[1\].RAM16.SLICE\[1\].RAM8.WORD\[6\].W.BYTE\[1\].B.SEL0_B
+ sky130_fd_sc_hd__inv_1
XSLICE_16\[0\].RAM16.SLICE\[0\].RAM8.WORD\[3\].W.BYTE\[0\].B.BIT\[2\].OBUF0 SLICE_16\[0\].RAM16.SLICE\[0\].RAM8.WORD\[3\].W.BYTE\[0\].B.Q_WIRE\[2\]
+ SLICE_16\[0\].RAM16.SLICE\[0\].RAM8.WORD\[3\].W.BYTE\[0\].B.SEL0_B VGND VGND VPWR
+ VPWR SLICE_16\[0\].RAM16.BYTE\[0\].FLOATBUF0\[2\].Z sky130_fd_sc_hd__ebufn_2
XSLICE_16\[0\].RAM16.SLICE\[0\].RAM8.WORD\[6\].W.CLKBUF SLICE_16\[0\].RAM16.SLICE\[0\].RAM8.CLKBUF.X
+ VGND VGND VPWR VPWR SLICE_16\[0\].RAM16.SLICE\[0\].RAM8.WORD\[6\].W.BYTE\[0\].B.CLK
+ sky130_fd_sc_hd__clkbuf_4
XSLICE_16\[0\].RAM16.SLICE\[0\].RAM8.WORD\[7\].W.BYTE\[3\].B.BIT\[5\].OBUF0 SLICE_16\[0\].RAM16.SLICE\[0\].RAM8.WORD\[7\].W.BYTE\[3\].B.Q_WIRE\[5\]
+ SLICE_16\[0\].RAM16.SLICE\[0\].RAM8.WORD\[7\].W.BYTE\[3\].B.SEL0_B VGND VGND VPWR
+ VPWR SLICE_16\[0\].RAM16.BYTE\[3\].FLOATBUF0\[29\].Z sky130_fd_sc_hd__ebufn_2
XSLICE_16\[1\].RAM16.SLICE\[1\].RAM8.WORD\[6\].W.BYTE\[2\].B.BIT\[1\].genblk1.STORAGE
+ DIBUF\[17\].X SLICE_16\[1\].RAM16.SLICE\[1\].RAM8.WORD\[6\].W.BYTE\[2\].B.GCLK VGND
+ VGND VPWR VPWR SLICE_16\[1\].RAM16.SLICE\[1\].RAM8.WORD\[6\].W.BYTE\[2\].B.Q_WIRE\[1\]
+ sky130_fd_sc_hd__dlxtp_1
XSLICE_16\[1\].RAM16.SLICE\[1\].RAM8.WORD\[0\].W.BYTE\[3\].B.BIT\[2\].genblk1.STORAGE
+ DIBUF\[26\].X SLICE_16\[1\].RAM16.SLICE\[1\].RAM8.WORD\[0\].W.BYTE\[3\].B.GCLK VGND
+ VGND VPWR VPWR SLICE_16\[1\].RAM16.SLICE\[1\].RAM8.WORD\[0\].W.BYTE\[3\].B.Q_WIRE\[2\]
+ sky130_fd_sc_hd__dlxtp_1
Xtap_15_19 VGND VPWR sky130_fd_sc_hd__tapvpwrvgnd_1
XSLICE_16\[1\].RAM16.SLICE\[1\].RAM8.WORD\[6\].W.BYTE\[0\].B.BIT\[7\].OBUF0 SLICE_16\[1\].RAM16.SLICE\[1\].RAM8.WORD\[6\].W.BYTE\[0\].B.Q_WIRE\[7\]
+ SLICE_16\[1\].RAM16.SLICE\[1\].RAM8.WORD\[6\].W.BYTE\[0\].B.SEL0_B VGND VGND VPWR
+ VPWR SLICE_16\[1\].RAM16.BYTE\[0\].FLOATBUF0\[7\].Z sky130_fd_sc_hd__ebufn_2
XSLICE_16\[1\].RAM16.SLICE\[1\].RAM8.WORD\[4\].W.BYTE\[0\].B.BIT\[0\].genblk1.STORAGE
+ DIBUF\[0\].X SLICE_16\[1\].RAM16.SLICE\[1\].RAM8.WORD\[4\].W.BYTE\[0\].B.GCLK VGND
+ VGND VPWR VPWR SLICE_16\[1\].RAM16.SLICE\[1\].RAM8.WORD\[4\].W.BYTE\[0\].B.Q_WIRE\[0\]
+ sky130_fd_sc_hd__dlxtp_1
Xtap_31_29 VGND VPWR sky130_fd_sc_hd__tapvpwrvgnd_1
Xtap_31_18 VGND VPWR sky130_fd_sc_hd__tapvpwrvgnd_1
XSLICE_16\[1\].RAM16.SLICE\[0\].RAM8.WORD\[4\].W.BYTE\[2\].B.BIT\[1\].OBUF0 SLICE_16\[1\].RAM16.SLICE\[0\].RAM8.WORD\[4\].W.BYTE\[2\].B.Q_WIRE\[1\]
+ SLICE_16\[1\].RAM16.SLICE\[0\].RAM8.WORD\[4\].W.BYTE\[2\].B.SEL0_B VGND VGND VPWR
+ VPWR SLICE_16\[1\].RAM16.BYTE\[2\].FLOATBUF0\[17\].Z sky130_fd_sc_hd__ebufn_2
XSLICE_16\[1\].RAM16.SLICE\[0\].RAM8.WORD\[2\].W.BYTE\[0\].B.SEL0INV SLICE_16\[1\].RAM16.SLICE\[0\].RAM8.WORD\[2\].W.BYTE\[0\].B.SEL0
+ VGND VGND VPWR VPWR SLICE_16\[1\].RAM16.SLICE\[0\].RAM8.WORD\[2\].W.BYTE\[0\].B.SEL0_B
+ sky130_fd_sc_hd__inv_1
Xfill_22_1 VGND VGND VPWR VPWR sky130_fd_sc_hd__decap_12
Xfill_15_0 VGND VPWR sky130_fd_sc_hd__tapvpwrvgnd_1
XSLICE_16\[1\].RAM16.SLICE\[0\].RAM8.WORD\[1\].W.BYTE\[3\].B.DIODE_CLK SLICE_16\[1\].RAM16.SLICE\[0\].RAM8.WORD\[1\].W.BYTE\[0\].B.CLK
+ VGND VGND VPWR VPWR sky130_fd_sc_hd__diode_2
Xtap_37_7 VGND VPWR sky130_fd_sc_hd__tapvpwrvgnd_1
Xtap_2_33 VGND VPWR sky130_fd_sc_hd__tapvpwrvgnd_1
Xtap_2_22 VGND VPWR sky130_fd_sc_hd__tapvpwrvgnd_1
Xtap_2_11 VGND VPWR sky130_fd_sc_hd__tapvpwrvgnd_1
Xfill_44_36 VGND VPWR sky130_fd_sc_hd__tapvpwrvgnd_1
Xfill_44_25 VGND VGND VPWR VPWR sky130_fd_sc_hd__decap_12
Xfill_44_14 VGND VGND VPWR VPWR sky130_fd_sc_hd__decap_12
XSLICE_16\[0\].RAM16.SLICE\[1\].RAM8.WORD\[4\].W.BYTE\[2\].B.SEL0INV SLICE_16\[0\].RAM16.SLICE\[1\].RAM8.WORD\[4\].W.BYTE\[0\].B.SEL0
+ VGND VGND VPWR VPWR SLICE_16\[0\].RAM16.SLICE\[1\].RAM8.WORD\[4\].W.BYTE\[2\].B.SEL0_B
+ sky130_fd_sc_hd__inv_1
XSLICE_16\[0\].RAM16.SLICE\[0\].RAM8.WORD\[6\].W.BYTE\[1\].B.BIT\[2\].OBUF0 SLICE_16\[0\].RAM16.SLICE\[0\].RAM8.WORD\[6\].W.BYTE\[1\].B.Q_WIRE\[2\]
+ SLICE_16\[0\].RAM16.SLICE\[0\].RAM8.WORD\[6\].W.BYTE\[1\].B.SEL0_B VGND VGND VPWR
+ VPWR SLICE_16\[0\].RAM16.BYTE\[1\].FLOATBUF0\[10\].Z sky130_fd_sc_hd__ebufn_2
Xfill_44_69 VGND VPWR sky130_fd_sc_hd__tapvpwrvgnd_1
Xfill_44_58 VGND VGND VPWR VPWR sky130_fd_sc_hd__decap_12
Xfill_44_47 VGND VGND VPWR VPWR sky130_fd_sc_hd__decap_12
XSLICE_16\[1\].RAM16.SLICE\[0\].RAM8.WORD\[3\].W.BYTE\[2\].B.BIT\[7\].genblk1.STORAGE
+ DIBUF\[23\].X SLICE_16\[1\].RAM16.SLICE\[0\].RAM8.WORD\[3\].W.BYTE\[2\].B.GCLK VGND
+ VGND VPWR VPWR SLICE_16\[1\].RAM16.SLICE\[0\].RAM8.WORD\[3\].W.BYTE\[2\].B.Q_WIRE\[7\]
+ sky130_fd_sc_hd__dlxtp_1
XSLICE_16\[1\].RAM16.SLICE\[0\].RAM8.WORD\[1\].W.BYTE\[0\].B.BIT\[6\].genblk1.STORAGE
+ DIBUF\[6\].X SLICE_16\[1\].RAM16.SLICE\[0\].RAM8.WORD\[1\].W.BYTE\[0\].B.GCLK VGND
+ VGND VPWR VPWR SLICE_16\[1\].RAM16.SLICE\[0\].RAM8.WORD\[1\].W.BYTE\[0\].B.Q_WIRE\[6\]
+ sky130_fd_sc_hd__dlxtp_1
XSLICE_16\[0\].RAM16.SLICE\[0\].RAM8.WORD\[4\].W.BYTE\[2\].B.DIODE_CLK SLICE_16\[0\].RAM16.SLICE\[0\].RAM8.WORD\[4\].W.BYTE\[0\].B.CLK
+ VGND VGND VPWR VPWR sky130_fd_sc_hd__diode_2
XSLICE_16\[0\].RAM16.SLICE\[1\].RAM8.WORD\[3\].W.BYTE\[0\].B.BIT\[7\].genblk1.STORAGE
+ DIBUF\[7\].X SLICE_16\[0\].RAM16.SLICE\[1\].RAM8.WORD\[3\].W.BYTE\[0\].B.GCLK VGND
+ VGND VPWR VPWR SLICE_16\[0\].RAM16.SLICE\[1\].RAM8.WORD\[3\].W.BYTE\[0\].B.Q_WIRE\[7\]
+ sky130_fd_sc_hd__dlxtp_1
XSLICE_16\[1\].RAM16.SLICE\[1\].RAM8.WORD\[0\].W.BYTE\[0\].B.DIODE_CLK SLICE_16\[1\].RAM16.SLICE\[1\].RAM8.WORD\[0\].W.BYTE\[0\].B.CLK
+ VGND VGND VPWR VPWR sky130_fd_sc_hd__diode_2
XSLICE_16\[0\].RAM16.SLICE\[0\].RAM8.WORD\[0\].W.BYTE\[1\].B.SEL0INV SLICE_16\[0\].RAM16.SLICE\[0\].RAM8.WORD\[0\].W.BYTE\[0\].B.SEL0
+ VGND VGND VPWR VPWR SLICE_16\[0\].RAM16.SLICE\[0\].RAM8.WORD\[0\].W.BYTE\[1\].B.SEL0_B
+ sky130_fd_sc_hd__inv_1
XSLICE_16\[0\].RAM16.SLICE\[0\].RAM8.WORD\[4\].W.BYTE\[2\].B.BIT\[3\].genblk1.STORAGE
+ DIBUF\[19\].X SLICE_16\[0\].RAM16.SLICE\[0\].RAM8.WORD\[4\].W.BYTE\[2\].B.GCLK VGND
+ VGND VPWR VPWR SLICE_16\[0\].RAM16.SLICE\[0\].RAM8.WORD\[4\].W.BYTE\[2\].B.Q_WIRE\[3\]
+ sky130_fd_sc_hd__dlxtp_1
XSLICE_16\[1\].RAM16.SLICE\[0\].RAM8.WORD\[7\].W.BYTE\[3\].B.BIT\[1\].OBUF0 SLICE_16\[1\].RAM16.SLICE\[0\].RAM8.WORD\[7\].W.BYTE\[3\].B.Q_WIRE\[1\]
+ SLICE_16\[1\].RAM16.SLICE\[0\].RAM8.WORD\[7\].W.BYTE\[3\].B.SEL0_B VGND VGND VPWR
+ VPWR SLICE_16\[1\].RAM16.BYTE\[3\].FLOATBUF0\[25\].Z sky130_fd_sc_hd__ebufn_2
XSLICE_16\[0\].RAM16.SLICE\[1\].RAM8.WORD\[5\].W.BYTE\[1\].B.CGAND SLICE_16\[0\].RAM16.SLICE\[1\].RAM8.WORD\[5\].W.BYTE\[0\].B.SEL0
+ SLICE_16\[0\].RAM16.SLICE\[1\].RAM8.WE0_buf\[1\] VGND VGND VPWR VPWR SLICE_16\[0\].RAM16.SLICE\[1\].RAM8.WORD\[5\].W.BYTE\[1\].B.WE0_WIRE
+ sky130_fd_sc_hd__and2_1
XSLICE_16\[0\].RAM16.SLICE\[0\].RAM8.WORD\[2\].W.BYTE\[0\].B.BIT\[2\].genblk1.STORAGE
+ DIBUF\[2\].X SLICE_16\[0\].RAM16.SLICE\[0\].RAM8.WORD\[2\].W.BYTE\[0\].B.GCLK VGND
+ VGND VPWR VPWR SLICE_16\[0\].RAM16.SLICE\[0\].RAM8.WORD\[2\].W.BYTE\[0\].B.Q_WIRE\[2\]
+ sky130_fd_sc_hd__dlxtp_1
XSLICE_16\[1\].RAM16.SLICE\[1\].RAM8.CLKBUF.__cell__ SLICE_16\[1\].RAM16.CLKBUF.X
+ VGND VGND VPWR VPWR SLICE_16\[1\].RAM16.SLICE\[1\].RAM8.CLKBUF.X sky130_fd_sc_hd__clkbuf_2
XSLICE_16\[1\].RAM16.SLICE\[0\].RAM8.WORD\[4\].W.BYTE\[0\].B.BIT\[6\].OBUF0 SLICE_16\[1\].RAM16.SLICE\[0\].RAM8.WORD\[4\].W.BYTE\[0\].B.Q_WIRE\[6\]
+ SLICE_16\[1\].RAM16.SLICE\[0\].RAM8.WORD\[4\].W.BYTE\[0\].B.SEL0_B VGND VGND VPWR
+ VPWR SLICE_16\[1\].RAM16.BYTE\[0\].FLOATBUF0\[6\].Z sky130_fd_sc_hd__ebufn_2
XSLICE_16\[0\].RAM16.SLICE\[0\].RAM8.WORD\[4\].W.BYTE\[0\].B.genblk1.CG SLICE_16\[0\].RAM16.SLICE\[0\].RAM8.WORD\[4\].W.BYTE\[0\].B.CLK_B
+ SLICE_16\[0\].RAM16.SLICE\[0\].RAM8.WORD\[4\].W.BYTE\[0\].B.WE0_WIRE VGND VGND VPWR
+ VPWR SLICE_16\[0\].RAM16.SLICE\[0\].RAM8.WORD\[4\].W.BYTE\[0\].B.GCLK sky130_fd_sc_hd__dlclkp_1
XSLICE_16\[0\].RAM16.SLICE\[1\].RAM8.DEC0.ABUF\[0\] SLICE_16\[0\].RAM16.A0BUF\[0\].X
+ VGND VGND VPWR VPWR SLICE_16\[0\].RAM16.SLICE\[1\].RAM8.DEC0.A_buf\[0\] sky130_fd_sc_hd__clkbuf_2
XSLICE_16\[0\].RAM16.SLICE\[1\].RAM8.WORD\[1\].W.BYTE\[2\].B.BIT\[5\].OBUF0 SLICE_16\[0\].RAM16.SLICE\[1\].RAM8.WORD\[1\].W.BYTE\[2\].B.Q_WIRE\[5\]
+ SLICE_16\[0\].RAM16.SLICE\[1\].RAM8.WORD\[1\].W.BYTE\[2\].B.SEL0_B VGND VGND VPWR
+ VPWR SLICE_16\[0\].RAM16.BYTE\[2\].FLOATBUF0\[21\].Z sky130_fd_sc_hd__ebufn_2
Xtap_26_29 VGND VPWR sky130_fd_sc_hd__tapvpwrvgnd_1
Xtap_26_18 VGND VPWR sky130_fd_sc_hd__tapvpwrvgnd_1
XSLICE_16\[1\].RAM16.SLICE\[0\].RAM8.WORD\[6\].W.BYTE\[3\].B.genblk1.CG SLICE_16\[1\].RAM16.SLICE\[0\].RAM8.WORD\[6\].W.BYTE\[3\].B.CLK_B
+ SLICE_16\[1\].RAM16.SLICE\[0\].RAM8.WORD\[6\].W.BYTE\[3\].B.WE0_WIRE VGND VGND VPWR
+ VPWR SLICE_16\[1\].RAM16.SLICE\[0\].RAM8.WORD\[6\].W.BYTE\[3\].B.GCLK sky130_fd_sc_hd__dlclkp_1
Xtap_35_4 VGND VPWR sky130_fd_sc_hd__tapvpwrvgnd_1
Xfill_39_69 VGND VGND VPWR VPWR sky130_fd_sc_hd__decap_6
Xfill_39_58 VGND VGND VPWR VPWR sky130_fd_sc_hd__decap_12
Xfill_39_47 VGND VGND VPWR VPWR sky130_fd_sc_hd__decap_12
Xfill_39_36 VGND VPWR sky130_fd_sc_hd__tapvpwrvgnd_1
Xfill_39_25 VGND VGND VPWR VPWR sky130_fd_sc_hd__decap_12
Xfill_39_14 VGND VGND VPWR VPWR sky130_fd_sc_hd__decap_12
XSLICE_16\[1\].RAM16.SLICE\[1\].RAM8.WORD\[7\].W.BYTE\[1\].B.BIT\[0\].genblk1.STORAGE
+ DIBUF\[8\].X SLICE_16\[1\].RAM16.SLICE\[1\].RAM8.WORD\[7\].W.BYTE\[1\].B.GCLK VGND
+ VGND VPWR VPWR SLICE_16\[1\].RAM16.SLICE\[1\].RAM8.WORD\[7\].W.BYTE\[1\].B.Q_WIRE\[0\]
+ sky130_fd_sc_hd__dlxtp_1
XSLICE_16\[1\].RAM16.SLICE\[1\].RAM8.WORD\[1\].W.BYTE\[2\].B.BIT\[1\].genblk1.STORAGE
+ DIBUF\[17\].X SLICE_16\[1\].RAM16.SLICE\[1\].RAM8.WORD\[1\].W.BYTE\[2\].B.GCLK VGND
+ VGND VPWR VPWR SLICE_16\[1\].RAM16.SLICE\[1\].RAM8.WORD\[1\].W.BYTE\[2\].B.Q_WIRE\[1\]
+ sky130_fd_sc_hd__dlxtp_1
Xtap_28_3 VGND VPWR sky130_fd_sc_hd__tapvpwrvgnd_1
XSLICE_16\[0\].RAM16.SLICE\[1\].RAM8.WORD\[0\].W.BYTE\[0\].B.BIT\[2\].OBUF0 SLICE_16\[0\].RAM16.SLICE\[1\].RAM8.WORD\[0\].W.BYTE\[0\].B.Q_WIRE\[2\]
+ SLICE_16\[0\].RAM16.SLICE\[1\].RAM8.WORD\[0\].W.BYTE\[0\].B.SEL0_B VGND VGND VPWR
+ VPWR SLICE_16\[0\].RAM16.BYTE\[0\].FLOATBUF0\[2\].Z sky130_fd_sc_hd__ebufn_2
XSLICE_16\[1\].RAM16.SLICE\[0\].RAM8.WORD\[7\].W.BYTE\[1\].B.BIT\[6\].OBUF0 SLICE_16\[1\].RAM16.SLICE\[0\].RAM8.WORD\[7\].W.BYTE\[1\].B.Q_WIRE\[6\]
+ SLICE_16\[1\].RAM16.SLICE\[0\].RAM8.WORD\[7\].W.BYTE\[1\].B.SEL0_B VGND VGND VPWR
+ VPWR SLICE_16\[1\].RAM16.BYTE\[1\].FLOATBUF0\[14\].Z sky130_fd_sc_hd__ebufn_2
XSLICE_16\[1\].RAM16.SLICE\[0\].RAM8.WORD\[6\].W.BYTE\[3\].B.BIT\[7\].genblk1.STORAGE
+ DIBUF\[31\].X SLICE_16\[1\].RAM16.SLICE\[0\].RAM8.WORD\[6\].W.BYTE\[3\].B.GCLK VGND
+ VGND VPWR VPWR SLICE_16\[1\].RAM16.SLICE\[0\].RAM8.WORD\[6\].W.BYTE\[3\].B.Q_WIRE\[7\]
+ sky130_fd_sc_hd__dlxtp_1
Xfill_20_93 VGND VPWR sky130_fd_sc_hd__tapvpwrvgnd_1
Xfill_20_82 VGND VGND VPWR VPWR sky130_fd_sc_hd__decap_12
Xfill_20_71 VGND VGND VPWR VPWR sky130_fd_sc_hd__decap_12
Xfill_20_60 VGND VPWR sky130_fd_sc_hd__tapvpwrvgnd_1
XSLICE_16\[0\].RAM16.SLICE\[1\].RAM8.WORD\[4\].W.BYTE\[3\].B.BIT\[5\].OBUF0 SLICE_16\[0\].RAM16.SLICE\[1\].RAM8.WORD\[4\].W.BYTE\[3\].B.Q_WIRE\[5\]
+ SLICE_16\[0\].RAM16.SLICE\[1\].RAM8.WORD\[4\].W.BYTE\[3\].B.SEL0_B VGND VGND VPWR
+ VPWR SLICE_16\[0\].RAM16.BYTE\[3\].FLOATBUF0\[29\].Z sky130_fd_sc_hd__ebufn_2
XDo0MUX.M\[1\].DIODE_A0MUX\[15\] Do0MUX.A0\[15\] VGND VGND VPWR VPWR sky130_fd_sc_hd__diode_2
XSLICE_16\[1\].RAM16.SLICE\[0\].RAM8.WORD\[4\].W.BYTE\[1\].B.BIT\[6\].genblk1.STORAGE
+ DIBUF\[14\].X SLICE_16\[1\].RAM16.SLICE\[0\].RAM8.WORD\[4\].W.BYTE\[1\].B.GCLK VGND
+ VGND VPWR VPWR SLICE_16\[1\].RAM16.SLICE\[0\].RAM8.WORD\[4\].W.BYTE\[1\].B.Q_WIRE\[6\]
+ sky130_fd_sc_hd__dlxtp_1
Xfill_45_90 VGND VPWR sky130_fd_sc_hd__tapvpwrvgnd_1
XSLICE_16\[1\].RAM16.SLICE\[1\].RAM8.WORD\[3\].W.BYTE\[3\].B.DIODE_CLK SLICE_16\[1\].RAM16.SLICE\[1\].RAM8.WORD\[3\].W.BYTE\[0\].B.CLK
+ VGND VGND VPWR VPWR sky130_fd_sc_hd__diode_2
XSLICE_16\[0\].RAM16.SLICE\[1\].RAM8.WORD\[6\].W.BYTE\[1\].B.BIT\[7\].genblk1.STORAGE
+ DIBUF\[15\].X SLICE_16\[0\].RAM16.SLICE\[1\].RAM8.WORD\[6\].W.BYTE\[1\].B.GCLK VGND
+ VGND VPWR VPWR SLICE_16\[0\].RAM16.SLICE\[1\].RAM8.WORD\[6\].W.BYTE\[1\].B.Q_WIRE\[7\]
+ sky130_fd_sc_hd__dlxtp_1
Xfill_4_6 VGND VGND VPWR VPWR sky130_fd_sc_hd__fill_2
XSLICE_16\[0\].RAM16.TIE0\[1\].__cell__ VGND VGND VPWR VPWR SLICE_16\[0\].RAM16.TIE0\[1\].__cell__/HI
+ SLICE_16\[0\].RAM16.BYTE\[1\].FLOATBUF0\[10\].A sky130_fd_sc_hd__conb_1
XSLICE_16\[0\].RAM16.SLICE\[0\].RAM8.WORD\[5\].W.BYTE\[1\].B.BIT\[2\].genblk1.STORAGE
+ DIBUF\[10\].X SLICE_16\[0\].RAM16.SLICE\[0\].RAM8.WORD\[5\].W.BYTE\[1\].B.GCLK VGND
+ VGND VPWR VPWR SLICE_16\[0\].RAM16.SLICE\[0\].RAM8.WORD\[5\].W.BYTE\[1\].B.Q_WIRE\[2\]
+ sky130_fd_sc_hd__dlxtp_1
XSLICE_16\[0\].RAM16.SLICE\[0\].RAM8.WORD\[7\].W.BYTE\[3\].B.BIT\[3\].genblk1.STORAGE
+ DIBUF\[27\].X SLICE_16\[0\].RAM16.SLICE\[0\].RAM8.WORD\[7\].W.BYTE\[3\].B.GCLK VGND
+ VGND VPWR VPWR SLICE_16\[0\].RAM16.SLICE\[0\].RAM8.WORD\[7\].W.BYTE\[3\].B.Q_WIRE\[3\]
+ sky130_fd_sc_hd__dlxtp_1
Xtap_37_28 VGND VPWR sky130_fd_sc_hd__tapvpwrvgnd_1
Xtap_37_17 VGND VPWR sky130_fd_sc_hd__tapvpwrvgnd_1
XSLICE_16\[1\].RAM16.SLICE\[1\].RAM8.WORD\[1\].W.BYTE\[2\].B.BIT\[1\].OBUF0 SLICE_16\[1\].RAM16.SLICE\[1\].RAM8.WORD\[1\].W.BYTE\[2\].B.Q_WIRE\[1\]
+ SLICE_16\[1\].RAM16.SLICE\[1\].RAM8.WORD\[1\].W.BYTE\[2\].B.SEL0_B VGND VGND VPWR
+ VPWR SLICE_16\[1\].RAM16.BYTE\[2\].FLOATBUF0\[17\].Z sky130_fd_sc_hd__ebufn_2
Xtap_14_9 VGND VPWR sky130_fd_sc_hd__tapvpwrvgnd_1
Xtap_7_8 VGND VPWR sky130_fd_sc_hd__tapvpwrvgnd_1
Xtap_8_10 VGND VPWR sky130_fd_sc_hd__tapvpwrvgnd_1
Xtap_8_21 VGND VPWR sky130_fd_sc_hd__tapvpwrvgnd_1
Xtap_8_32 VGND VPWR sky130_fd_sc_hd__tapvpwrvgnd_1
XDo0MUX.M\[2\].DIODE_A0MUX\[19\] Do0MUX.A0\[19\] VGND VGND VPWR VPWR sky130_fd_sc_hd__diode_2
Xfill_41_59 VGND VGND VPWR VPWR sky130_fd_sc_hd__decap_12
Xfill_41_48 VGND VPWR sky130_fd_sc_hd__tapvpwrvgnd_1
Xfill_41_37 VGND VGND VPWR VPWR sky130_fd_sc_hd__decap_12
Xfill_41_26 VGND VGND VPWR VPWR sky130_fd_sc_hd__decap_12
Xfill_41_15 VGND VPWR sky130_fd_sc_hd__tapvpwrvgnd_1
XSLICE_16\[1\].RAM16.SLICE\[1\].RAM8.WORD\[2\].W.BYTE\[2\].B.SEL0INV SLICE_16\[1\].RAM16.SLICE\[1\].RAM8.WORD\[2\].W.BYTE\[0\].B.SEL0
+ VGND VGND VPWR VPWR SLICE_16\[1\].RAM16.SLICE\[1\].RAM8.WORD\[2\].W.BYTE\[2\].B.SEL0_B
+ sky130_fd_sc_hd__inv_1
XSLICE_16\[0\].RAM16.SLICE\[1\].RAM8.WORD\[6\].W.BYTE\[2\].B.DIODE_CLK SLICE_16\[0\].RAM16.SLICE\[1\].RAM8.WORD\[6\].W.BYTE\[0\].B.CLK
+ VGND VGND VPWR VPWR sky130_fd_sc_hd__diode_2
XSLICE_16\[0\].RAM16.SLICE\[1\].RAM8.WORD\[3\].W.BYTE\[1\].B.BIT\[2\].OBUF0 SLICE_16\[0\].RAM16.SLICE\[1\].RAM8.WORD\[3\].W.BYTE\[1\].B.Q_WIRE\[2\]
+ SLICE_16\[0\].RAM16.SLICE\[1\].RAM8.WORD\[3\].W.BYTE\[1\].B.SEL0_B VGND VGND VPWR
+ VPWR SLICE_16\[0\].RAM16.BYTE\[1\].FLOATBUF0\[10\].Z sky130_fd_sc_hd__ebufn_2
XSLICE_16\[0\].RAM16.SLICE\[0\].RAM8.WORD\[0\].W.BYTE\[1\].B.CGAND SLICE_16\[0\].RAM16.SLICE\[0\].RAM8.WORD\[0\].W.BYTE\[0\].B.SEL0
+ SLICE_16\[0\].RAM16.SLICE\[0\].RAM8.WE0_buf\[1\] VGND VGND VPWR VPWR SLICE_16\[0\].RAM16.SLICE\[0\].RAM8.WORD\[0\].W.BYTE\[1\].B.WE0_WIRE
+ sky130_fd_sc_hd__and2_1
XDo0MUX.M\[0\].DIODE_A1MUX\[2\] Do0MUX.A1\[2\] VGND VGND VPWR VPWR sky130_fd_sc_hd__diode_2
Xtap_40_2 VGND VPWR sky130_fd_sc_hd__tapvpwrvgnd_1
Xtap_33_1 VGND VPWR sky130_fd_sc_hd__tapvpwrvgnd_1
Xtap_26_0 VGND VPWR sky130_fd_sc_hd__tapvpwrvgnd_1
XSLICE_16\[1\].RAM16.SLICE\[0\].RAM8.WORD\[1\].W.BYTE\[1\].B.genblk1.CLKINV SLICE_16\[1\].RAM16.SLICE\[0\].RAM8.WORD\[1\].W.BYTE\[0\].B.CLK
+ VGND VGND VPWR VPWR SLICE_16\[1\].RAM16.SLICE\[0\].RAM8.WORD\[1\].W.BYTE\[1\].B.CLK_B
+ sky130_fd_sc_hd__inv_1
XSLICE_16\[0\].RAM16.SLICE\[0\].RAM8.WORD\[2\].W.BYTE\[3\].B.BIT\[4\].OBUF0 SLICE_16\[0\].RAM16.SLICE\[0\].RAM8.WORD\[2\].W.BYTE\[3\].B.Q_WIRE\[4\]
+ SLICE_16\[0\].RAM16.SLICE\[0\].RAM8.WORD\[2\].W.BYTE\[3\].B.SEL0_B VGND VGND VPWR
+ VPWR SLICE_16\[0\].RAM16.BYTE\[3\].FLOATBUF0\[28\].Z sky130_fd_sc_hd__ebufn_2
XSLICE_16\[1\].RAM16.SLICE\[1\].RAM8.WORD\[4\].W.BYTE\[3\].B.BIT\[1\].genblk1.STORAGE
+ DIBUF\[25\].X SLICE_16\[1\].RAM16.SLICE\[1\].RAM8.WORD\[4\].W.BYTE\[3\].B.GCLK VGND
+ VGND VPWR VPWR SLICE_16\[1\].RAM16.SLICE\[1\].RAM8.WORD\[4\].W.BYTE\[3\].B.Q_WIRE\[1\]
+ sky130_fd_sc_hd__dlxtp_1
Xfill_47_3 VGND VPWR sky130_fd_sc_hd__tapvpwrvgnd_1
XSLICE_16\[1\].RAM16.SLICE\[1\].RAM8.WORD\[4\].W.BYTE\[3\].B.BIT\[1\].OBUF0 SLICE_16\[1\].RAM16.SLICE\[1\].RAM8.WORD\[4\].W.BYTE\[3\].B.Q_WIRE\[1\]
+ SLICE_16\[1\].RAM16.SLICE\[1\].RAM8.WORD\[4\].W.BYTE\[3\].B.SEL0_B VGND VGND VPWR
+ VPWR SLICE_16\[1\].RAM16.BYTE\[3\].FLOATBUF0\[25\].Z sky130_fd_sc_hd__ebufn_2
XSLICE_16\[1\].RAM16.SLICE\[1\].RAM8.WORD\[2\].W.BYTE\[1\].B.BIT\[0\].genblk1.STORAGE
+ DIBUF\[8\].X SLICE_16\[1\].RAM16.SLICE\[1\].RAM8.WORD\[2\].W.BYTE\[1\].B.GCLK VGND
+ VGND VPWR VPWR SLICE_16\[1\].RAM16.SLICE\[1\].RAM8.WORD\[2\].W.BYTE\[1\].B.Q_WIRE\[0\]
+ sky130_fd_sc_hd__dlxtp_1
XSLICE_16\[1\].RAM16.DIODE_A0\[2\].__cell__ A0BUF\[2\].X VGND VGND VPWR VPWR sky130_fd_sc_hd__diode_2
Xtap_23_19 VGND VPWR sky130_fd_sc_hd__tapvpwrvgnd_1
Xfill_2_3 VGND VPWR sky130_fd_sc_hd__tapvpwrvgnd_1
XSLICE_16\[1\].RAM16.SLICE\[1\].RAM8.WORD\[1\].W.BYTE\[0\].B.BIT\[6\].OBUF0 SLICE_16\[1\].RAM16.SLICE\[1\].RAM8.WORD\[1\].W.BYTE\[0\].B.Q_WIRE\[6\]
+ SLICE_16\[1\].RAM16.SLICE\[1\].RAM8.WORD\[1\].W.BYTE\[0\].B.SEL0_B VGND VGND VPWR
+ VPWR SLICE_16\[1\].RAM16.BYTE\[0\].FLOATBUF0\[6\].Z sky130_fd_sc_hd__ebufn_2
XSLICE_16\[0\].RAM16.Do0_REG.OUTREG_BYTE\[0\].Do_FF\[0\] SLICE_16\[0\].RAM16.Do0_REG.CLKBUF\[0\]
+ SLICE_16\[0\].RAM16.BYTE\[0\].FLOATBUF0\[0\].Z VGND VGND VPWR VPWR Do0MUX.A0\[0\]
+ sky130_fd_sc_hd__dfxtp_1
XSLICE_16\[0\].RAM16.BYTE\[2\].FLOATBUF0\[23\].__cell__ SLICE_16\[0\].RAM16.BYTE\[2\].FLOATBUF0\[16\].A
+ SLICE_16\[0\].RAM16.BYTE\[2\].FLOATBUF0\[16\].TE_B VGND VGND VPWR VPWR SLICE_16\[0\].RAM16.BYTE\[2\].FLOATBUF0\[23\].Z
+ sky130_fd_sc_hd__ebufn_2
XSLICE_16\[0\].RAM16.SLICE\[1\].RAM8.WORD\[6\].W.BYTE\[2\].B.BIT\[2\].OBUF0 SLICE_16\[0\].RAM16.SLICE\[1\].RAM8.WORD\[6\].W.BYTE\[2\].B.Q_WIRE\[2\]
+ SLICE_16\[0\].RAM16.SLICE\[1\].RAM8.WORD\[6\].W.BYTE\[2\].B.SEL0_B VGND VGND VPWR
+ VPWR SLICE_16\[0\].RAM16.BYTE\[2\].FLOATBUF0\[18\].Z sky130_fd_sc_hd__ebufn_2
XSLICE_16\[0\].RAM16.SLICE\[1\].RAM8.WORD\[0\].W.BYTE\[3\].B.SEL0INV SLICE_16\[0\].RAM16.SLICE\[1\].RAM8.WORD\[0\].W.BYTE\[0\].B.SEL0
+ VGND VGND VPWR VPWR SLICE_16\[0\].RAM16.SLICE\[1\].RAM8.WORD\[0\].W.BYTE\[3\].B.SEL0_B
+ sky130_fd_sc_hd__inv_1
XSLICE_16\[1\].RAM16.SLICE\[0\].RAM8.WORD\[7\].W.BYTE\[2\].B.BIT\[6\].genblk1.STORAGE
+ DIBUF\[22\].X SLICE_16\[1\].RAM16.SLICE\[0\].RAM8.WORD\[7\].W.BYTE\[2\].B.GCLK VGND
+ VGND VPWR VPWR SLICE_16\[1\].RAM16.SLICE\[0\].RAM8.WORD\[7\].W.BYTE\[2\].B.Q_WIRE\[6\]
+ sky130_fd_sc_hd__dlxtp_1
XSLICE_16\[1\].RAM16.SLICE\[0\].RAM8.WORD\[4\].W.BYTE\[2\].B.genblk1.CLKINV SLICE_16\[1\].RAM16.SLICE\[0\].RAM8.WORD\[4\].W.BYTE\[0\].B.CLK
+ VGND VGND VPWR VPWR SLICE_16\[1\].RAM16.SLICE\[0\].RAM8.WORD\[4\].W.BYTE\[2\].B.CLK_B
+ sky130_fd_sc_hd__inv_1
XSLICE_16\[1\].RAM16.SLICE\[0\].RAM8.WORD\[1\].W.BYTE\[3\].B.BIT\[7\].genblk1.STORAGE
+ DIBUF\[31\].X SLICE_16\[1\].RAM16.SLICE\[0\].RAM8.WORD\[1\].W.BYTE\[3\].B.GCLK VGND
+ VGND VPWR VPWR SLICE_16\[1\].RAM16.SLICE\[0\].RAM8.WORD\[1\].W.BYTE\[3\].B.Q_WIRE\[7\]
+ sky130_fd_sc_hd__dlxtp_1
XSLICE_16\[1\].RAM16.SLICE\[0\].RAM8.WORD\[5\].W.BYTE\[0\].B.BIT\[5\].genblk1.STORAGE
+ DIBUF\[5\].X SLICE_16\[1\].RAM16.SLICE\[0\].RAM8.WORD\[5\].W.BYTE\[0\].B.GCLK VGND
+ VGND VPWR VPWR SLICE_16\[1\].RAM16.SLICE\[0\].RAM8.WORD\[5\].W.BYTE\[0\].B.Q_WIRE\[5\]
+ sky130_fd_sc_hd__dlxtp_1
Xtap_12_6 VGND VPWR sky130_fd_sc_hd__tapvpwrvgnd_1
XSLICE_16\[0\].RAM16.SLICE\[0\].RAM8.WORD\[1\].W.BYTE\[1\].B.BIT\[1\].OBUF0 SLICE_16\[0\].RAM16.SLICE\[0\].RAM8.WORD\[1\].W.BYTE\[1\].B.Q_WIRE\[1\]
+ SLICE_16\[0\].RAM16.SLICE\[0\].RAM8.WORD\[1\].W.BYTE\[1\].B.SEL0_B VGND VGND VPWR
+ VPWR SLICE_16\[0\].RAM16.BYTE\[1\].FLOATBUF0\[9\].Z sky130_fd_sc_hd__ebufn_2
Xtap_5_5 VGND VPWR sky130_fd_sc_hd__tapvpwrvgnd_1
XSLICE_16\[0\].RAM16.SLICE\[1\].RAM8.WORD\[7\].W.BYTE\[0\].B.BIT\[6\].genblk1.STORAGE
+ DIBUF\[6\].X SLICE_16\[0\].RAM16.SLICE\[1\].RAM8.WORD\[7\].W.BYTE\[0\].B.GCLK VGND
+ VGND VPWR VPWR SLICE_16\[0\].RAM16.SLICE\[1\].RAM8.WORD\[7\].W.BYTE\[0\].B.Q_WIRE\[6\]
+ sky130_fd_sc_hd__dlxtp_1
Xtap_13_30 VGND VPWR sky130_fd_sc_hd__tapvpwrvgnd_1
XSLICE_16\[0\].RAM16.SLICE\[0\].RAM8.WORD\[2\].W.BYTE\[3\].B.BIT\[3\].genblk1.STORAGE
+ DIBUF\[27\].X SLICE_16\[0\].RAM16.SLICE\[0\].RAM8.WORD\[2\].W.BYTE\[3\].B.GCLK VGND
+ VGND VPWR VPWR SLICE_16\[0\].RAM16.SLICE\[0\].RAM8.WORD\[2\].W.BYTE\[3\].B.Q_WIRE\[3\]
+ sky130_fd_sc_hd__dlxtp_1
XSLICE_16\[0\].RAM16.SLICE\[1\].RAM8.WORD\[1\].W.BYTE\[1\].B.BIT\[7\].genblk1.STORAGE
+ DIBUF\[15\].X SLICE_16\[0\].RAM16.SLICE\[1\].RAM8.WORD\[1\].W.BYTE\[1\].B.GCLK VGND
+ VGND VPWR VPWR SLICE_16\[0\].RAM16.SLICE\[1\].RAM8.WORD\[1\].W.BYTE\[1\].B.Q_WIRE\[7\]
+ sky130_fd_sc_hd__dlxtp_1
XSLICE_16\[0\].RAM16.SLICE\[0\].RAM8.WORD\[0\].W.BYTE\[1\].B.BIT\[2\].genblk1.STORAGE
+ DIBUF\[10\].X SLICE_16\[0\].RAM16.SLICE\[0\].RAM8.WORD\[0\].W.BYTE\[1\].B.GCLK VGND
+ VGND VPWR VPWR SLICE_16\[0\].RAM16.SLICE\[0\].RAM8.WORD\[0\].W.BYTE\[1\].B.Q_WIRE\[2\]
+ sky130_fd_sc_hd__dlxtp_1
XSLICE_16\[0\].RAM16.SLICE\[0\].RAM8.WORD\[6\].W.BYTE\[0\].B.BIT\[1\].genblk1.STORAGE
+ DIBUF\[1\].X SLICE_16\[0\].RAM16.SLICE\[0\].RAM8.WORD\[6\].W.BYTE\[0\].B.GCLK VGND
+ VGND VPWR VPWR SLICE_16\[0\].RAM16.SLICE\[0\].RAM8.WORD\[6\].W.BYTE\[0\].B.Q_WIRE\[1\]
+ sky130_fd_sc_hd__dlxtp_1
XSLICE_16\[0\].RAM16.SLICE\[1\].RAM8.WORD\[1\].W.BYTE\[0\].B.CGAND SLICE_16\[0\].RAM16.SLICE\[1\].RAM8.WORD\[1\].W.BYTE\[0\].B.SEL0
+ SLICE_16\[0\].RAM16.SLICE\[1\].RAM8.WE0_buf\[0\] VGND VGND VPWR VPWR SLICE_16\[0\].RAM16.SLICE\[1\].RAM8.WORD\[1\].W.BYTE\[0\].B.WE0_WIRE
+ sky130_fd_sc_hd__and2_1
Xfill_19_7 VGND VGND VPWR VPWR sky130_fd_sc_hd__decap_12
Xfill_42_91 VGND VGND VPWR VPWR sky130_fd_sc_hd__decap_12
Xfill_42_80 VGND VGND VPWR VPWR sky130_fd_sc_hd__decap_12
XSLICE_16\[1\].RAM16.SLICE\[1\].RAM8.WORD\[4\].W.BYTE\[1\].B.BIT\[6\].OBUF0 SLICE_16\[1\].RAM16.SLICE\[1\].RAM8.WORD\[4\].W.BYTE\[1\].B.Q_WIRE\[6\]
+ SLICE_16\[1\].RAM16.SLICE\[1\].RAM8.WORD\[4\].W.BYTE\[1\].B.SEL0_B VGND VGND VPWR
+ VPWR SLICE_16\[1\].RAM16.BYTE\[1\].FLOATBUF0\[14\].Z sky130_fd_sc_hd__ebufn_2
XSLICE_16\[1\].RAM16.SLICE\[0\].RAM8.WORD\[7\].W.BYTE\[3\].B.genblk1.CLKINV SLICE_16\[1\].RAM16.SLICE\[0\].RAM8.WORD\[7\].W.BYTE\[0\].B.CLK
+ VGND VGND VPWR VPWR SLICE_16\[1\].RAM16.SLICE\[0\].RAM8.WORD\[7\].W.BYTE\[3\].B.CLK_B
+ sky130_fd_sc_hd__inv_1
XSLICE_16\[1\].RAM16.SLICE\[0\].RAM8.WORD\[2\].W.BYTE\[3\].B.BIT\[0\].OBUF0 SLICE_16\[1\].RAM16.SLICE\[0\].RAM8.WORD\[2\].W.BYTE\[3\].B.Q_WIRE\[0\]
+ SLICE_16\[1\].RAM16.SLICE\[0\].RAM8.WORD\[2\].W.BYTE\[3\].B.SEL0_B VGND VGND VPWR
+ VPWR SLICE_16\[1\].RAM16.BYTE\[3\].FLOATBUF0\[24\].Z sky130_fd_sc_hd__ebufn_2
Xfill_45_0 VGND VPWR sky130_fd_sc_hd__tapvpwrvgnd_1
Xtap_34_29 VGND VPWR sky130_fd_sc_hd__tapvpwrvgnd_1
Xtap_34_18 VGND VPWR sky130_fd_sc_hd__tapvpwrvgnd_1
Xtap_18_19 VGND VPWR sky130_fd_sc_hd__tapvpwrvgnd_1
XSLICE_16\[0\].RAM16.SLICE\[1\].RAM8.WORD\[6\].W.BYTE\[0\].B.BIT\[7\].OBUF0 SLICE_16\[0\].RAM16.SLICE\[1\].RAM8.WORD\[6\].W.BYTE\[0\].B.Q_WIRE\[7\]
+ SLICE_16\[0\].RAM16.SLICE\[1\].RAM8.WORD\[6\].W.BYTE\[0\].B.SEL0_B VGND VGND VPWR
+ VPWR SLICE_16\[0\].RAM16.BYTE\[0\].FLOATBUF0\[7\].Z sky130_fd_sc_hd__ebufn_2
XSLICE_16\[0\].RAM16.SLICE\[0\].RAM8.WORD\[4\].W.BYTE\[2\].B.BIT\[1\].OBUF0 SLICE_16\[0\].RAM16.SLICE\[0\].RAM8.WORD\[4\].W.BYTE\[2\].B.Q_WIRE\[1\]
+ SLICE_16\[0\].RAM16.SLICE\[0\].RAM8.WORD\[4\].W.BYTE\[2\].B.SEL0_B VGND VGND VPWR
+ VPWR SLICE_16\[0\].RAM16.BYTE\[2\].FLOATBUF0\[17\].Z sky130_fd_sc_hd__ebufn_2
Xfill_0_0 VGND VPWR sky130_fd_sc_hd__tapvpwrvgnd_1
XSLICE_16\[1\].RAM16.SLICE\[1\].RAM8.WORD\[5\].W.BYTE\[2\].B.BIT\[0\].genblk1.STORAGE
+ DIBUF\[16\].X SLICE_16\[1\].RAM16.SLICE\[1\].RAM8.WORD\[5\].W.BYTE\[2\].B.GCLK VGND
+ VGND VPWR VPWR SLICE_16\[1\].RAM16.SLICE\[1\].RAM8.WORD\[5\].W.BYTE\[2\].B.Q_WIRE\[0\]
+ sky130_fd_sc_hd__dlxtp_1
Xfill_22_39 VGND VPWR sky130_fd_sc_hd__tapvpwrvgnd_1
Xfill_22_28 VGND VGND VPWR VPWR sky130_fd_sc_hd__decap_12
Xfill_22_17 VGND VGND VPWR VPWR sky130_fd_sc_hd__decap_12
Xtap_5_11 VGND VPWR sky130_fd_sc_hd__tapvpwrvgnd_1
Xtap_5_22 VGND VPWR sky130_fd_sc_hd__tapvpwrvgnd_1
Xtap_5_33 VGND VPWR sky130_fd_sc_hd__tapvpwrvgnd_1
Xfill_47_14 VGND VGND VPWR VPWR sky130_fd_sc_hd__decap_12
XSLICE_16\[0\].RAM16.SLICE\[0\].RAM8.WORD\[5\].W.BYTE\[3\].B.genblk1.CG SLICE_16\[0\].RAM16.SLICE\[0\].RAM8.WORD\[5\].W.BYTE\[3\].B.CLK_B
+ SLICE_16\[0\].RAM16.SLICE\[0\].RAM8.WORD\[5\].W.BYTE\[3\].B.WE0_WIRE VGND VGND VPWR
+ VPWR SLICE_16\[0\].RAM16.SLICE\[0\].RAM8.WORD\[5\].W.BYTE\[3\].B.GCLK sky130_fd_sc_hd__dlclkp_1
Xtap_10_3 VGND VPWR sky130_fd_sc_hd__tapvpwrvgnd_1
Xfill_47_58 VGND VGND VPWR VPWR sky130_fd_sc_hd__decap_12
Xfill_47_47 VGND VGND VPWR VPWR sky130_fd_sc_hd__decap_12
Xfill_47_36 VGND VPWR sky130_fd_sc_hd__tapvpwrvgnd_1
Xfill_47_25 VGND VGND VPWR VPWR sky130_fd_sc_hd__decap_12
XSLICE_16\[1\].RAM16.SLICE\[1\].RAM8.WORD\[7\].W.BYTE\[2\].B.BIT\[6\].OBUF0 SLICE_16\[1\].RAM16.SLICE\[1\].RAM8.WORD\[7\].W.BYTE\[2\].B.Q_WIRE\[6\]
+ SLICE_16\[1\].RAM16.SLICE\[1\].RAM8.WORD\[7\].W.BYTE\[2\].B.SEL0_B VGND VGND VPWR
+ VPWR SLICE_16\[1\].RAM16.BYTE\[2\].FLOATBUF0\[22\].Z sky130_fd_sc_hd__ebufn_2
XSLICE_16\[1\].RAM16.SLICE\[1\].RAM8.WORD\[6\].W.BYTE\[0\].B.SEL0INV SLICE_16\[1\].RAM16.SLICE\[1\].RAM8.WORD\[6\].W.BYTE\[0\].B.SEL0
+ VGND VGND VPWR VPWR SLICE_16\[1\].RAM16.SLICE\[1\].RAM8.WORD\[6\].W.BYTE\[0\].B.SEL0_B
+ sky130_fd_sc_hd__inv_1
Xtap_3_2 VGND VPWR sky130_fd_sc_hd__tapvpwrvgnd_1
XSLICE_16\[1\].RAM16.SLICE\[0\].RAM8.WORD\[2\].W.BYTE\[2\].B.BIT\[6\].genblk1.STORAGE
+ DIBUF\[22\].X SLICE_16\[1\].RAM16.SLICE\[0\].RAM8.WORD\[2\].W.BYTE\[2\].B.GCLK VGND
+ VGND VPWR VPWR SLICE_16\[1\].RAM16.SLICE\[0\].RAM8.WORD\[2\].W.BYTE\[2\].B.Q_WIRE\[6\]
+ sky130_fd_sc_hd__dlxtp_1
XSLICE_16\[1\].RAM16.SLICE\[0\].RAM8.WORD\[2\].W.BYTE\[1\].B.BIT\[5\].OBUF0 SLICE_16\[1\].RAM16.SLICE\[0\].RAM8.WORD\[2\].W.BYTE\[1\].B.Q_WIRE\[5\]
+ SLICE_16\[1\].RAM16.SLICE\[0\].RAM8.WORD\[2\].W.BYTE\[1\].B.SEL0_B VGND VGND VPWR
+ VPWR SLICE_16\[1\].RAM16.BYTE\[1\].FLOATBUF0\[13\].Z sky130_fd_sc_hd__ebufn_2
XSLICE_16\[1\].RAM16.SLICE\[0\].RAM8.WORD\[0\].W.BYTE\[0\].B.BIT\[5\].genblk1.STORAGE
+ DIBUF\[5\].X SLICE_16\[1\].RAM16.SLICE\[0\].RAM8.WORD\[0\].W.BYTE\[0\].B.GCLK VGND
+ VGND VPWR VPWR SLICE_16\[1\].RAM16.SLICE\[0\].RAM8.WORD\[0\].W.BYTE\[0\].B.Q_WIRE\[5\]
+ sky130_fd_sc_hd__dlxtp_1
XSLICE_16\[0\].RAM16.SLICE\[1\].RAM8.WORD\[4\].W.BYTE\[2\].B.BIT\[7\].genblk1.STORAGE
+ DIBUF\[23\].X SLICE_16\[0\].RAM16.SLICE\[1\].RAM8.WORD\[4\].W.BYTE\[2\].B.GCLK VGND
+ VGND VPWR VPWR SLICE_16\[0\].RAM16.SLICE\[1\].RAM8.WORD\[4\].W.BYTE\[2\].B.Q_WIRE\[7\]
+ sky130_fd_sc_hd__dlxtp_1
XSLICE_16\[0\].RAM16.SLICE\[0\].RAM8.WORD\[7\].W.BYTE\[3\].B.BIT\[1\].OBUF0 SLICE_16\[0\].RAM16.SLICE\[0\].RAM8.WORD\[7\].W.BYTE\[3\].B.Q_WIRE\[1\]
+ SLICE_16\[0\].RAM16.SLICE\[0\].RAM8.WORD\[7\].W.BYTE\[3\].B.SEL0_B VGND VGND VPWR
+ VPWR SLICE_16\[0\].RAM16.BYTE\[3\].FLOATBUF0\[25\].Z sky130_fd_sc_hd__ebufn_2
Xfill_17_4 VGND VGND VPWR VPWR sky130_fd_sc_hd__decap_12
XSLICE_16\[0\].RAM16.SLICE\[0\].RAM8.WORD\[3\].W.BYTE\[2\].B.BIT\[2\].genblk1.STORAGE
+ DIBUF\[18\].X SLICE_16\[0\].RAM16.SLICE\[0\].RAM8.WORD\[3\].W.BYTE\[2\].B.GCLK VGND
+ VGND VPWR VPWR SLICE_16\[0\].RAM16.SLICE\[0\].RAM8.WORD\[3\].W.BYTE\[2\].B.Q_WIRE\[2\]
+ sky130_fd_sc_hd__dlxtp_1
XSLICE_16\[0\].RAM16.SLICE\[1\].RAM8.WORD\[2\].W.BYTE\[0\].B.BIT\[6\].genblk1.STORAGE
+ DIBUF\[6\].X SLICE_16\[0\].RAM16.SLICE\[1\].RAM8.WORD\[2\].W.BYTE\[0\].B.GCLK VGND
+ VGND VPWR VPWR SLICE_16\[0\].RAM16.SLICE\[1\].RAM8.WORD\[2\].W.BYTE\[0\].B.Q_WIRE\[6\]
+ sky130_fd_sc_hd__dlxtp_1
XSLICE_16\[1\].RAM16.SLICE\[0\].RAM8.WORD\[2\].W.BYTE\[2\].B.genblk1.CG SLICE_16\[1\].RAM16.SLICE\[0\].RAM8.WORD\[2\].W.BYTE\[2\].B.CLK_B
+ SLICE_16\[1\].RAM16.SLICE\[0\].RAM8.WORD\[2\].W.BYTE\[2\].B.WE0_WIRE VGND VGND VPWR
+ VPWR SLICE_16\[1\].RAM16.SLICE\[0\].RAM8.WORD\[2\].W.BYTE\[2\].B.GCLK sky130_fd_sc_hd__dlclkp_1
XSLICE_16\[0\].RAM16.SLICE\[0\].RAM8.WORD\[1\].W.BYTE\[0\].B.BIT\[1\].genblk1.STORAGE
+ DIBUF\[1\].X SLICE_16\[0\].RAM16.SLICE\[0\].RAM8.WORD\[1\].W.BYTE\[0\].B.GCLK VGND
+ VGND VPWR VPWR SLICE_16\[0\].RAM16.SLICE\[0\].RAM8.WORD\[1\].W.BYTE\[0\].B.Q_WIRE\[1\]
+ sky130_fd_sc_hd__dlxtp_1
XSLICE_16\[0\].RAM16.SLICE\[0\].RAM8.WORD\[4\].W.BYTE\[0\].B.BIT\[6\].OBUF0 SLICE_16\[0\].RAM16.SLICE\[0\].RAM8.WORD\[4\].W.BYTE\[0\].B.Q_WIRE\[6\]
+ SLICE_16\[0\].RAM16.SLICE\[0\].RAM8.WORD\[4\].W.BYTE\[0\].B.SEL0_B VGND VGND VPWR
+ VPWR SLICE_16\[0\].RAM16.BYTE\[0\].FLOATBUF0\[6\].Z sky130_fd_sc_hd__ebufn_2
XSLICE_16\[1\].RAM16.SLICE\[1\].RAM8.WORD\[6\].W.BYTE\[0\].B.BIT\[3\].OBUF0 SLICE_16\[1\].RAM16.SLICE\[1\].RAM8.WORD\[6\].W.BYTE\[0\].B.Q_WIRE\[3\]
+ SLICE_16\[1\].RAM16.SLICE\[1\].RAM8.WORD\[6\].W.BYTE\[0\].B.SEL0_B VGND VGND VPWR
+ VPWR SLICE_16\[1\].RAM16.BYTE\[0\].FLOATBUF0\[3\].Z sky130_fd_sc_hd__ebufn_2
Xtap_29_29 VGND VPWR sky130_fd_sc_hd__tapvpwrvgnd_1
Xtap_29_18 VGND VPWR sky130_fd_sc_hd__tapvpwrvgnd_1
XSLICE_16\[0\].RAM16.SLICE\[1\].RAM8.WORD\[4\].W.BYTE\[1\].B.SEL0INV SLICE_16\[0\].RAM16.SLICE\[1\].RAM8.WORD\[4\].W.BYTE\[0\].B.SEL0
+ VGND VGND VPWR VPWR SLICE_16\[0\].RAM16.SLICE\[1\].RAM8.WORD\[4\].W.BYTE\[1\].B.SEL0_B
+ sky130_fd_sc_hd__inv_1
XSLICE_16\[1\].RAM16.SLICE\[1\].RAM8.WORD\[1\].W.BYTE\[2\].B.genblk1.CLKINV SLICE_16\[1\].RAM16.SLICE\[1\].RAM8.WORD\[1\].W.BYTE\[0\].B.CLK
+ VGND VGND VPWR VPWR SLICE_16\[1\].RAM16.SLICE\[1\].RAM8.WORD\[1\].W.BYTE\[2\].B.CLK_B
+ sky130_fd_sc_hd__inv_1
Xfill_17_39 VGND VPWR sky130_fd_sc_hd__tapvpwrvgnd_1
Xfill_17_28 VGND VGND VPWR VPWR sky130_fd_sc_hd__decap_12
Xfill_17_17 VGND VGND VPWR VPWR sky130_fd_sc_hd__decap_12
Xtap_10_20 VGND VPWR sky130_fd_sc_hd__tapvpwrvgnd_1
Xtap_10_31 VGND VPWR sky130_fd_sc_hd__tapvpwrvgnd_1
XSLICE_16\[1\].RAM16.SLICE\[0\].RAM8.WORD\[5\].W.BYTE\[2\].B.BIT\[5\].OBUF0 SLICE_16\[1\].RAM16.SLICE\[0\].RAM8.WORD\[5\].W.BYTE\[2\].B.Q_WIRE\[5\]
+ SLICE_16\[1\].RAM16.SLICE\[0\].RAM8.WORD\[5\].W.BYTE\[2\].B.SEL0_B VGND VGND VPWR
+ VPWR SLICE_16\[1\].RAM16.BYTE\[2\].FLOATBUF0\[21\].Z sky130_fd_sc_hd__ebufn_2
XSLICE_16\[0\].RAM16.SLICE\[0\].RAM8.WORD\[0\].W.BYTE\[0\].B.SEL0INV SLICE_16\[0\].RAM16.SLICE\[0\].RAM8.WORD\[0\].W.BYTE\[0\].B.SEL0
+ VGND VGND VPWR VPWR SLICE_16\[0\].RAM16.SLICE\[0\].RAM8.WORD\[0\].W.BYTE\[0\].B.SEL0_B
+ sky130_fd_sc_hd__inv_1
XSLICE_16\[1\].RAM16.SLICE\[1\].RAM8.WORD\[0\].W.BYTE\[2\].B.BIT\[0\].genblk1.STORAGE
+ DIBUF\[16\].X SLICE_16\[1\].RAM16.SLICE\[1\].RAM8.WORD\[0\].W.BYTE\[2\].B.GCLK VGND
+ VGND VPWR VPWR SLICE_16\[1\].RAM16.SLICE\[1\].RAM8.WORD\[0\].W.BYTE\[2\].B.Q_WIRE\[0\]
+ sky130_fd_sc_hd__dlxtp_1
XSLICE_16\[0\].RAM16.SLICE\[0\].RAM8.WORD\[7\].W.BYTE\[1\].B.BIT\[6\].OBUF0 SLICE_16\[0\].RAM16.SLICE\[0\].RAM8.WORD\[7\].W.BYTE\[1\].B.Q_WIRE\[6\]
+ SLICE_16\[0\].RAM16.SLICE\[0\].RAM8.WORD\[7\].W.BYTE\[1\].B.SEL0_B VGND VGND VPWR
+ VPWR SLICE_16\[0\].RAM16.BYTE\[1\].FLOATBUF0\[14\].Z sky130_fd_sc_hd__ebufn_2
XSLICE_16\[0\].RAM16.Do0_REG.Do_CLKBUF\[0\] SLICE_16\[0\].RAM16.Do0_REG.CLK_buf VGND
+ VGND VPWR VPWR SLICE_16\[0\].RAM16.Do0_REG.CLKBUF\[0\] sky130_fd_sc_hd__clkbuf_4
XSLICE_16\[1\].RAM16.SLICE\[1\].RAM8.WORD\[4\].W.BYTE\[3\].B.genblk1.CLKINV SLICE_16\[1\].RAM16.SLICE\[1\].RAM8.WORD\[4\].W.BYTE\[0\].B.CLK
+ VGND VGND VPWR VPWR SLICE_16\[1\].RAM16.SLICE\[1\].RAM8.WORD\[4\].W.BYTE\[3\].B.CLK_B
+ sky130_fd_sc_hd__inv_1
XSLICE_16\[1\].RAM16.SLICE\[1\].RAM8.WEBUF\[0\].__cell__ SLICE_16\[1\].RAM16.SLICE\[0\].RAM8.WE0\[0\]
+ VGND VGND VPWR VPWR SLICE_16\[1\].RAM16.SLICE\[1\].RAM8.WE0_buf\[0\] sky130_fd_sc_hd__clkbuf_2
Xfill_22_2 VGND VGND VPWR VPWR sky130_fd_sc_hd__decap_12
XSLICE_16\[1\].RAM16.SLICE\[1\].RAM8.WORD\[5\].W.CLKBUF SLICE_16\[1\].RAM16.SLICE\[1\].RAM8.CLKBUF.X
+ VGND VGND VPWR VPWR SLICE_16\[1\].RAM16.SLICE\[1\].RAM8.WORD\[5\].W.BYTE\[0\].B.CLK
+ sky130_fd_sc_hd__clkbuf_4
XSLICE_16\[1\].RAM16.SLICE\[1\].RAM8.WORD\[3\].W.BYTE\[3\].B.CGAND SLICE_16\[1\].RAM16.SLICE\[1\].RAM8.WORD\[3\].W.BYTE\[0\].B.SEL0
+ SLICE_16\[1\].RAM16.SLICE\[1\].RAM8.WE0_buf\[3\] VGND VGND VPWR VPWR SLICE_16\[1\].RAM16.SLICE\[1\].RAM8.WORD\[3\].W.BYTE\[3\].B.WE0_WIRE
+ sky130_fd_sc_hd__and2_1
Xtap_31_19 VGND VPWR sky130_fd_sc_hd__tapvpwrvgnd_1
XSLICE_16\[1\].RAM16.SLICE\[0\].RAM8.WORD\[5\].W.BYTE\[3\].B.BIT\[6\].genblk1.STORAGE
+ DIBUF\[30\].X SLICE_16\[1\].RAM16.SLICE\[0\].RAM8.WORD\[5\].W.BYTE\[3\].B.GCLK VGND
+ VGND VPWR VPWR SLICE_16\[1\].RAM16.SLICE\[0\].RAM8.WORD\[5\].W.BYTE\[3\].B.Q_WIRE\[6\]
+ sky130_fd_sc_hd__dlxtp_1
XSLICE_16\[1\].RAM16.SLICE\[0\].RAM8.WORD\[3\].W.BYTE\[1\].B.BIT\[5\].genblk1.STORAGE
+ DIBUF\[13\].X SLICE_16\[1\].RAM16.SLICE\[0\].RAM8.WORD\[3\].W.BYTE\[1\].B.GCLK VGND
+ VGND VPWR VPWR SLICE_16\[1\].RAM16.SLICE\[0\].RAM8.WORD\[3\].W.BYTE\[1\].B.Q_WIRE\[5\]
+ sky130_fd_sc_hd__dlxtp_1
XSLICE_16\[1\].RAM16.SLICE\[0\].RAM8.WORD\[4\].W.BYTE\[0\].B.BIT\[2\].OBUF0 SLICE_16\[1\].RAM16.SLICE\[0\].RAM8.WORD\[4\].W.BYTE\[0\].B.Q_WIRE\[2\]
+ SLICE_16\[1\].RAM16.SLICE\[0\].RAM8.WORD\[4\].W.BYTE\[0\].B.SEL0_B VGND VGND VPWR
+ VPWR SLICE_16\[1\].RAM16.BYTE\[0\].FLOATBUF0\[2\].Z sky130_fd_sc_hd__ebufn_2
XSLICE_16\[0\].RAM16.SLICE\[1\].RAM8.WORD\[7\].W.BYTE\[3\].B.BIT\[7\].genblk1.STORAGE
+ DIBUF\[31\].X SLICE_16\[0\].RAM16.SLICE\[1\].RAM8.WORD\[7\].W.BYTE\[3\].B.GCLK VGND
+ VGND VPWR VPWR SLICE_16\[0\].RAM16.SLICE\[1\].RAM8.WORD\[7\].W.BYTE\[3\].B.Q_WIRE\[7\]
+ sky130_fd_sc_hd__dlxtp_1
Xfill_15_1 VGND VGND VPWR VPWR sky130_fd_sc_hd__decap_3
XSLICE_16\[0\].RAM16.SLICE\[1\].RAM8.WORD\[1\].W.BYTE\[2\].B.BIT\[1\].OBUF0 SLICE_16\[0\].RAM16.SLICE\[1\].RAM8.WORD\[1\].W.BYTE\[2\].B.Q_WIRE\[1\]
+ SLICE_16\[0\].RAM16.SLICE\[1\].RAM8.WORD\[1\].W.BYTE\[2\].B.SEL0_B VGND VGND VPWR
+ VPWR SLICE_16\[0\].RAM16.BYTE\[2\].FLOATBUF0\[17\].Z sky130_fd_sc_hd__ebufn_2
Xtap_37_8 VGND VPWR sky130_fd_sc_hd__tapvpwrvgnd_1
XSLICE_16\[0\].RAM16.SLICE\[1\].RAM8.WORD\[5\].W.BYTE\[1\].B.BIT\[6\].genblk1.STORAGE
+ DIBUF\[14\].X SLICE_16\[0\].RAM16.SLICE\[1\].RAM8.WORD\[5\].W.BYTE\[1\].B.GCLK VGND
+ VGND VPWR VPWR SLICE_16\[0\].RAM16.SLICE\[1\].RAM8.WORD\[5\].W.BYTE\[1\].B.Q_WIRE\[6\]
+ sky130_fd_sc_hd__dlxtp_1
Xtap_2_34 VGND VPWR sky130_fd_sc_hd__tapvpwrvgnd_1
Xtap_2_23 VGND VPWR sky130_fd_sc_hd__tapvpwrvgnd_1
Xtap_2_12 VGND VPWR sky130_fd_sc_hd__tapvpwrvgnd_1
XSLICE_16\[0\].RAM16.SLICE\[0\].RAM8.WORD\[6\].W.BYTE\[3\].B.BIT\[2\].genblk1.STORAGE
+ DIBUF\[26\].X SLICE_16\[0\].RAM16.SLICE\[0\].RAM8.WORD\[6\].W.BYTE\[3\].B.GCLK VGND
+ VGND VPWR VPWR SLICE_16\[0\].RAM16.SLICE\[0\].RAM8.WORD\[6\].W.BYTE\[3\].B.Q_WIRE\[2\]
+ sky130_fd_sc_hd__dlxtp_1
Xfill_44_59 VGND VGND VPWR VPWR sky130_fd_sc_hd__decap_12
Xfill_44_48 VGND VPWR sky130_fd_sc_hd__tapvpwrvgnd_1
Xfill_44_37 VGND VGND VPWR VPWR sky130_fd_sc_hd__decap_12
Xfill_44_26 VGND VGND VPWR VPWR sky130_fd_sc_hd__decap_12
Xfill_44_15 VGND VPWR sky130_fd_sc_hd__tapvpwrvgnd_1
XSLICE_16\[0\].RAM16.SLICE\[0\].RAM8.WORD\[1\].W.BYTE\[1\].B.genblk1.CLKINV SLICE_16\[0\].RAM16.SLICE\[0\].RAM8.WORD\[1\].W.BYTE\[0\].B.CLK
+ VGND VGND VPWR VPWR SLICE_16\[0\].RAM16.SLICE\[0\].RAM8.WORD\[1\].W.BYTE\[1\].B.CLK_B
+ sky130_fd_sc_hd__inv_1
XSLICE_16\[0\].RAM16.SLICE\[0\].RAM8.WORD\[4\].W.BYTE\[1\].B.BIT\[1\].genblk1.STORAGE
+ DIBUF\[9\].X SLICE_16\[0\].RAM16.SLICE\[0\].RAM8.WORD\[4\].W.BYTE\[1\].B.GCLK VGND
+ VGND VPWR VPWR SLICE_16\[0\].RAM16.SLICE\[0\].RAM8.WORD\[4\].W.BYTE\[1\].B.Q_WIRE\[1\]
+ sky130_fd_sc_hd__dlxtp_1
XSLICE_16\[1\].RAM16.Do0_REG.OUTREG_BYTE\[3\].Do_FF\[3\] SLICE_16\[1\].RAM16.Do0_REG.CLKBUF\[3\]
+ SLICE_16\[1\].RAM16.BYTE\[3\].FLOATBUF0\[27\].Z VGND VGND VPWR VPWR Do0MUX.A1\[27\]
+ sky130_fd_sc_hd__dfxtp_1
XSLICE_16\[1\].RAM16.SLICE\[1\].RAM8.WORD\[7\].W.BYTE\[2\].B.genblk1.CG SLICE_16\[1\].RAM16.SLICE\[1\].RAM8.WORD\[7\].W.BYTE\[2\].B.CLK_B
+ SLICE_16\[1\].RAM16.SLICE\[1\].RAM8.WORD\[7\].W.BYTE\[2\].B.WE0_WIRE VGND VGND VPWR
+ VPWR SLICE_16\[1\].RAM16.SLICE\[1\].RAM8.WORD\[7\].W.BYTE\[2\].B.GCLK sky130_fd_sc_hd__dlclkp_1
XSLICE_16\[1\].RAM16.SLICE\[0\].RAM8.WORD\[7\].W.BYTE\[1\].B.BIT\[2\].OBUF0 SLICE_16\[1\].RAM16.SLICE\[0\].RAM8.WORD\[7\].W.BYTE\[1\].B.Q_WIRE\[2\]
+ SLICE_16\[1\].RAM16.SLICE\[0\].RAM8.WORD\[7\].W.BYTE\[1\].B.SEL0_B VGND VGND VPWR
+ VPWR SLICE_16\[1\].RAM16.BYTE\[1\].FLOATBUF0\[10\].Z sky130_fd_sc_hd__ebufn_2
XSLICE_16\[0\].RAM16.SLICE\[1\].RAM8.WORD\[4\].W.BYTE\[3\].B.BIT\[1\].OBUF0 SLICE_16\[0\].RAM16.SLICE\[1\].RAM8.WORD\[4\].W.BYTE\[3\].B.Q_WIRE\[1\]
+ SLICE_16\[0\].RAM16.SLICE\[1\].RAM8.WORD\[4\].W.BYTE\[3\].B.SEL0_B VGND VGND VPWR
+ VPWR SLICE_16\[0\].RAM16.BYTE\[3\].FLOATBUF0\[25\].Z sky130_fd_sc_hd__ebufn_2
XSLICE_16\[1\].RAM16.SLICE\[1\].RAM8.WORD\[3\].W.BYTE\[3\].B.BIT\[0\].genblk1.STORAGE
+ DIBUF\[24\].X SLICE_16\[1\].RAM16.SLICE\[1\].RAM8.WORD\[3\].W.BYTE\[3\].B.GCLK VGND
+ VGND VPWR VPWR SLICE_16\[1\].RAM16.SLICE\[1\].RAM8.WORD\[3\].W.BYTE\[3\].B.Q_WIRE\[0\]
+ sky130_fd_sc_hd__dlxtp_1
XSLICE_16\[1\].RAM16.SLICE\[0\].RAM8.WORD\[7\].W.BYTE\[0\].B.CGAND SLICE_16\[1\].RAM16.SLICE\[0\].RAM8.WORD\[7\].W.BYTE\[0\].B.SEL0
+ SLICE_16\[1\].RAM16.SLICE\[0\].RAM8.WE0_buf\[0\] VGND VGND VPWR VPWR SLICE_16\[1\].RAM16.SLICE\[0\].RAM8.WORD\[7\].W.BYTE\[0\].B.WE0_WIRE
+ sky130_fd_sc_hd__and2_1
Xtap_26_19 VGND VPWR sky130_fd_sc_hd__tapvpwrvgnd_1
XSLICE_16\[0\].RAM16.SLICE\[1\].RAM8.WORD\[1\].W.BYTE\[0\].B.BIT\[6\].OBUF0 SLICE_16\[0\].RAM16.SLICE\[1\].RAM8.WORD\[1\].W.BYTE\[0\].B.Q_WIRE\[6\]
+ SLICE_16\[0\].RAM16.SLICE\[1\].RAM8.WORD\[1\].W.BYTE\[0\].B.SEL0_B VGND VGND VPWR
+ VPWR SLICE_16\[0\].RAM16.BYTE\[0\].FLOATBUF0\[6\].Z sky130_fd_sc_hd__ebufn_2
XSLICE_16\[1\].RAM16.BYTE\[0\].FLOATBUF0\[7\].__cell__ SLICE_16\[1\].RAM16.BYTE\[0\].FLOATBUF0\[0\].A
+ SLICE_16\[1\].RAM16.BYTE\[0\].FLOATBUF0\[0\].TE_B VGND VGND VPWR VPWR SLICE_16\[1\].RAM16.BYTE\[0\].FLOATBUF0\[7\].Z
+ sky130_fd_sc_hd__ebufn_2
XSLICE_16\[0\].RAM16.SLICE\[0\].RAM8.WORD\[4\].W.BYTE\[2\].B.genblk1.CLKINV SLICE_16\[0\].RAM16.SLICE\[0\].RAM8.WORD\[4\].W.BYTE\[0\].B.CLK
+ VGND VGND VPWR VPWR SLICE_16\[0\].RAM16.SLICE\[0\].RAM8.WORD\[4\].W.BYTE\[2\].B.CLK_B
+ sky130_fd_sc_hd__inv_1
XSLICE_16\[1\].RAM16.SLICE\[1\].RAM8.WORD\[2\].W.BYTE\[1\].B.SEL0INV SLICE_16\[1\].RAM16.SLICE\[1\].RAM8.WORD\[2\].W.BYTE\[0\].B.SEL0
+ VGND VGND VPWR VPWR SLICE_16\[1\].RAM16.SLICE\[1\].RAM8.WORD\[2\].W.BYTE\[1\].B.SEL0_B
+ sky130_fd_sc_hd__inv_1
XSLICE_16\[1\].RAM16.SLICE\[0\].RAM8.WEBUF\[2\].__cell__ SLICE_16\[1\].RAM16.SLICE\[0\].RAM8.WE0\[2\]
+ VGND VGND VPWR VPWR SLICE_16\[1\].RAM16.SLICE\[0\].RAM8.WE0_buf\[2\] sky130_fd_sc_hd__clkbuf_2
Xfill_39_15 VGND VPWR sky130_fd_sc_hd__tapvpwrvgnd_1
Xtap_35_5 VGND VPWR sky130_fd_sc_hd__tapvpwrvgnd_1
Xtap_28_4 VGND VPWR sky130_fd_sc_hd__tapvpwrvgnd_1
Xfill_39_59 VGND VGND VPWR VPWR sky130_fd_sc_hd__decap_12
Xfill_39_48 VGND VPWR sky130_fd_sc_hd__tapvpwrvgnd_1
Xfill_39_37 VGND VGND VPWR VPWR sky130_fd_sc_hd__decap_12
Xfill_39_26 VGND VGND VPWR VPWR sky130_fd_sc_hd__decap_12
XSLICE_16\[1\].RAM16.Do0_REG.OUTREG_BYTE\[0\].DIODE\[6\] SLICE_16\[1\].RAM16.BYTE\[0\].FLOATBUF0\[6\].Z
+ VGND VGND VPWR VPWR sky130_fd_sc_hd__diode_2
XSLICE_16\[1\].RAM16.SLICE\[0\].RAM8.WORD\[6\].W.BYTE\[2\].B.BIT\[5\].genblk1.STORAGE
+ DIBUF\[21\].X SLICE_16\[1\].RAM16.SLICE\[0\].RAM8.WORD\[6\].W.BYTE\[2\].B.GCLK VGND
+ VGND VPWR VPWR SLICE_16\[1\].RAM16.SLICE\[0\].RAM8.WORD\[6\].W.BYTE\[2\].B.Q_WIRE\[5\]
+ sky130_fd_sc_hd__dlxtp_1
XSLICE_16\[1\].RAM16.SLICE\[0\].RAM8.WORD\[0\].W.BYTE\[3\].B.BIT\[6\].genblk1.STORAGE
+ DIBUF\[30\].X SLICE_16\[1\].RAM16.SLICE\[0\].RAM8.WORD\[0\].W.BYTE\[3\].B.GCLK VGND
+ VGND VPWR VPWR SLICE_16\[1\].RAM16.SLICE\[0\].RAM8.WORD\[0\].W.BYTE\[3\].B.Q_WIRE\[6\]
+ sky130_fd_sc_hd__dlxtp_1
Xtap_16_30 VGND VPWR sky130_fd_sc_hd__tapvpwrvgnd_1
XSLICE_16\[1\].RAM16.SLICE\[1\].RAM8.WORD\[2\].W.BYTE\[2\].B.BIT\[5\].OBUF0 SLICE_16\[1\].RAM16.SLICE\[1\].RAM8.WORD\[2\].W.BYTE\[2\].B.Q_WIRE\[5\]
+ SLICE_16\[1\].RAM16.SLICE\[1\].RAM8.WORD\[2\].W.BYTE\[2\].B.SEL0_B VGND VGND VPWR
+ VPWR SLICE_16\[1\].RAM16.BYTE\[2\].FLOATBUF0\[21\].Z sky130_fd_sc_hd__ebufn_2
XSLICE_16\[1\].RAM16.SLICE\[0\].RAM8.WORD\[4\].W.BYTE\[0\].B.BIT\[4\].genblk1.STORAGE
+ DIBUF\[4\].X SLICE_16\[1\].RAM16.SLICE\[0\].RAM8.WORD\[4\].W.BYTE\[0\].B.GCLK VGND
+ VGND VPWR VPWR SLICE_16\[1\].RAM16.SLICE\[0\].RAM8.WORD\[4\].W.BYTE\[0\].B.Q_WIRE\[4\]
+ sky130_fd_sc_hd__dlxtp_1
XSLICE_16\[1\].RAM16.SLICE\[0\].RAM8.WORD\[0\].W.BYTE\[1\].B.DIODE_CLK SLICE_16\[1\].RAM16.SLICE\[0\].RAM8.WORD\[0\].W.BYTE\[0\].B.CLK
+ VGND VGND VPWR VPWR sky130_fd_sc_hd__diode_2
XSLICE_16\[0\].RAM16.SLICE\[1\].RAM8.WORD\[2\].W.BYTE\[3\].B.BIT\[7\].genblk1.STORAGE
+ DIBUF\[31\].X SLICE_16\[0\].RAM16.SLICE\[1\].RAM8.WORD\[2\].W.BYTE\[3\].B.GCLK VGND
+ VGND VPWR VPWR SLICE_16\[0\].RAM16.SLICE\[1\].RAM8.WORD\[2\].W.BYTE\[3\].B.Q_WIRE\[7\]
+ sky130_fd_sc_hd__dlxtp_1
XSLICE_16\[0\].RAM16.SLICE\[1\].RAM8.WORD\[6\].W.BYTE\[0\].B.BIT\[5\].genblk1.STORAGE
+ DIBUF\[5\].X SLICE_16\[0\].RAM16.SLICE\[1\].RAM8.WORD\[6\].W.BYTE\[0\].B.GCLK VGND
+ VGND VPWR VPWR SLICE_16\[0\].RAM16.SLICE\[1\].RAM8.WORD\[6\].W.BYTE\[0\].B.Q_WIRE\[5\]
+ sky130_fd_sc_hd__dlxtp_1
XSLICE_16\[0\].RAM16.SLICE\[1\].RAM8.WORD\[0\].W.BYTE\[1\].B.BIT\[6\].genblk1.STORAGE
+ DIBUF\[14\].X SLICE_16\[0\].RAM16.SLICE\[1\].RAM8.WORD\[0\].W.BYTE\[1\].B.GCLK VGND
+ VGND VPWR VPWR SLICE_16\[0\].RAM16.SLICE\[1\].RAM8.WORD\[0\].W.BYTE\[1\].B.Q_WIRE\[6\]
+ sky130_fd_sc_hd__dlxtp_1
XDo0MUX.M\[0\].MUX\[1\] Do0MUX.A0\[1\] Do0MUX.A1\[1\] Do0MUX.SEL\[0\] VGND VGND VPWR
+ VPWR Do0[1] sky130_fd_sc_hd__mux2_1
Xfill_20_94 VGND VGND VPWR VPWR sky130_fd_sc_hd__decap_12
Xfill_20_83 VGND VGND VPWR VPWR sky130_fd_sc_hd__decap_12
Xfill_20_72 VGND VPWR sky130_fd_sc_hd__tapvpwrvgnd_1
Xfill_20_61 VGND VGND VPWR VPWR sky130_fd_sc_hd__decap_12
Xfill_20_50 VGND VGND VPWR VPWR sky130_fd_sc_hd__decap_12
XSLICE_16\[0\].RAM16.SLICE\[1\].RAM8.WORD\[4\].W.BYTE\[1\].B.BIT\[6\].OBUF0 SLICE_16\[0\].RAM16.SLICE\[1\].RAM8.WORD\[4\].W.BYTE\[1\].B.Q_WIRE\[6\]
+ SLICE_16\[0\].RAM16.SLICE\[1\].RAM8.WORD\[4\].W.BYTE\[1\].B.SEL0_B VGND VGND VPWR
+ VPWR SLICE_16\[0\].RAM16.BYTE\[1\].FLOATBUF0\[14\].Z sky130_fd_sc_hd__ebufn_2
XSLICE_16\[0\].RAM16.SLICE\[0\].RAM8.WORD\[1\].W.BYTE\[3\].B.BIT\[2\].genblk1.STORAGE
+ DIBUF\[26\].X SLICE_16\[0\].RAM16.SLICE\[0\].RAM8.WORD\[1\].W.BYTE\[3\].B.GCLK VGND
+ VGND VPWR VPWR SLICE_16\[0\].RAM16.SLICE\[0\].RAM8.WORD\[1\].W.BYTE\[3\].B.Q_WIRE\[2\]
+ sky130_fd_sc_hd__dlxtp_1
XSLICE_16\[0\].RAM16.SLICE\[0\].RAM8.WORD\[2\].W.BYTE\[3\].B.BIT\[0\].OBUF0 SLICE_16\[0\].RAM16.SLICE\[0\].RAM8.WORD\[2\].W.BYTE\[3\].B.Q_WIRE\[0\]
+ SLICE_16\[0\].RAM16.SLICE\[0\].RAM8.WORD\[2\].W.BYTE\[3\].B.SEL0_B VGND VGND VPWR
+ VPWR SLICE_16\[0\].RAM16.BYTE\[3\].FLOATBUF0\[24\].Z sky130_fd_sc_hd__ebufn_2
XSLICE_16\[0\].RAM16.SLICE\[0\].RAM8.WORD\[5\].W.BYTE\[0\].B.BIT\[0\].genblk1.STORAGE
+ DIBUF\[0\].X SLICE_16\[0\].RAM16.SLICE\[0\].RAM8.WORD\[5\].W.BYTE\[0\].B.GCLK VGND
+ VGND VPWR VPWR SLICE_16\[0\].RAM16.SLICE\[0\].RAM8.WORD\[5\].W.BYTE\[0\].B.Q_WIRE\[0\]
+ sky130_fd_sc_hd__dlxtp_1
XSLICE_16\[0\].RAM16.SLICE\[0\].RAM8.WORD\[7\].W.BYTE\[2\].B.BIT\[1\].genblk1.STORAGE
+ DIBUF\[17\].X SLICE_16\[0\].RAM16.SLICE\[0\].RAM8.WORD\[7\].W.BYTE\[2\].B.GCLK VGND
+ VGND VPWR VPWR SLICE_16\[0\].RAM16.SLICE\[0\].RAM8.WORD\[7\].W.BYTE\[2\].B.Q_WIRE\[1\]
+ sky130_fd_sc_hd__dlxtp_1
XSLICE_16\[0\].RAM16.Do0_REG.OUTREG_BYTE\[2\].DIODE\[3\] SLICE_16\[0\].RAM16.BYTE\[2\].FLOATBUF0\[19\].Z
+ VGND VGND VPWR VPWR sky130_fd_sc_hd__diode_2
XSLICE_16\[0\].RAM16.SLICE\[0\].RAM8.WORD\[3\].W.BYTE\[0\].B.DIODE_CLK SLICE_16\[0\].RAM16.SLICE\[0\].RAM8.WORD\[3\].W.BYTE\[0\].B.CLK
+ VGND VGND VPWR VPWR sky130_fd_sc_hd__diode_2
XSLICE_16\[0\].RAM16.SLICE\[0\].RAM8.WORD\[7\].W.BYTE\[3\].B.genblk1.CLKINV SLICE_16\[0\].RAM16.SLICE\[0\].RAM8.WORD\[7\].W.BYTE\[0\].B.CLK
+ VGND VGND VPWR VPWR SLICE_16\[0\].RAM16.SLICE\[0\].RAM8.WORD\[7\].W.BYTE\[3\].B.CLK_B
+ sky130_fd_sc_hd__inv_1
Xfill_45_91 VGND VGND VPWR VPWR sky130_fd_sc_hd__decap_12
Xfill_45_80 VGND VGND VPWR VPWR sky130_fd_sc_hd__decap_12
XSLICE_16\[0\].RAM16.SLICE\[1\].RAM8.WORD\[0\].W.BYTE\[2\].B.SEL0INV SLICE_16\[0\].RAM16.SLICE\[1\].RAM8.WORD\[0\].W.BYTE\[0\].B.SEL0
+ VGND VGND VPWR VPWR SLICE_16\[0\].RAM16.SLICE\[1\].RAM8.WORD\[0\].W.BYTE\[2\].B.SEL0_B
+ sky130_fd_sc_hd__inv_1
Xtap_37_29 VGND VPWR sky130_fd_sc_hd__tapvpwrvgnd_1
Xtap_37_18 VGND VPWR sky130_fd_sc_hd__tapvpwrvgnd_1
XSLICE_16\[1\].RAM16.SLICE\[1\].RAM8.WORD\[1\].W.BYTE\[0\].B.BIT\[2\].OBUF0 SLICE_16\[1\].RAM16.SLICE\[1\].RAM8.WORD\[1\].W.BYTE\[0\].B.Q_WIRE\[2\]
+ SLICE_16\[1\].RAM16.SLICE\[1\].RAM8.WORD\[1\].W.BYTE\[0\].B.SEL0_B VGND VGND VPWR
+ VPWR SLICE_16\[1\].RAM16.BYTE\[0\].FLOATBUF0\[2\].Z sky130_fd_sc_hd__ebufn_2
XSLICE_16\[0\].RAM16.SLICE\[0\].RAM8.WORD\[1\].W.BYTE\[2\].B.genblk1.CG SLICE_16\[0\].RAM16.SLICE\[0\].RAM8.WORD\[1\].W.BYTE\[2\].B.CLK_B
+ SLICE_16\[0\].RAM16.SLICE\[0\].RAM8.WORD\[1\].W.BYTE\[2\].B.WE0_WIRE VGND VGND VPWR
+ VPWR SLICE_16\[0\].RAM16.SLICE\[0\].RAM8.WORD\[1\].W.BYTE\[2\].B.GCLK sky130_fd_sc_hd__dlclkp_1
Xtap_7_9 VGND VPWR sky130_fd_sc_hd__tapvpwrvgnd_1
XSLICE_16\[1\].RAM16.SLICE\[1\].RAM8.WORD\[5\].W.BYTE\[3\].B.BIT\[5\].OBUF0 SLICE_16\[1\].RAM16.SLICE\[1\].RAM8.WORD\[5\].W.BYTE\[3\].B.Q_WIRE\[5\]
+ SLICE_16\[1\].RAM16.SLICE\[1\].RAM8.WORD\[5\].W.BYTE\[3\].B.SEL0_B VGND VGND VPWR
+ VPWR SLICE_16\[1\].RAM16.BYTE\[3\].FLOATBUF0\[29\].Z sky130_fd_sc_hd__ebufn_2
Xtap_8_11 VGND VPWR sky130_fd_sc_hd__tapvpwrvgnd_1
Xtap_8_22 VGND VPWR sky130_fd_sc_hd__tapvpwrvgnd_1
Xtap_8_33 VGND VPWR sky130_fd_sc_hd__tapvpwrvgnd_1
Xfill_41_49 VGND VGND VPWR VPWR sky130_fd_sc_hd__decap_12
Xfill_41_38 VGND VGND VPWR VPWR sky130_fd_sc_hd__decap_12
Xfill_41_27 VGND VPWR sky130_fd_sc_hd__tapvpwrvgnd_1
Xfill_41_16 VGND VGND VPWR VPWR sky130_fd_sc_hd__decap_12
Xtap_40_3 VGND VPWR sky130_fd_sc_hd__tapvpwrvgnd_1
Xtap_33_2 VGND VPWR sky130_fd_sc_hd__tapvpwrvgnd_1
Xtap_26_1 VGND VPWR sky130_fd_sc_hd__tapvpwrvgnd_1
XSLICE_16\[1\].RAM16.SLICE\[0\].RAM8.WORD\[0\].W.BYTE\[2\].B.BIT\[4\].OBUF0 SLICE_16\[1\].RAM16.SLICE\[0\].RAM8.WORD\[0\].W.BYTE\[2\].B.Q_WIRE\[4\]
+ SLICE_16\[1\].RAM16.SLICE\[0\].RAM8.WORD\[0\].W.BYTE\[2\].B.SEL0_B VGND VGND VPWR
+ VPWR SLICE_16\[1\].RAM16.BYTE\[2\].FLOATBUF0\[20\].Z sky130_fd_sc_hd__ebufn_2
Xtap_19_0 VGND VPWR sky130_fd_sc_hd__tapvpwrvgnd_1
XSLICE_16\[0\].RAM16.SLICE\[1\].RAM8.WORD\[7\].W.BYTE\[2\].B.BIT\[6\].OBUF0 SLICE_16\[0\].RAM16.SLICE\[1\].RAM8.WORD\[7\].W.BYTE\[2\].B.Q_WIRE\[6\]
+ SLICE_16\[0\].RAM16.SLICE\[1\].RAM8.WORD\[7\].W.BYTE\[2\].B.SEL0_B VGND VGND VPWR
+ VPWR SLICE_16\[0\].RAM16.BYTE\[2\].FLOATBUF0\[22\].Z sky130_fd_sc_hd__ebufn_2
XSLICE_16\[0\].RAM16.SLICE\[0\].RAM8.WORD\[2\].W.BYTE\[1\].B.BIT\[5\].OBUF0 SLICE_16\[0\].RAM16.SLICE\[0\].RAM8.WORD\[2\].W.BYTE\[1\].B.Q_WIRE\[5\]
+ SLICE_16\[0\].RAM16.SLICE\[0\].RAM8.WORD\[2\].W.BYTE\[1\].B.SEL0_B VGND VGND VPWR
+ VPWR SLICE_16\[0\].RAM16.BYTE\[1\].FLOATBUF0\[13\].Z sky130_fd_sc_hd__ebufn_2
XSLICE_16\[1\].RAM16.SLICE\[1\].RAM8.WORD\[4\].W.BYTE\[1\].B.BIT\[2\].OBUF0 SLICE_16\[1\].RAM16.SLICE\[1\].RAM8.WORD\[4\].W.BYTE\[1\].B.Q_WIRE\[2\]
+ SLICE_16\[1\].RAM16.SLICE\[1\].RAM8.WORD\[4\].W.BYTE\[1\].B.SEL0_B VGND VGND VPWR
+ VPWR SLICE_16\[1\].RAM16.BYTE\[1\].FLOATBUF0\[10\].Z sky130_fd_sc_hd__ebufn_2
Xfill_47_4 VGND VGND VPWR VPWR sky130_fd_sc_hd__decap_12
XSLICE_16\[1\].RAM16.SLICE\[0\].RAM8.WORD\[7\].W.BYTE\[1\].B.BIT\[4\].genblk1.STORAGE
+ DIBUF\[12\].X SLICE_16\[1\].RAM16.SLICE\[0\].RAM8.WORD\[7\].W.BYTE\[1\].B.GCLK VGND
+ VGND VPWR VPWR SLICE_16\[1\].RAM16.SLICE\[0\].RAM8.WORD\[7\].W.BYTE\[1\].B.Q_WIRE\[4\]
+ sky130_fd_sc_hd__dlxtp_1
XSLICE_16\[1\].RAM16.SLICE\[0\].RAM8.WORD\[1\].W.BYTE\[2\].B.BIT\[5\].genblk1.STORAGE
+ DIBUF\[21\].X SLICE_16\[1\].RAM16.SLICE\[0\].RAM8.WORD\[1\].W.BYTE\[2\].B.GCLK VGND
+ VGND VPWR VPWR SLICE_16\[1\].RAM16.SLICE\[0\].RAM8.WORD\[1\].W.BYTE\[2\].B.Q_WIRE\[5\]
+ sky130_fd_sc_hd__dlxtp_1
XSLICE_16\[0\].RAM16.Do0_REG.OUTREG_BYTE\[1\].Do_FF\[4\] SLICE_16\[0\].RAM16.Do0_REG.CLKBUF\[1\]
+ SLICE_16\[0\].RAM16.BYTE\[1\].FLOATBUF0\[12\].Z VGND VGND VPWR VPWR Do0MUX.A0\[12\]
+ sky130_fd_sc_hd__dfxtp_1
XDo0MUX.M\[3\].MUX\[6\] Do0MUX.A0\[30\] Do0MUX.A1\[30\] Do0MUX.SEL\[3\] VGND VGND
+ VPWR VPWR Do0[30] sky130_fd_sc_hd__mux2_1
XSLICE_16\[0\].RAM16.SLICE\[1\].RAM8.WORD\[3\].W.BYTE\[2\].B.BIT\[6\].genblk1.STORAGE
+ DIBUF\[22\].X SLICE_16\[0\].RAM16.SLICE\[1\].RAM8.WORD\[3\].W.BYTE\[2\].B.GCLK VGND
+ VGND VPWR VPWR SLICE_16\[0\].RAM16.SLICE\[1\].RAM8.WORD\[3\].W.BYTE\[2\].B.Q_WIRE\[6\]
+ sky130_fd_sc_hd__dlxtp_1
Xfill_2_4 VGND VGND VPWR VPWR sky130_fd_sc_hd__decap_4
XSLICE_16\[0\].RAM16.SLICE\[1\].RAM8.WORD\[6\].W.BYTE\[0\].B.BIT\[3\].OBUF0 SLICE_16\[0\].RAM16.SLICE\[1\].RAM8.WORD\[6\].W.BYTE\[0\].B.Q_WIRE\[3\]
+ SLICE_16\[0\].RAM16.SLICE\[1\].RAM8.WORD\[6\].W.BYTE\[0\].B.SEL0_B VGND VGND VPWR
+ VPWR SLICE_16\[0\].RAM16.BYTE\[0\].FLOATBUF0\[3\].Z sky130_fd_sc_hd__ebufn_2
XSLICE_16\[0\].RAM16.SLICE\[0\].RAM8.WORD\[2\].W.BYTE\[2\].B.BIT\[1\].genblk1.STORAGE
+ DIBUF\[17\].X SLICE_16\[0\].RAM16.SLICE\[0\].RAM8.WORD\[2\].W.BYTE\[2\].B.GCLK VGND
+ VGND VPWR VPWR SLICE_16\[0\].RAM16.SLICE\[0\].RAM8.WORD\[2\].W.BYTE\[2\].B.Q_WIRE\[1\]
+ sky130_fd_sc_hd__dlxtp_1
XSLICE_16\[0\].RAM16.SLICE\[1\].RAM8.WORD\[1\].W.BYTE\[0\].B.BIT\[5\].genblk1.STORAGE
+ DIBUF\[5\].X SLICE_16\[0\].RAM16.SLICE\[1\].RAM8.WORD\[1\].W.BYTE\[0\].B.GCLK VGND
+ VGND VPWR VPWR SLICE_16\[0\].RAM16.SLICE\[1\].RAM8.WORD\[1\].W.BYTE\[0\].B.Q_WIRE\[5\]
+ sky130_fd_sc_hd__dlxtp_1
XSLICE_16\[1\].RAM16.SLICE\[0\].RAM8.WORD\[3\].W.BYTE\[3\].B.BIT\[4\].OBUF0 SLICE_16\[1\].RAM16.SLICE\[0\].RAM8.WORD\[3\].W.BYTE\[3\].B.Q_WIRE\[4\]
+ SLICE_16\[1\].RAM16.SLICE\[0\].RAM8.WORD\[3\].W.BYTE\[3\].B.SEL0_B VGND VGND VPWR
+ VPWR SLICE_16\[1\].RAM16.BYTE\[3\].FLOATBUF0\[28\].Z sky130_fd_sc_hd__ebufn_2
Xtap_12_7 VGND VPWR sky130_fd_sc_hd__tapvpwrvgnd_1
XSLICE_16\[0\].RAM16.SLICE\[0\].RAM8.WORD\[0\].W.BYTE\[0\].B.BIT\[0\].genblk1.STORAGE
+ DIBUF\[0\].X SLICE_16\[0\].RAM16.SLICE\[0\].RAM8.WORD\[0\].W.BYTE\[0\].B.GCLK VGND
+ VGND VPWR VPWR SLICE_16\[0\].RAM16.SLICE\[0\].RAM8.WORD\[0\].W.BYTE\[0\].B.Q_WIRE\[0\]
+ sky130_fd_sc_hd__dlxtp_1
XSLICE_16\[0\].RAM16.SLICE\[0\].RAM8.WORD\[6\].W.BYTE\[3\].B.DIODE_CLK SLICE_16\[0\].RAM16.SLICE\[0\].RAM8.WORD\[6\].W.BYTE\[0\].B.CLK
+ VGND VGND VPWR VPWR sky130_fd_sc_hd__diode_2
XSLICE_16\[0\].RAM16.SLICE\[1\].RAM8.WORD\[1\].W.BYTE\[2\].B.genblk1.CLKINV SLICE_16\[0\].RAM16.SLICE\[1\].RAM8.WORD\[1\].W.BYTE\[0\].B.CLK
+ VGND VGND VPWR VPWR SLICE_16\[0\].RAM16.SLICE\[1\].RAM8.WORD\[1\].W.BYTE\[2\].B.CLK_B
+ sky130_fd_sc_hd__inv_1
XSLICE_16\[1\].RAM16.SLICE\[1\].RAM8.WORD\[2\].W.BYTE\[1\].B.DIODE_CLK SLICE_16\[1\].RAM16.SLICE\[1\].RAM8.WORD\[2\].W.BYTE\[0\].B.CLK
+ VGND VGND VPWR VPWR sky130_fd_sc_hd__diode_2
XSLICE_16\[0\].RAM16.BYTE\[1\].FLOATBUF0\[15\].__cell__ SLICE_16\[0\].RAM16.BYTE\[1\].FLOATBUF0\[10\].A
+ SLICE_16\[0\].RAM16.BYTE\[1\].FLOATBUF0\[10\].TE_B VGND VGND VPWR VPWR SLICE_16\[0\].RAM16.BYTE\[1\].FLOATBUF0\[15\].Z
+ sky130_fd_sc_hd__ebufn_2
Xtap_5_6 VGND VPWR sky130_fd_sc_hd__tapvpwrvgnd_1
Xtap_13_31 VGND VPWR sky130_fd_sc_hd__tapvpwrvgnd_1
Xtap_13_20 VGND VPWR sky130_fd_sc_hd__tapvpwrvgnd_1
XSLICE_16\[0\].RAM16.SLICE\[0\].RAM8.WORD\[5\].W.BYTE\[2\].B.BIT\[5\].OBUF0 SLICE_16\[0\].RAM16.SLICE\[0\].RAM8.WORD\[5\].W.BYTE\[2\].B.Q_WIRE\[5\]
+ SLICE_16\[0\].RAM16.SLICE\[0\].RAM8.WORD\[5\].W.BYTE\[2\].B.SEL0_B VGND VGND VPWR
+ VPWR SLICE_16\[0\].RAM16.BYTE\[2\].FLOATBUF0\[21\].Z sky130_fd_sc_hd__ebufn_2
XSLICE_16\[1\].RAM16.SLICE\[1\].RAM8.WORD\[7\].W.BYTE\[2\].B.BIT\[2\].OBUF0 SLICE_16\[1\].RAM16.SLICE\[1\].RAM8.WORD\[7\].W.BYTE\[2\].B.Q_WIRE\[2\]
+ SLICE_16\[1\].RAM16.SLICE\[1\].RAM8.WORD\[7\].W.BYTE\[2\].B.SEL0_B VGND VGND VPWR
+ VPWR SLICE_16\[1\].RAM16.BYTE\[2\].FLOATBUF0\[18\].Z sky130_fd_sc_hd__ebufn_2
XSLICE_16\[0\].RAM16.SLICE\[1\].RAM8.WORD\[6\].W.BYTE\[2\].B.genblk1.CG SLICE_16\[0\].RAM16.SLICE\[1\].RAM8.WORD\[6\].W.BYTE\[2\].B.CLK_B
+ SLICE_16\[0\].RAM16.SLICE\[1\].RAM8.WORD\[6\].W.BYTE\[2\].B.WE0_WIRE VGND VGND VPWR
+ VPWR SLICE_16\[0\].RAM16.SLICE\[1\].RAM8.WORD\[6\].W.BYTE\[2\].B.GCLK sky130_fd_sc_hd__dlclkp_1
Xfill_19_8 VGND VGND VPWR VPWR sky130_fd_sc_hd__decap_12
XSLICE_16\[0\].RAM16.SLICE\[1\].RAM8.WORD\[5\].W.BYTE\[0\].B.DIODE_CLK SLICE_16\[0\].RAM16.SLICE\[1\].RAM8.WORD\[5\].W.BYTE\[0\].B.CLK
+ VGND VGND VPWR VPWR sky130_fd_sc_hd__diode_2
Xfill_42_92 VGND VGND VPWR VPWR sky130_fd_sc_hd__decap_12
Xfill_42_81 VGND VPWR sky130_fd_sc_hd__tapvpwrvgnd_1
Xfill_42_70 VGND VGND VPWR VPWR sky130_fd_sc_hd__decap_12
XSLICE_16\[1\].RAM16.SLICE\[0\].RAM8.WORD\[2\].W.BYTE\[1\].B.BIT\[1\].OBUF0 SLICE_16\[1\].RAM16.SLICE\[0\].RAM8.WORD\[2\].W.BYTE\[1\].B.Q_WIRE\[1\]
+ SLICE_16\[1\].RAM16.SLICE\[0\].RAM8.WORD\[2\].W.BYTE\[1\].B.SEL0_B VGND VGND VPWR
+ VPWR SLICE_16\[1\].RAM16.BYTE\[1\].FLOATBUF0\[9\].Z sky130_fd_sc_hd__ebufn_2
XSLICE_16\[0\].RAM16.SLICE\[1\].RAM8.WORD\[4\].W.BYTE\[3\].B.genblk1.CLKINV SLICE_16\[0\].RAM16.SLICE\[1\].RAM8.WORD\[4\].W.BYTE\[0\].B.CLK
+ VGND VGND VPWR VPWR SLICE_16\[0\].RAM16.SLICE\[1\].RAM8.WORD\[4\].W.BYTE\[3\].B.CLK_B
+ sky130_fd_sc_hd__inv_1
XSLICE_16\[0\].RAM16.A0BUF\[0\].__cell__ A0BUF\[0\].X VGND VGND VPWR VPWR SLICE_16\[0\].RAM16.A0BUF\[0\].X
+ sky130_fd_sc_hd__clkbuf_2
XSLICE_16\[0\].RAM16.SLICE\[1\].RAM8.WORD\[4\].W.BYTE\[0\].B.SEL0INV SLICE_16\[0\].RAM16.SLICE\[1\].RAM8.WORD\[4\].W.BYTE\[0\].B.SEL0
+ VGND VGND VPWR VPWR SLICE_16\[0\].RAM16.SLICE\[1\].RAM8.WORD\[4\].W.BYTE\[0\].B.SEL0_B
+ sky130_fd_sc_hd__inv_1
XEN0BUF.__cell__ EN0 VGND VGND VPWR VPWR DEC0.EN sky130_fd_sc_hd__clkbuf_2
Xfill_45_1 VGND VGND VPWR VPWR sky130_fd_sc_hd__decap_12
Xfill_38_0 VGND VPWR sky130_fd_sc_hd__tapvpwrvgnd_1
Xtap_34_19 VGND VPWR sky130_fd_sc_hd__tapvpwrvgnd_1
XSLICE_16\[0\].RAM16.SLICE\[0\].RAM8.WORD\[4\].W.BYTE\[0\].B.BIT\[2\].OBUF0 SLICE_16\[0\].RAM16.SLICE\[0\].RAM8.WORD\[4\].W.BYTE\[0\].B.Q_WIRE\[2\]
+ SLICE_16\[0\].RAM16.SLICE\[0\].RAM8.WORD\[4\].W.BYTE\[0\].B.SEL0_B VGND VGND VPWR
+ VPWR SLICE_16\[0\].RAM16.BYTE\[0\].FLOATBUF0\[2\].Z sky130_fd_sc_hd__ebufn_2
Xfill_0_1 VGND VGND VPWR VPWR sky130_fd_sc_hd__decap_12
XSLICE_16\[1\].RAM16.SLICE\[1\].RAM8.WORD\[3\].W.BYTE\[1\].B.genblk1.CG SLICE_16\[1\].RAM16.SLICE\[1\].RAM8.WORD\[3\].W.BYTE\[1\].B.CLK_B
+ SLICE_16\[1\].RAM16.SLICE\[1\].RAM8.WORD\[3\].W.BYTE\[1\].B.WE0_WIRE VGND VGND VPWR
+ VPWR SLICE_16\[1\].RAM16.SLICE\[1\].RAM8.WORD\[3\].W.BYTE\[1\].B.GCLK sky130_fd_sc_hd__dlclkp_1
XSLICE_16\[1\].RAM16.SLICE\[0\].RAM8.WORD\[4\].W.BYTE\[3\].B.BIT\[5\].genblk1.STORAGE
+ DIBUF\[29\].X SLICE_16\[1\].RAM16.SLICE\[0\].RAM8.WORD\[4\].W.BYTE\[3\].B.GCLK VGND
+ VGND VPWR VPWR SLICE_16\[1\].RAM16.SLICE\[0\].RAM8.WORD\[4\].W.BYTE\[3\].B.Q_WIRE\[5\]
+ sky130_fd_sc_hd__dlxtp_1
Xfill_22_29 VGND VGND VPWR VPWR sky130_fd_sc_hd__decap_12
Xfill_22_18 VGND VPWR sky130_fd_sc_hd__tapvpwrvgnd_1
Xtap_5_12 VGND VPWR sky130_fd_sc_hd__tapvpwrvgnd_1
Xtap_5_23 VGND VPWR sky130_fd_sc_hd__tapvpwrvgnd_1
Xtap_5_34 VGND VPWR sky130_fd_sc_hd__tapvpwrvgnd_1
Xfill_47_37 VGND VGND VPWR VPWR sky130_fd_sc_hd__decap_12
Xfill_47_26 VGND VGND VPWR VPWR sky130_fd_sc_hd__decap_12
Xfill_47_15 VGND VPWR sky130_fd_sc_hd__tapvpwrvgnd_1
XSLICE_16\[1\].RAM16.SLICE\[0\].RAM8.WORD\[2\].W.BYTE\[1\].B.BIT\[4\].genblk1.STORAGE
+ DIBUF\[12\].X SLICE_16\[1\].RAM16.SLICE\[0\].RAM8.WORD\[2\].W.BYTE\[1\].B.GCLK VGND
+ VGND VPWR VPWR SLICE_16\[1\].RAM16.SLICE\[0\].RAM8.WORD\[2\].W.BYTE\[1\].B.Q_WIRE\[4\]
+ sky130_fd_sc_hd__dlxtp_1
XSLICE_16\[0\].RAM16.SLICE\[1\].RAM8.WORD\[6\].W.BYTE\[3\].B.BIT\[6\].genblk1.STORAGE
+ DIBUF\[30\].X SLICE_16\[0\].RAM16.SLICE\[1\].RAM8.WORD\[6\].W.BYTE\[3\].B.GCLK VGND
+ VGND VPWR VPWR SLICE_16\[0\].RAM16.SLICE\[1\].RAM8.WORD\[6\].W.BYTE\[3\].B.Q_WIRE\[6\]
+ sky130_fd_sc_hd__dlxtp_1
Xtap_10_4 VGND VPWR sky130_fd_sc_hd__tapvpwrvgnd_1
Xfill_47_59 VGND VGND VPWR VPWR sky130_fd_sc_hd__decap_12
Xfill_47_48 VGND VPWR sky130_fd_sc_hd__tapvpwrvgnd_1
XSLICE_16\[1\].RAM16.SLICE\[1\].RAM8.WORD\[7\].W.BYTE\[0\].B.BIT\[7\].OBUF0 SLICE_16\[1\].RAM16.SLICE\[1\].RAM8.WORD\[7\].W.BYTE\[0\].B.Q_WIRE\[7\]
+ SLICE_16\[1\].RAM16.SLICE\[1\].RAM8.WORD\[7\].W.BYTE\[0\].B.SEL0_B VGND VGND VPWR
+ VPWR SLICE_16\[1\].RAM16.BYTE\[0\].FLOATBUF0\[7\].Z sky130_fd_sc_hd__ebufn_2
XSLICE_16\[1\].RAM16.SLICE\[0\].RAM8.WORD\[5\].W.BYTE\[2\].B.BIT\[1\].OBUF0 SLICE_16\[1\].RAM16.SLICE\[0\].RAM8.WORD\[5\].W.BYTE\[2\].B.Q_WIRE\[1\]
+ SLICE_16\[1\].RAM16.SLICE\[0\].RAM8.WORD\[5\].W.BYTE\[2\].B.SEL0_B VGND VGND VPWR
+ VPWR SLICE_16\[1\].RAM16.BYTE\[2\].FLOATBUF0\[17\].Z sky130_fd_sc_hd__ebufn_2
Xtap_24_30 VGND VPWR sky130_fd_sc_hd__tapvpwrvgnd_1
XSLICE_16\[0\].RAM16.SLICE\[1\].RAM8.WORD\[4\].W.BYTE\[1\].B.BIT\[5\].genblk1.STORAGE
+ DIBUF\[13\].X SLICE_16\[0\].RAM16.SLICE\[1\].RAM8.WORD\[4\].W.BYTE\[1\].B.GCLK VGND
+ VGND VPWR VPWR SLICE_16\[0\].RAM16.SLICE\[1\].RAM8.WORD\[4\].W.BYTE\[1\].B.Q_WIRE\[5\]
+ sky130_fd_sc_hd__dlxtp_1
Xtap_3_3 VGND VPWR sky130_fd_sc_hd__tapvpwrvgnd_1
XSLICE_16\[0\].RAM16.SLICE\[0\].RAM8.WORD\[5\].W.BYTE\[1\].B.CGAND SLICE_16\[0\].RAM16.SLICE\[0\].RAM8.WORD\[5\].W.BYTE\[0\].B.SEL0
+ SLICE_16\[0\].RAM16.SLICE\[0\].RAM8.WE0_buf\[1\] VGND VGND VPWR VPWR SLICE_16\[0\].RAM16.SLICE\[0\].RAM8.WORD\[5\].W.BYTE\[1\].B.WE0_WIRE
+ sky130_fd_sc_hd__and2_1
XSLICE_16\[0\].RAM16.SLICE\[0\].RAM8.WORD\[5\].W.BYTE\[3\].B.BIT\[1\].genblk1.STORAGE
+ DIBUF\[25\].X SLICE_16\[0\].RAM16.SLICE\[0\].RAM8.WORD\[5\].W.BYTE\[3\].B.GCLK VGND
+ VGND VPWR VPWR SLICE_16\[0\].RAM16.SLICE\[0\].RAM8.WORD\[5\].W.BYTE\[3\].B.Q_WIRE\[1\]
+ sky130_fd_sc_hd__dlxtp_1
XSLICE_16\[0\].RAM16.SLICE\[0\].RAM8.WORD\[3\].W.BYTE\[1\].B.BIT\[0\].genblk1.STORAGE
+ DIBUF\[8\].X SLICE_16\[0\].RAM16.SLICE\[0\].RAM8.WORD\[3\].W.BYTE\[1\].B.GCLK VGND
+ VGND VPWR VPWR SLICE_16\[0\].RAM16.SLICE\[0\].RAM8.WORD\[3\].W.BYTE\[1\].B.Q_WIRE\[0\]
+ sky130_fd_sc_hd__dlxtp_1
XSLICE_16\[0\].RAM16.SLICE\[0\].RAM8.WORD\[7\].W.BYTE\[1\].B.BIT\[2\].OBUF0 SLICE_16\[0\].RAM16.SLICE\[0\].RAM8.WORD\[7\].W.BYTE\[1\].B.Q_WIRE\[2\]
+ SLICE_16\[0\].RAM16.SLICE\[0\].RAM8.WORD\[7\].W.BYTE\[1\].B.SEL0_B VGND VGND VPWR
+ VPWR SLICE_16\[0\].RAM16.BYTE\[1\].FLOATBUF0\[10\].Z sky130_fd_sc_hd__ebufn_2
Xfill_17_5 VGND VGND VPWR VPWR sky130_fd_sc_hd__decap_12
Xfill_0_20 VGND VGND VPWR VPWR sky130_fd_sc_hd__decap_12
XDIBUF\[26\].__cell__ Di0[26] VGND VGND VPWR VPWR DIBUF\[26\].X sky130_fd_sc_hd__clkbuf_16
Xtap_29_19 VGND VPWR sky130_fd_sc_hd__tapvpwrvgnd_1
XSLICE_16\[1\].RAM16.Do0_REG.OUTREG_BYTE\[0\].Do_FF\[0\] SLICE_16\[1\].RAM16.Do0_REG.CLKBUF\[0\]
+ SLICE_16\[1\].RAM16.BYTE\[0\].FLOATBUF0\[0\].Z VGND VGND VPWR VPWR Do0MUX.A1\[0\]
+ sky130_fd_sc_hd__dfxtp_1
XSLICE_16\[1\].RAM16.SLICE\[1\].RAM8.WORD\[0\].W.BYTE\[3\].B.BIT\[4\].OBUF0 SLICE_16\[1\].RAM16.SLICE\[1\].RAM8.WORD\[0\].W.BYTE\[3\].B.Q_WIRE\[4\]
+ SLICE_16\[1\].RAM16.SLICE\[1\].RAM8.WORD\[0\].W.BYTE\[3\].B.SEL0_B VGND VGND VPWR
+ VPWR SLICE_16\[1\].RAM16.BYTE\[3\].FLOATBUF0\[28\].Z sky130_fd_sc_hd__ebufn_2
Xfill_17_29 VGND VGND VPWR VPWR sky130_fd_sc_hd__decap_12
Xfill_17_18 VGND VPWR sky130_fd_sc_hd__tapvpwrvgnd_1
Xtap_10_10 VGND VPWR sky130_fd_sc_hd__tapvpwrvgnd_1
Xtap_10_21 VGND VPWR sky130_fd_sc_hd__tapvpwrvgnd_1
XSLICE_16\[1\].RAM16.SLICE\[0\].RAM8.WORD\[5\].W.BYTE\[0\].B.BIT\[6\].OBUF0 SLICE_16\[1\].RAM16.SLICE\[0\].RAM8.WORD\[5\].W.BYTE\[0\].B.Q_WIRE\[6\]
+ SLICE_16\[1\].RAM16.SLICE\[0\].RAM8.WORD\[5\].W.BYTE\[0\].B.SEL0_B VGND VGND VPWR
+ VPWR SLICE_16\[1\].RAM16.BYTE\[0\].FLOATBUF0\[6\].Z sky130_fd_sc_hd__ebufn_2
Xtap_10_32 VGND VPWR sky130_fd_sc_hd__tapvpwrvgnd_1
Xtap_1_0 VGND VPWR sky130_fd_sc_hd__tapvpwrvgnd_1
XSLICE_16\[0\].RAM16.SLICE\[1\].RAM8.WORD\[2\].W.BYTE\[2\].B.BIT\[5\].OBUF0 SLICE_16\[0\].RAM16.SLICE\[1\].RAM8.WORD\[2\].W.BYTE\[2\].B.Q_WIRE\[5\]
+ SLICE_16\[0\].RAM16.SLICE\[1\].RAM8.WORD\[2\].W.BYTE\[2\].B.SEL0_B VGND VGND VPWR
+ VPWR SLICE_16\[0\].RAM16.BYTE\[2\].FLOATBUF0\[21\].Z sky130_fd_sc_hd__ebufn_2
XSLICE_16\[1\].RAM16.SLICE\[0\].RAM8.WORD\[5\].W.BYTE\[2\].B.BIT\[4\].genblk1.STORAGE
+ DIBUF\[20\].X SLICE_16\[1\].RAM16.SLICE\[0\].RAM8.WORD\[5\].W.BYTE\[2\].B.GCLK VGND
+ VGND VPWR VPWR SLICE_16\[1\].RAM16.SLICE\[0\].RAM8.WORD\[5\].W.BYTE\[2\].B.Q_WIRE\[4\]
+ sky130_fd_sc_hd__dlxtp_1
XSLICE_16\[0\].RAM16.SLICE\[1\].RAM8.WORD\[6\].W.BYTE\[0\].B.CGAND SLICE_16\[0\].RAM16.SLICE\[1\].RAM8.WORD\[6\].W.BYTE\[0\].B.SEL0
+ SLICE_16\[0\].RAM16.SLICE\[1\].RAM8.WE0_buf\[0\] VGND VGND VPWR VPWR SLICE_16\[0\].RAM16.SLICE\[1\].RAM8.WORD\[6\].W.BYTE\[0\].B.WE0_WIRE
+ sky130_fd_sc_hd__and2_1
XSLICE_16\[1\].RAM16.SLICE\[0\].RAM8.WORD\[3\].W.BYTE\[0\].B.BIT\[3\].genblk1.STORAGE
+ DIBUF\[3\].X SLICE_16\[1\].RAM16.SLICE\[0\].RAM8.WORD\[3\].W.BYTE\[0\].B.GCLK VGND
+ VGND VPWR VPWR SLICE_16\[1\].RAM16.SLICE\[0\].RAM8.WORD\[3\].W.BYTE\[0\].B.Q_WIRE\[3\]
+ sky130_fd_sc_hd__dlxtp_1
XSLICE_16\[0\].RAM16.SLICE\[1\].RAM8.WORD\[7\].W.BYTE\[2\].B.BIT\[5\].genblk1.STORAGE
+ DIBUF\[21\].X SLICE_16\[0\].RAM16.SLICE\[1\].RAM8.WORD\[7\].W.BYTE\[2\].B.GCLK VGND
+ VGND VPWR VPWR SLICE_16\[0\].RAM16.SLICE\[1\].RAM8.WORD\[7\].W.BYTE\[2\].B.Q_WIRE\[5\]
+ sky130_fd_sc_hd__dlxtp_1
XSLICE_16\[0\].RAM16.SLICE\[1\].RAM8.WORD\[1\].W.BYTE\[3\].B.BIT\[6\].genblk1.STORAGE
+ DIBUF\[30\].X SLICE_16\[0\].RAM16.SLICE\[1\].RAM8.WORD\[1\].W.BYTE\[3\].B.GCLK VGND
+ VGND VPWR VPWR SLICE_16\[0\].RAM16.SLICE\[1\].RAM8.WORD\[1\].W.BYTE\[3\].B.Q_WIRE\[6\]
+ sky130_fd_sc_hd__dlxtp_1
XSLICE_16\[0\].RAM16.SLICE\[1\].RAM8.WORD\[5\].W.BYTE\[0\].B.BIT\[4\].genblk1.STORAGE
+ DIBUF\[4\].X SLICE_16\[0\].RAM16.SLICE\[1\].RAM8.WORD\[5\].W.BYTE\[0\].B.GCLK VGND
+ VGND VPWR VPWR SLICE_16\[0\].RAM16.SLICE\[1\].RAM8.WORD\[5\].W.BYTE\[0\].B.Q_WIRE\[4\]
+ sky130_fd_sc_hd__dlxtp_1
Xfill_22_3 VGND VPWR sky130_fd_sc_hd__tapvpwrvgnd_1
Xfill_15_2 VGND VPWR sky130_fd_sc_hd__tapvpwrvgnd_1
XSLICE_16\[0\].RAM16.SLICE\[0\].RAM8.WORD\[0\].W.BYTE\[3\].B.BIT\[1\].genblk1.STORAGE
+ DIBUF\[25\].X SLICE_16\[0\].RAM16.SLICE\[0\].RAM8.WORD\[0\].W.BYTE\[3\].B.GCLK VGND
+ VGND VPWR VPWR SLICE_16\[0\].RAM16.SLICE\[0\].RAM8.WORD\[0\].W.BYTE\[3\].B.Q_WIRE\[1\]
+ sky130_fd_sc_hd__dlxtp_1
XSLICE_16\[0\].RAM16.SLICE\[0\].RAM8.WORD\[6\].W.BYTE\[2\].B.BIT\[0\].genblk1.STORAGE
+ DIBUF\[16\].X SLICE_16\[0\].RAM16.SLICE\[0\].RAM8.WORD\[6\].W.BYTE\[2\].B.GCLK VGND
+ VGND VPWR VPWR SLICE_16\[0\].RAM16.SLICE\[0\].RAM8.WORD\[6\].W.BYTE\[2\].B.Q_WIRE\[0\]
+ sky130_fd_sc_hd__dlxtp_1
XSLICE_16\[1\].RAM16.SLICE\[1\].RAM8.WORD\[2\].W.BYTE\[0\].B.SEL0INV SLICE_16\[1\].RAM16.SLICE\[1\].RAM8.WORD\[2\].W.BYTE\[0\].B.SEL0
+ VGND VGND VPWR VPWR SLICE_16\[1\].RAM16.SLICE\[1\].RAM8.WORD\[2\].W.BYTE\[0\].B.SEL0_B
+ sky130_fd_sc_hd__inv_1
XSLICE_16\[0\].RAM16.SLICE\[1\].RAM8.WORD\[7\].W.SEL0BUF SLICE_16\[0\].RAM16.SLICE\[1\].RAM8.DEC0.SEL\[7\]
+ VGND VGND VPWR VPWR SLICE_16\[0\].RAM16.SLICE\[1\].RAM8.WORD\[7\].W.BYTE\[0\].B.SEL0
+ sky130_fd_sc_hd__clkbuf_2
XSLICE_16\[0\].RAM16.SLICE\[1\].RAM8.WORD\[1\].W.BYTE\[0\].B.BIT\[2\].OBUF0 SLICE_16\[0\].RAM16.SLICE\[1\].RAM8.WORD\[1\].W.BYTE\[0\].B.Q_WIRE\[2\]
+ SLICE_16\[0\].RAM16.SLICE\[1\].RAM8.WORD\[1\].W.BYTE\[0\].B.SEL0_B VGND VGND VPWR
+ VPWR SLICE_16\[0\].RAM16.BYTE\[0\].FLOATBUF0\[2\].Z sky130_fd_sc_hd__ebufn_2
Xtap_37_9 VGND VPWR sky130_fd_sc_hd__tapvpwrvgnd_1
XSLICE_16\[0\].RAM16.SLICE\[1\].RAM8.WORD\[5\].W.BYTE\[3\].B.BIT\[5\].OBUF0 SLICE_16\[0\].RAM16.SLICE\[1\].RAM8.WORD\[5\].W.BYTE\[3\].B.Q_WIRE\[5\]
+ SLICE_16\[0\].RAM16.SLICE\[1\].RAM8.WORD\[5\].W.BYTE\[3\].B.SEL0_B VGND VGND VPWR
+ VPWR SLICE_16\[0\].RAM16.BYTE\[3\].FLOATBUF0\[29\].Z sky130_fd_sc_hd__ebufn_2
Xtap_2_24 VGND VPWR sky130_fd_sc_hd__tapvpwrvgnd_1
Xtap_2_13 VGND VPWR sky130_fd_sc_hd__tapvpwrvgnd_1
XSLICE_16\[0\].RAM16.DIODE_A0\[1\].__cell__ A0BUF\[1\].X VGND VGND VPWR VPWR sky130_fd_sc_hd__diode_2
Xtap_2_35 VGND VPWR sky130_fd_sc_hd__tapvpwrvgnd_1
Xfill_44_49 VGND VGND VPWR VPWR sky130_fd_sc_hd__decap_12
Xfill_44_38 VGND VGND VPWR VPWR sky130_fd_sc_hd__decap_12
Xfill_44_27 VGND VPWR sky130_fd_sc_hd__tapvpwrvgnd_1
Xfill_44_16 VGND VGND VPWR VPWR sky130_fd_sc_hd__decap_12
XSLICE_16\[0\].RAM16.SLICE\[0\].RAM8.WORD\[0\].W.BYTE\[2\].B.BIT\[4\].OBUF0 SLICE_16\[0\].RAM16.SLICE\[0\].RAM8.WORD\[0\].W.BYTE\[2\].B.Q_WIRE\[4\]
+ SLICE_16\[0\].RAM16.SLICE\[0\].RAM8.WORD\[0\].W.BYTE\[2\].B.SEL0_B VGND VGND VPWR
+ VPWR SLICE_16\[0\].RAM16.BYTE\[2\].FLOATBUF0\[20\].Z sky130_fd_sc_hd__ebufn_2
XSLICE_16\[1\].RAM16.SLICE\[1\].RAM8.WORD\[2\].W.BYTE\[2\].B.BIT\[1\].OBUF0 SLICE_16\[1\].RAM16.SLICE\[1\].RAM8.WORD\[2\].W.BYTE\[2\].B.Q_WIRE\[1\]
+ SLICE_16\[1\].RAM16.SLICE\[1\].RAM8.WORD\[2\].W.BYTE\[2\].B.SEL0_B VGND VGND VPWR
+ VPWR SLICE_16\[1\].RAM16.BYTE\[2\].FLOATBUF0\[17\].Z sky130_fd_sc_hd__ebufn_2
XSLICE_16\[0\].RAM16.SLICE\[1\].RAM8.WORD\[0\].W.BYTE\[1\].B.SEL0INV SLICE_16\[0\].RAM16.SLICE\[1\].RAM8.WORD\[0\].W.BYTE\[0\].B.SEL0
+ VGND VGND VPWR VPWR SLICE_16\[0\].RAM16.SLICE\[1\].RAM8.WORD\[0\].W.BYTE\[1\].B.SEL0_B
+ sky130_fd_sc_hd__inv_1
XSLICE_16\[0\].RAM16.SLICE\[1\].RAM8.WORD\[4\].W.BYTE\[1\].B.BIT\[2\].OBUF0 SLICE_16\[0\].RAM16.SLICE\[1\].RAM8.WORD\[4\].W.BYTE\[1\].B.Q_WIRE\[2\]
+ SLICE_16\[0\].RAM16.SLICE\[1\].RAM8.WORD\[4\].W.BYTE\[1\].B.SEL0_B VGND VGND VPWR
+ VPWR SLICE_16\[0\].RAM16.BYTE\[1\].FLOATBUF0\[10\].Z sky130_fd_sc_hd__ebufn_2
XSLICE_16\[1\].RAM16.SLICE\[0\].RAM8.WORD\[2\].W.BYTE\[1\].B.genblk1.CLKINV SLICE_16\[1\].RAM16.SLICE\[0\].RAM8.WORD\[2\].W.BYTE\[0\].B.CLK
+ VGND VGND VPWR VPWR SLICE_16\[1\].RAM16.SLICE\[0\].RAM8.WORD\[2\].W.BYTE\[1\].B.CLK_B
+ sky130_fd_sc_hd__inv_1
XDo0MUX.M\[1\].DIODE_A1MUX\[9\] Do0MUX.A1\[9\] VGND VGND VPWR VPWR sky130_fd_sc_hd__diode_2
XSLICE_16\[1\].RAM16.SLICE\[1\].RAM8.DEC0.ABUF\[0\] SLICE_16\[1\].RAM16.A0BUF\[0\].X
+ VGND VGND VPWR VPWR SLICE_16\[1\].RAM16.SLICE\[1\].RAM8.DEC0.A_buf\[0\] sky130_fd_sc_hd__clkbuf_2
XSLICE_16\[1\].RAM16.SLICE\[0\].RAM8.WORD\[6\].W.BYTE\[1\].B.BIT\[3\].genblk1.STORAGE
+ DIBUF\[11\].X SLICE_16\[1\].RAM16.SLICE\[0\].RAM8.WORD\[6\].W.BYTE\[1\].B.GCLK VGND
+ VGND VPWR VPWR SLICE_16\[1\].RAM16.SLICE\[0\].RAM8.WORD\[6\].W.BYTE\[1\].B.Q_WIRE\[3\]
+ sky130_fd_sc_hd__dlxtp_1
XSLICE_16\[1\].RAM16.SLICE\[0\].RAM8.WORD\[0\].W.BYTE\[2\].B.BIT\[4\].genblk1.STORAGE
+ DIBUF\[20\].X SLICE_16\[1\].RAM16.SLICE\[0\].RAM8.WORD\[0\].W.BYTE\[2\].B.GCLK VGND
+ VGND VPWR VPWR SLICE_16\[1\].RAM16.SLICE\[0\].RAM8.WORD\[0\].W.BYTE\[2\].B.Q_WIRE\[4\]
+ sky130_fd_sc_hd__dlxtp_1
Xfill_20_0 VGND VPWR sky130_fd_sc_hd__tapvpwrvgnd_1
XSLICE_16\[0\].RAM16.SLICE\[0\].RAM8.WORD\[3\].W.BYTE\[3\].B.BIT\[4\].OBUF0 SLICE_16\[0\].RAM16.SLICE\[0\].RAM8.WORD\[3\].W.BYTE\[3\].B.Q_WIRE\[4\]
+ SLICE_16\[0\].RAM16.SLICE\[0\].RAM8.WORD\[3\].W.BYTE\[3\].B.SEL0_B VGND VGND VPWR
+ VPWR SLICE_16\[0\].RAM16.BYTE\[3\].FLOATBUF0\[28\].Z sky130_fd_sc_hd__ebufn_2
XSLICE_16\[0\].RAM16.SLICE\[0\].RAM8.WORD\[1\].W.BYTE\[0\].B.CGAND SLICE_16\[0\].RAM16.SLICE\[0\].RAM8.WORD\[1\].W.BYTE\[0\].B.SEL0
+ SLICE_16\[0\].RAM16.SLICE\[0\].RAM8.WE0_buf\[0\] VGND VGND VPWR VPWR SLICE_16\[0\].RAM16.SLICE\[0\].RAM8.WORD\[1\].W.BYTE\[0\].B.WE0_WIRE
+ sky130_fd_sc_hd__and2_1
XSLICE_16\[0\].RAM16.SLICE\[1\].RAM8.WORD\[2\].W.BYTE\[2\].B.BIT\[5\].genblk1.STORAGE
+ DIBUF\[21\].X SLICE_16\[0\].RAM16.SLICE\[1\].RAM8.WORD\[2\].W.BYTE\[2\].B.GCLK VGND
+ VGND VPWR VPWR SLICE_16\[0\].RAM16.SLICE\[1\].RAM8.WORD\[2\].W.BYTE\[2\].B.Q_WIRE\[5\]
+ sky130_fd_sc_hd__dlxtp_1
Xfill_39_49 VGND VGND VPWR VPWR sky130_fd_sc_hd__decap_12
Xfill_39_38 VGND VGND VPWR VPWR sky130_fd_sc_hd__decap_12
Xfill_39_27 VGND VPWR sky130_fd_sc_hd__tapvpwrvgnd_1
Xfill_39_16 VGND VGND VPWR VPWR sky130_fd_sc_hd__decap_12
XSLICE_16\[1\].RAM16.SLICE\[1\].RAM8.WORD\[5\].W.BYTE\[3\].B.BIT\[1\].OBUF0 SLICE_16\[1\].RAM16.SLICE\[1\].RAM8.WORD\[5\].W.BYTE\[3\].B.Q_WIRE\[1\]
+ SLICE_16\[1\].RAM16.SLICE\[1\].RAM8.WORD\[5\].W.BYTE\[3\].B.SEL0_B VGND VGND VPWR
+ VPWR SLICE_16\[1\].RAM16.BYTE\[3\].FLOATBUF0\[25\].Z sky130_fd_sc_hd__ebufn_2
Xtap_35_6 VGND VPWR sky130_fd_sc_hd__tapvpwrvgnd_1
Xtap_28_5 VGND VPWR sky130_fd_sc_hd__tapvpwrvgnd_1
XSLICE_16\[0\].RAM16.SLICE\[1\].RAM8.WORD\[0\].W.BYTE\[0\].B.BIT\[4\].genblk1.STORAGE
+ DIBUF\[4\].X SLICE_16\[0\].RAM16.SLICE\[1\].RAM8.WORD\[0\].W.BYTE\[0\].B.GCLK VGND
+ VGND VPWR VPWR SLICE_16\[0\].RAM16.SLICE\[1\].RAM8.WORD\[0\].W.BYTE\[0\].B.Q_WIRE\[4\]
+ sky130_fd_sc_hd__dlxtp_1
Xtap_16_31 VGND VPWR sky130_fd_sc_hd__tapvpwrvgnd_1
Xtap_16_20 VGND VPWR sky130_fd_sc_hd__tapvpwrvgnd_1
XSLICE_16\[0\].RAM16.SLICE\[0\].RAM8.WORD\[1\].W.BYTE\[2\].B.BIT\[0\].genblk1.STORAGE
+ DIBUF\[16\].X SLICE_16\[0\].RAM16.SLICE\[0\].RAM8.WORD\[1\].W.BYTE\[2\].B.GCLK VGND
+ VGND VPWR VPWR SLICE_16\[0\].RAM16.SLICE\[0\].RAM8.WORD\[1\].W.BYTE\[2\].B.Q_WIRE\[0\]
+ sky130_fd_sc_hd__dlxtp_1
XSLICE_16\[0\].RAM16.SLICE\[1\].RAM8.WORD\[2\].W.BYTE\[1\].B.genblk1.CG SLICE_16\[0\].RAM16.SLICE\[1\].RAM8.WORD\[2\].W.BYTE\[1\].B.CLK_B
+ SLICE_16\[0\].RAM16.SLICE\[1\].RAM8.WORD\[2\].W.BYTE\[1\].B.WE0_WIRE VGND VGND VPWR
+ VPWR SLICE_16\[0\].RAM16.SLICE\[1\].RAM8.WORD\[2\].W.BYTE\[1\].B.GCLK sky130_fd_sc_hd__dlclkp_1
XSLICE_16\[1\].RAM16.SLICE\[1\].RAM8.WORD\[2\].W.BYTE\[0\].B.BIT\[6\].OBUF0 SLICE_16\[1\].RAM16.SLICE\[1\].RAM8.WORD\[2\].W.BYTE\[0\].B.Q_WIRE\[6\]
+ SLICE_16\[1\].RAM16.SLICE\[1\].RAM8.WORD\[2\].W.BYTE\[0\].B.SEL0_B VGND VGND VPWR
+ VPWR SLICE_16\[1\].RAM16.BYTE\[0\].FLOATBUF0\[6\].Z sky130_fd_sc_hd__ebufn_2
Xtap_32_30 VGND VPWR sky130_fd_sc_hd__tapvpwrvgnd_1
XSLICE_16\[1\].RAM16.SLICE\[0\].RAM8.WORD\[0\].W.BYTE\[2\].B.BIT\[0\].OBUF0 SLICE_16\[1\].RAM16.SLICE\[0\].RAM8.WORD\[0\].W.BYTE\[2\].B.Q_WIRE\[0\]
+ SLICE_16\[1\].RAM16.SLICE\[0\].RAM8.WORD\[0\].W.BYTE\[2\].B.SEL0_B VGND VGND VPWR
+ VPWR SLICE_16\[1\].RAM16.BYTE\[2\].FLOATBUF0\[16\].Z sky130_fd_sc_hd__ebufn_2
XSLICE_16\[0\].RAM16.SLICE\[1\].RAM8.WORD\[7\].W.BYTE\[2\].B.BIT\[2\].OBUF0 SLICE_16\[0\].RAM16.SLICE\[1\].RAM8.WORD\[7\].W.BYTE\[2\].B.Q_WIRE\[2\]
+ SLICE_16\[0\].RAM16.SLICE\[1\].RAM8.WORD\[7\].W.BYTE\[2\].B.SEL0_B VGND VGND VPWR
+ VPWR SLICE_16\[0\].RAM16.BYTE\[2\].FLOATBUF0\[18\].Z sky130_fd_sc_hd__ebufn_2
XSLICE_16\[1\].RAM16.SLICE\[0\].RAM8.WORD\[5\].W.BYTE\[2\].B.genblk1.CLKINV SLICE_16\[1\].RAM16.SLICE\[0\].RAM8.WORD\[5\].W.BYTE\[0\].B.CLK
+ VGND VGND VPWR VPWR SLICE_16\[1\].RAM16.SLICE\[0\].RAM8.WORD\[5\].W.BYTE\[2\].B.CLK_B
+ sky130_fd_sc_hd__inv_1
Xfill_22_100 VGND VGND VPWR VPWR sky130_fd_sc_hd__decap_12
Xfill_20_62 VGND VGND VPWR VPWR sky130_fd_sc_hd__decap_12
Xfill_20_51 VGND VPWR sky130_fd_sc_hd__tapvpwrvgnd_1
Xfill_20_40 VGND VGND VPWR VPWR sky130_fd_sc_hd__decap_12
XSLICE_16\[0\].RAM16.Do0_REG.OUTREG_BYTE\[3\].DIODE\[7\] SLICE_16\[0\].RAM16.BYTE\[3\].FLOATBUF0\[31\].Z
+ VGND VGND VPWR VPWR sky130_fd_sc_hd__diode_2
Xfill_20_95 VGND VGND VPWR VPWR sky130_fd_sc_hd__decap_12
Xfill_20_84 VGND VPWR sky130_fd_sc_hd__tapvpwrvgnd_1
Xfill_20_73 VGND VGND VPWR VPWR sky130_fd_sc_hd__decap_12
XSLICE_16\[0\].RAM16.SLICE\[0\].RAM8.WORD\[2\].W.BYTE\[1\].B.BIT\[1\].OBUF0 SLICE_16\[0\].RAM16.SLICE\[0\].RAM8.WORD\[2\].W.BYTE\[1\].B.Q_WIRE\[1\]
+ SLICE_16\[0\].RAM16.SLICE\[0\].RAM8.WORD\[2\].W.BYTE\[1\].B.SEL0_B VGND VGND VPWR
+ VPWR SLICE_16\[0\].RAM16.BYTE\[1\].FLOATBUF0\[9\].Z sky130_fd_sc_hd__ebufn_2
Xfill_45_92 VGND VGND VPWR VPWR sky130_fd_sc_hd__decap_12
Xfill_45_81 VGND VPWR sky130_fd_sc_hd__tapvpwrvgnd_1
Xfill_45_70 VGND VGND VPWR VPWR sky130_fd_sc_hd__decap_12
Xtap_37_19 VGND VPWR sky130_fd_sc_hd__tapvpwrvgnd_1
XSLICE_16\[1\].RAM16.SLICE\[1\].RAM8.WORD\[5\].W.BYTE\[1\].B.BIT\[6\].OBUF0 SLICE_16\[1\].RAM16.SLICE\[1\].RAM8.WORD\[5\].W.BYTE\[1\].B.Q_WIRE\[6\]
+ SLICE_16\[1\].RAM16.SLICE\[1\].RAM8.WORD\[5\].W.BYTE\[1\].B.SEL0_B VGND VGND VPWR
+ VPWR SLICE_16\[1\].RAM16.BYTE\[1\].FLOATBUF0\[14\].Z sky130_fd_sc_hd__ebufn_2
XSLICE_16\[1\].RAM16.SLICE\[0\].RAM8.WORD\[3\].W.BYTE\[3\].B.BIT\[0\].OBUF0 SLICE_16\[1\].RAM16.SLICE\[0\].RAM8.WORD\[3\].W.BYTE\[3\].B.Q_WIRE\[0\]
+ SLICE_16\[1\].RAM16.SLICE\[0\].RAM8.WORD\[3\].W.BYTE\[3\].B.SEL0_B VGND VGND VPWR
+ VPWR SLICE_16\[1\].RAM16.BYTE\[3\].FLOATBUF0\[24\].Z sky130_fd_sc_hd__ebufn_2
Xtap_8_12 VGND VPWR sky130_fd_sc_hd__tapvpwrvgnd_1
Xtap_8_23 VGND VPWR sky130_fd_sc_hd__tapvpwrvgnd_1
Xtap_8_34 VGND VPWR sky130_fd_sc_hd__tapvpwrvgnd_1
Xfill_41_39 VGND VPWR sky130_fd_sc_hd__tapvpwrvgnd_1
Xfill_41_28 VGND VGND VPWR VPWR sky130_fd_sc_hd__decap_12
Xfill_41_17 VGND VGND VPWR VPWR sky130_fd_sc_hd__decap_12
Xtap_40_4 VGND VPWR sky130_fd_sc_hd__tapvpwrvgnd_1
Xtap_33_3 VGND VPWR sky130_fd_sc_hd__tapvpwrvgnd_1
XSLICE_16\[1\].RAM16.SLICE\[0\].RAM8.WORD\[3\].W.BYTE\[3\].B.BIT\[4\].genblk1.STORAGE
+ DIBUF\[28\].X SLICE_16\[1\].RAM16.SLICE\[0\].RAM8.WORD\[3\].W.BYTE\[3\].B.GCLK VGND
+ VGND VPWR VPWR SLICE_16\[1\].RAM16.SLICE\[0\].RAM8.WORD\[3\].W.BYTE\[3\].B.Q_WIRE\[4\]
+ sky130_fd_sc_hd__dlxtp_1
Xtap_27_30 VGND VPWR sky130_fd_sc_hd__tapvpwrvgnd_1
Xtap_26_2 VGND VPWR sky130_fd_sc_hd__tapvpwrvgnd_1
XSLICE_16\[1\].RAM16.SLICE\[0\].RAM8.WORD\[0\].W.BYTE\[0\].B.BIT\[5\].OBUF0 SLICE_16\[1\].RAM16.SLICE\[0\].RAM8.WORD\[0\].W.BYTE\[0\].B.Q_WIRE\[5\]
+ SLICE_16\[1\].RAM16.SLICE\[0\].RAM8.WORD\[0\].W.BYTE\[0\].B.SEL0_B VGND VGND VPWR
+ VPWR SLICE_16\[1\].RAM16.BYTE\[0\].FLOATBUF0\[5\].Z sky130_fd_sc_hd__ebufn_2
XSLICE_16\[0\].RAM16.SLICE\[1\].RAM8.WORD\[7\].W.BYTE\[0\].B.BIT\[7\].OBUF0 SLICE_16\[0\].RAM16.SLICE\[1\].RAM8.WORD\[7\].W.BYTE\[0\].B.Q_WIRE\[7\]
+ SLICE_16\[0\].RAM16.SLICE\[1\].RAM8.WORD\[7\].W.BYTE\[0\].B.SEL0_B VGND VGND VPWR
+ VPWR SLICE_16\[0\].RAM16.BYTE\[0\].FLOATBUF0\[7\].Z sky130_fd_sc_hd__ebufn_2
XSLICE_16\[0\].RAM16.SLICE\[0\].RAM8.WORD\[5\].W.BYTE\[2\].B.BIT\[1\].OBUF0 SLICE_16\[0\].RAM16.SLICE\[0\].RAM8.WORD\[5\].W.BYTE\[2\].B.Q_WIRE\[1\]
+ SLICE_16\[0\].RAM16.SLICE\[0\].RAM8.WORD\[5\].W.BYTE\[2\].B.SEL0_B VGND VGND VPWR
+ VPWR SLICE_16\[0\].RAM16.BYTE\[2\].FLOATBUF0\[17\].Z sky130_fd_sc_hd__ebufn_2
XSLICE_16\[1\].RAM16.SLICE\[0\].RAM8.WORD\[7\].W.BYTE\[0\].B.BIT\[2\].genblk1.STORAGE
+ DIBUF\[2\].X SLICE_16\[1\].RAM16.SLICE\[0\].RAM8.WORD\[7\].W.BYTE\[0\].B.GCLK VGND
+ VGND VPWR VPWR SLICE_16\[1\].RAM16.SLICE\[0\].RAM8.WORD\[7\].W.BYTE\[0\].B.Q_WIRE\[2\]
+ sky130_fd_sc_hd__dlxtp_1
XSLICE_16\[1\].RAM16.SLICE\[0\].RAM8.WORD\[1\].W.BYTE\[1\].B.BIT\[3\].genblk1.STORAGE
+ DIBUF\[11\].X SLICE_16\[1\].RAM16.SLICE\[0\].RAM8.WORD\[1\].W.BYTE\[1\].B.GCLK VGND
+ VGND VPWR VPWR SLICE_16\[1\].RAM16.SLICE\[0\].RAM8.WORD\[1\].W.BYTE\[1\].B.Q_WIRE\[3\]
+ sky130_fd_sc_hd__dlxtp_1
XSLICE_16\[0\].RAM16.SLICE\[1\].RAM8.WORD\[5\].W.BYTE\[3\].B.BIT\[5\].genblk1.STORAGE
+ DIBUF\[29\].X SLICE_16\[0\].RAM16.SLICE\[1\].RAM8.WORD\[5\].W.BYTE\[3\].B.GCLK VGND
+ VGND VPWR VPWR SLICE_16\[0\].RAM16.SLICE\[1\].RAM8.WORD\[5\].W.BYTE\[3\].B.Q_WIRE\[5\]
+ sky130_fd_sc_hd__dlxtp_1
XSLICE_16\[0\].RAM16.SLICE\[1\].RAM8.WORD\[2\].W.CLKBUF SLICE_16\[0\].RAM16.SLICE\[1\].RAM8.CLKBUF.X
+ VGND VGND VPWR VPWR SLICE_16\[0\].RAM16.SLICE\[1\].RAM8.WORD\[2\].W.BYTE\[0\].B.CLK
+ sky130_fd_sc_hd__clkbuf_4
XSLICE_16\[0\].RAM16.SLICE\[1\].RAM8.WORD\[3\].W.BYTE\[1\].B.BIT\[4\].genblk1.STORAGE
+ DIBUF\[12\].X SLICE_16\[0\].RAM16.SLICE\[1\].RAM8.WORD\[3\].W.BYTE\[1\].B.GCLK VGND
+ VGND VPWR VPWR SLICE_16\[0\].RAM16.SLICE\[1\].RAM8.WORD\[3\].W.BYTE\[1\].B.Q_WIRE\[4\]
+ sky130_fd_sc_hd__dlxtp_1
XSLICE_16\[0\].RAM16.SLICE\[0\].RAM8.WORD\[4\].W.BYTE\[3\].B.BIT\[0\].genblk1.STORAGE
+ DIBUF\[24\].X SLICE_16\[0\].RAM16.SLICE\[0\].RAM8.WORD\[4\].W.BYTE\[3\].B.GCLK VGND
+ VGND VPWR VPWR SLICE_16\[0\].RAM16.SLICE\[0\].RAM8.WORD\[4\].W.BYTE\[3\].B.Q_WIRE\[0\]
+ sky130_fd_sc_hd__dlxtp_1
Xfill_47_5 VGND VGND VPWR VPWR sky130_fd_sc_hd__decap_12
Xfill_2_5 VGND VPWR sky130_fd_sc_hd__tapvpwrvgnd_1
XSLICE_16\[1\].RAM16.SLICE\[0\].RAM8.WORD\[3\].W.BYTE\[1\].B.BIT\[5\].OBUF0 SLICE_16\[1\].RAM16.SLICE\[0\].RAM8.WORD\[3\].W.BYTE\[1\].B.Q_WIRE\[5\]
+ SLICE_16\[1\].RAM16.SLICE\[0\].RAM8.WORD\[3\].W.BYTE\[1\].B.SEL0_B VGND VGND VPWR
+ VPWR SLICE_16\[1\].RAM16.BYTE\[1\].FLOATBUF0\[13\].Z sky130_fd_sc_hd__ebufn_2
Xtap_12_8 VGND VPWR sky130_fd_sc_hd__tapvpwrvgnd_1
XSLICE_16\[0\].RAM16.SLICE\[1\].RAM8.WORD\[0\].W.BYTE\[3\].B.BIT\[4\].OBUF0 SLICE_16\[0\].RAM16.SLICE\[1\].RAM8.WORD\[0\].W.BYTE\[3\].B.Q_WIRE\[4\]
+ SLICE_16\[0\].RAM16.SLICE\[1\].RAM8.WORD\[0\].W.BYTE\[3\].B.SEL0_B VGND VGND VPWR
+ VPWR SLICE_16\[0\].RAM16.BYTE\[3\].FLOATBUF0\[28\].Z sky130_fd_sc_hd__ebufn_2
Xtap_5_7 VGND VPWR sky130_fd_sc_hd__tapvpwrvgnd_1
Xtap_13_32 VGND VPWR sky130_fd_sc_hd__tapvpwrvgnd_1
Xtap_13_21 VGND VPWR sky130_fd_sc_hd__tapvpwrvgnd_1
Xtap_13_10 VGND VPWR sky130_fd_sc_hd__tapvpwrvgnd_1
XSLICE_16\[0\].RAM16.SLICE\[0\].RAM8.WORD\[5\].W.BYTE\[0\].B.BIT\[6\].OBUF0 SLICE_16\[0\].RAM16.SLICE\[0\].RAM8.WORD\[5\].W.BYTE\[0\].B.Q_WIRE\[6\]
+ SLICE_16\[0\].RAM16.SLICE\[0\].RAM8.WORD\[5\].W.BYTE\[0\].B.SEL0_B VGND VGND VPWR
+ VPWR SLICE_16\[0\].RAM16.BYTE\[0\].FLOATBUF0\[6\].Z sky130_fd_sc_hd__ebufn_2
XSLICE_16\[1\].RAM16.SLICE\[1\].RAM8.WORD\[7\].W.BYTE\[0\].B.BIT\[3\].OBUF0 SLICE_16\[1\].RAM16.SLICE\[1\].RAM8.WORD\[7\].W.BYTE\[0\].B.Q_WIRE\[3\]
+ SLICE_16\[1\].RAM16.SLICE\[1\].RAM8.WORD\[7\].W.BYTE\[0\].B.SEL0_B VGND VGND VPWR
+ VPWR SLICE_16\[1\].RAM16.BYTE\[0\].FLOATBUF0\[3\].Z sky130_fd_sc_hd__ebufn_2
Xtap_31_0 VGND VPWR sky130_fd_sc_hd__tapvpwrvgnd_1
XSLICE_16\[0\].RAM16.SLICE\[0\].RAM8.DEC0.AND0 SLICE_16\[0\].RAM16.SLICE\[0\].RAM8.DEC0.A_buf\[0\]
+ SLICE_16\[0\].RAM16.SLICE\[0\].RAM8.DEC0.A_buf\[1\] SLICE_16\[0\].RAM16.SLICE\[0\].RAM8.DEC0.A_buf\[2\]
+ SLICE_16\[0\].RAM16.SLICE\[0\].RAM8.DEC0.EN_buf VGND VGND VPWR VPWR SLICE_16\[0\].RAM16.SLICE\[0\].RAM8.DEC0.SEL\[0\]
+ sky130_fd_sc_hd__nor4b_2
XSLICE_16\[1\].RAM16.SLICE\[1\].RAM8.WORD\[2\].W.BYTE\[2\].B.genblk1.CLKINV SLICE_16\[1\].RAM16.SLICE\[1\].RAM8.WORD\[2\].W.BYTE\[0\].B.CLK
+ VGND VGND VPWR VPWR SLICE_16\[1\].RAM16.SLICE\[1\].RAM8.WORD\[2\].W.BYTE\[2\].B.CLK_B
+ sky130_fd_sc_hd__inv_1
XSLICE_16\[1\].RAM16.SLICE\[0\].RAM8.WORD\[3\].W.BYTE\[3\].B.CGAND SLICE_16\[1\].RAM16.SLICE\[0\].RAM8.WORD\[3\].W.BYTE\[0\].B.SEL0
+ SLICE_16\[1\].RAM16.SLICE\[0\].RAM8.WE0_buf\[3\] VGND VGND VPWR VPWR SLICE_16\[1\].RAM16.SLICE\[0\].RAM8.WORD\[3\].W.BYTE\[3\].B.WE0_WIRE
+ sky130_fd_sc_hd__and2_1
Xfill_19_9 VGND VPWR sky130_fd_sc_hd__tapvpwrvgnd_1
XDIBUF\[16\].__cell__ Di0[16] VGND VGND VPWR VPWR DIBUF\[16\].X sky130_fd_sc_hd__clkbuf_16
Xfill_42_93 VGND VPWR sky130_fd_sc_hd__tapvpwrvgnd_1
Xfill_42_82 VGND VGND VPWR VPWR sky130_fd_sc_hd__decap_12
Xfill_42_71 VGND VGND VPWR VPWR sky130_fd_sc_hd__decap_12
Xfill_42_60 VGND VPWR sky130_fd_sc_hd__tapvpwrvgnd_1
XSLICE_16\[1\].RAM16.SLICE\[1\].RAM8.WORD\[3\].W.BYTE\[0\].B.BIT\[7\].genblk1.STORAGE
+ DIBUF\[7\].X SLICE_16\[1\].RAM16.SLICE\[1\].RAM8.WORD\[3\].W.BYTE\[0\].B.GCLK VGND
+ VGND VPWR VPWR SLICE_16\[1\].RAM16.SLICE\[1\].RAM8.WORD\[3\].W.BYTE\[0\].B.Q_WIRE\[7\]
+ sky130_fd_sc_hd__dlxtp_1
XDo0MUX.M\[3\].DIODE_A0MUX\[28\] Do0MUX.A0\[28\] VGND VGND VPWR VPWR sky130_fd_sc_hd__diode_2
XSLICE_16\[1\].RAM16.Do0_REG.OUTREG_BYTE\[2\].DIODE\[3\] SLICE_16\[1\].RAM16.BYTE\[2\].FLOATBUF0\[19\].Z
+ VGND VGND VPWR VPWR sky130_fd_sc_hd__diode_2
XSLICE_16\[1\].RAM16.SLICE\[0\].RAM8.WORD\[6\].W.BYTE\[2\].B.BIT\[5\].OBUF0 SLICE_16\[1\].RAM16.SLICE\[0\].RAM8.WORD\[6\].W.BYTE\[2\].B.Q_WIRE\[5\]
+ SLICE_16\[1\].RAM16.SLICE\[0\].RAM8.WORD\[6\].W.BYTE\[2\].B.SEL0_B VGND VGND VPWR
+ VPWR SLICE_16\[1\].RAM16.BYTE\[2\].FLOATBUF0\[21\].Z sky130_fd_sc_hd__ebufn_2
XSLICE_16\[1\].RAM16.SLICE\[0\].RAM8.WORD\[4\].W.BYTE\[2\].B.BIT\[3\].genblk1.STORAGE
+ DIBUF\[19\].X SLICE_16\[1\].RAM16.SLICE\[0\].RAM8.WORD\[4\].W.BYTE\[2\].B.GCLK VGND
+ VGND VPWR VPWR SLICE_16\[1\].RAM16.SLICE\[0\].RAM8.WORD\[4\].W.BYTE\[2\].B.Q_WIRE\[3\]
+ sky130_fd_sc_hd__dlxtp_1
Xfill_45_2 VGND VGND VPWR VPWR sky130_fd_sc_hd__decap_12
Xfill_38_1 VGND VPWR sky130_fd_sc_hd__tapvpwrvgnd_1
XSLICE_16\[1\].RAM16.SLICE\[0\].RAM8.WORD\[2\].W.BYTE\[0\].B.BIT\[2\].genblk1.STORAGE
+ DIBUF\[2\].X SLICE_16\[1\].RAM16.SLICE\[0\].RAM8.WORD\[2\].W.BYTE\[0\].B.GCLK VGND
+ VGND VPWR VPWR SLICE_16\[1\].RAM16.SLICE\[0\].RAM8.WORD\[2\].W.BYTE\[0\].B.Q_WIRE\[2\]
+ sky130_fd_sc_hd__dlxtp_1
XSLICE_16\[0\].RAM16.SLICE\[1\].RAM8.WORD\[6\].W.BYTE\[2\].B.BIT\[4\].genblk1.STORAGE
+ DIBUF\[20\].X SLICE_16\[0\].RAM16.SLICE\[1\].RAM8.WORD\[6\].W.BYTE\[2\].B.GCLK VGND
+ VGND VPWR VPWR SLICE_16\[0\].RAM16.SLICE\[1\].RAM8.WORD\[6\].W.BYTE\[2\].B.Q_WIRE\[4\]
+ sky130_fd_sc_hd__dlxtp_1
XSLICE_16\[0\].RAM16.SLICE\[1\].RAM8.WORD\[4\].W.BYTE\[0\].B.BIT\[3\].genblk1.STORAGE
+ DIBUF\[3\].X SLICE_16\[0\].RAM16.SLICE\[1\].RAM8.WORD\[4\].W.BYTE\[0\].B.GCLK VGND
+ VGND VPWR VPWR SLICE_16\[0\].RAM16.SLICE\[1\].RAM8.WORD\[4\].W.BYTE\[0\].B.Q_WIRE\[3\]
+ sky130_fd_sc_hd__dlxtp_1
Xfill_0_2 VGND VGND VPWR VPWR sky130_fd_sc_hd__decap_12
XSLICE_16\[0\].RAM16.SLICE\[1\].RAM8.WORD\[0\].W.BYTE\[3\].B.BIT\[5\].genblk1.STORAGE
+ DIBUF\[29\].X SLICE_16\[0\].RAM16.SLICE\[1\].RAM8.WORD\[0\].W.BYTE\[3\].B.GCLK VGND
+ VGND VPWR VPWR SLICE_16\[0\].RAM16.SLICE\[1\].RAM8.WORD\[0\].W.BYTE\[3\].B.Q_WIRE\[5\]
+ sky130_fd_sc_hd__dlxtp_1
XSLICE_16\[1\].RAM16.SLICE\[0\].RAM8.WORD\[2\].W.BYTE\[2\].B.DIODE_CLK SLICE_16\[1\].RAM16.SLICE\[0\].RAM8.WORD\[2\].W.BYTE\[0\].B.CLK
+ VGND VGND VPWR VPWR sky130_fd_sc_hd__diode_2
Xfill_22_19 VGND VGND VPWR VPWR sky130_fd_sc_hd__decap_12
XSLICE_16\[1\].RAM16.Do0_REG.Do_CLKBUF\[0\] SLICE_16\[1\].RAM16.Do0_REG.CLK_buf VGND
+ VGND VPWR VPWR SLICE_16\[1\].RAM16.Do0_REG.CLKBUF\[0\] sky130_fd_sc_hd__clkbuf_4
XSLICE_16\[1\].RAM16.SLICE\[1\].RAM8.WORD\[0\].W.BYTE\[3\].B.BIT\[0\].OBUF0 SLICE_16\[1\].RAM16.SLICE\[1\].RAM8.WORD\[0\].W.BYTE\[3\].B.Q_WIRE\[0\]
+ SLICE_16\[1\].RAM16.SLICE\[1\].RAM8.WORD\[0\].W.BYTE\[3\].B.SEL0_B VGND VGND VPWR
+ VPWR SLICE_16\[1\].RAM16.BYTE\[3\].FLOATBUF0\[24\].Z sky130_fd_sc_hd__ebufn_2
Xtap_5_13 VGND VPWR sky130_fd_sc_hd__tapvpwrvgnd_1
Xtap_5_24 VGND VPWR sky130_fd_sc_hd__tapvpwrvgnd_1
Xtap_5_35 VGND VPWR sky130_fd_sc_hd__tapvpwrvgnd_1
Xfill_47_49 VGND VGND VPWR VPWR sky130_fd_sc_hd__decap_12
Xfill_47_38 VGND VGND VPWR VPWR sky130_fd_sc_hd__decap_12
Xfill_47_27 VGND VPWR sky130_fd_sc_hd__tapvpwrvgnd_1
Xfill_47_16 VGND VGND VPWR VPWR sky130_fd_sc_hd__decap_12
XSLICE_16\[1\].RAM16.SLICE\[1\].RAM8.WORD\[5\].W.BYTE\[3\].B.genblk1.CLKINV SLICE_16\[1\].RAM16.SLICE\[1\].RAM8.WORD\[5\].W.BYTE\[0\].B.CLK
+ VGND VGND VPWR VPWR SLICE_16\[1\].RAM16.SLICE\[1\].RAM8.WORD\[5\].W.BYTE\[3\].B.CLK_B
+ sky130_fd_sc_hd__inv_1
Xtap_10_5 VGND VPWR sky130_fd_sc_hd__tapvpwrvgnd_1
XSLICE_16\[1\].RAM16.SLICE\[0\].RAM8.WORD\[5\].W.BYTE\[0\].B.BIT\[2\].OBUF0 SLICE_16\[1\].RAM16.SLICE\[0\].RAM8.WORD\[5\].W.BYTE\[0\].B.Q_WIRE\[2\]
+ SLICE_16\[1\].RAM16.SLICE\[0\].RAM8.WORD\[5\].W.BYTE\[0\].B.SEL0_B VGND VGND VPWR
+ VPWR SLICE_16\[1\].RAM16.BYTE\[0\].FLOATBUF0\[2\].Z sky130_fd_sc_hd__ebufn_2
Xtap_24_31 VGND VPWR sky130_fd_sc_hd__tapvpwrvgnd_1
Xtap_24_20 VGND VPWR sky130_fd_sc_hd__tapvpwrvgnd_1
Xtap_3_4 VGND VPWR sky130_fd_sc_hd__tapvpwrvgnd_1
XSLICE_16\[0\].RAM16.SLICE\[1\].RAM8.WORD\[2\].W.BYTE\[2\].B.BIT\[1\].OBUF0 SLICE_16\[0\].RAM16.SLICE\[1\].RAM8.WORD\[2\].W.BYTE\[2\].B.Q_WIRE\[1\]
+ SLICE_16\[0\].RAM16.SLICE\[1\].RAM8.WORD\[2\].W.BYTE\[2\].B.SEL0_B VGND VGND VPWR
+ VPWR SLICE_16\[0\].RAM16.BYTE\[2\].FLOATBUF0\[17\].Z sky130_fd_sc_hd__ebufn_2
Xtap_40_30 VGND VPWR sky130_fd_sc_hd__tapvpwrvgnd_1
XSLICE_16\[0\].RAM16.BYTE\[3\].FLOATBUF0\[30\].__cell__ SLICE_16\[0\].RAM16.BYTE\[3\].FLOATBUF0\[24\].A
+ SLICE_16\[0\].RAM16.BYTE\[3\].FLOATBUF0\[24\].TE_B VGND VGND VPWR VPWR SLICE_16\[0\].RAM16.BYTE\[3\].FLOATBUF0\[30\].Z
+ sky130_fd_sc_hd__ebufn_2
XSLICE_16\[0\].RAM16.SLICE\[0\].RAM8.WORD\[5\].W.BYTE\[1\].B.DIODE_CLK SLICE_16\[0\].RAM16.SLICE\[0\].RAM8.WORD\[5\].W.BYTE\[0\].B.CLK
+ VGND VGND VPWR VPWR sky130_fd_sc_hd__diode_2
XSLICE_16\[0\].RAM16.SLICE\[0\].RAM8.WORD\[2\].W.BYTE\[1\].B.genblk1.CLKINV SLICE_16\[0\].RAM16.SLICE\[0\].RAM8.WORD\[2\].W.BYTE\[0\].B.CLK
+ VGND VGND VPWR VPWR SLICE_16\[0\].RAM16.SLICE\[0\].RAM8.WORD\[2\].W.BYTE\[1\].B.CLK_B
+ sky130_fd_sc_hd__inv_1
Xfill_17_6 VGND VPWR sky130_fd_sc_hd__tapvpwrvgnd_1
XSLICE_16\[0\].RAM16.SLICE\[1\].RAM8.WORD\[6\].W.SEL0BUF SLICE_16\[0\].RAM16.SLICE\[1\].RAM8.DEC0.SEL\[6\]
+ VGND VGND VPWR VPWR SLICE_16\[0\].RAM16.SLICE\[1\].RAM8.WORD\[6\].W.BYTE\[0\].B.SEL0
+ sky130_fd_sc_hd__clkbuf_2
Xfill_0_21 VGND VGND VPWR VPWR sky130_fd_sc_hd__decap_8
Xfill_0_10 VGND VGND VPWR VPWR sky130_fd_sc_hd__decap_12
XSLICE_16\[1\].RAM16.Do0_REG.OUTREG_BYTE\[1\].Do_FF\[4\] SLICE_16\[1\].RAM16.Do0_REG.CLKBUF\[1\]
+ SLICE_16\[1\].RAM16.BYTE\[1\].FLOATBUF0\[12\].Z VGND VGND VPWR VPWR Do0MUX.A1\[12\]
+ sky130_fd_sc_hd__dfxtp_1
XSLICE_16\[1\].RAM16.SLICE\[1\].RAM8.WORD\[4\].W.BYTE\[2\].B.CGAND SLICE_16\[1\].RAM16.SLICE\[1\].RAM8.WORD\[4\].W.BYTE\[0\].B.SEL0
+ SLICE_16\[1\].RAM16.SLICE\[1\].RAM8.WE0_buf\[2\] VGND VGND VPWR VPWR SLICE_16\[1\].RAM16.SLICE\[1\].RAM8.WORD\[4\].W.BYTE\[2\].B.WE0_WIRE
+ sky130_fd_sc_hd__and2_1
XSLICE_16\[1\].RAM16.SLICE\[1\].RAM8.WORD\[6\].W.BYTE\[1\].B.BIT\[7\].genblk1.STORAGE
+ DIBUF\[15\].X SLICE_16\[1\].RAM16.SLICE\[1\].RAM8.WORD\[6\].W.BYTE\[1\].B.GCLK VGND
+ VGND VPWR VPWR SLICE_16\[1\].RAM16.SLICE\[1\].RAM8.WORD\[6\].W.BYTE\[1\].B.Q_WIRE\[7\]
+ sky130_fd_sc_hd__dlxtp_1
XSLICE_16\[1\].RAM16.SLICE\[1\].RAM8.WORD\[0\].W.BYTE\[1\].B.BIT\[5\].OBUF0 SLICE_16\[1\].RAM16.SLICE\[1\].RAM8.WORD\[0\].W.BYTE\[1\].B.Q_WIRE\[5\]
+ SLICE_16\[1\].RAM16.SLICE\[1\].RAM8.WORD\[0\].W.BYTE\[1\].B.SEL0_B VGND VGND VPWR
+ VPWR SLICE_16\[1\].RAM16.BYTE\[1\].FLOATBUF0\[13\].Z sky130_fd_sc_hd__ebufn_2
XSLICE_16\[1\].RAM16.SLICE\[0\].RAM8.WORD\[7\].W.BYTE\[3\].B.BIT\[3\].genblk1.STORAGE
+ DIBUF\[27\].X SLICE_16\[1\].RAM16.SLICE\[0\].RAM8.WORD\[7\].W.BYTE\[3\].B.GCLK VGND
+ VGND VPWR VPWR SLICE_16\[1\].RAM16.SLICE\[0\].RAM8.WORD\[7\].W.BYTE\[3\].B.Q_WIRE\[3\]
+ sky130_fd_sc_hd__dlxtp_1
Xfill_17_19 VGND VGND VPWR VPWR sky130_fd_sc_hd__decap_12
XSLICE_16\[0\].RAM16.SLICE\[1\].RAM8.WORD\[5\].W.BYTE\[3\].B.BIT\[1\].OBUF0 SLICE_16\[0\].RAM16.SLICE\[1\].RAM8.WORD\[5\].W.BYTE\[3\].B.Q_WIRE\[1\]
+ SLICE_16\[0\].RAM16.SLICE\[1\].RAM8.WORD\[5\].W.BYTE\[3\].B.SEL0_B VGND VGND VPWR
+ VPWR SLICE_16\[0\].RAM16.BYTE\[3\].FLOATBUF0\[25\].Z sky130_fd_sc_hd__ebufn_2
XSLICE_16\[1\].RAM16.SLICE\[0\].RAM8.WORD\[5\].W.BYTE\[1\].B.BIT\[2\].genblk1.STORAGE
+ DIBUF\[10\].X SLICE_16\[1\].RAM16.SLICE\[0\].RAM8.WORD\[5\].W.BYTE\[1\].B.GCLK VGND
+ VGND VPWR VPWR SLICE_16\[1\].RAM16.SLICE\[0\].RAM8.WORD\[5\].W.BYTE\[1\].B.Q_WIRE\[2\]
+ sky130_fd_sc_hd__dlxtp_1
Xtap_10_11 VGND VPWR sky130_fd_sc_hd__tapvpwrvgnd_1
Xtap_10_22 VGND VPWR sky130_fd_sc_hd__tapvpwrvgnd_1
Xtap_10_33 VGND VPWR sky130_fd_sc_hd__tapvpwrvgnd_1
XSLICE_16\[1\].RAM16.SLICE\[1\].RAM8.WORD\[0\].W.BYTE\[3\].B.genblk1.CG SLICE_16\[1\].RAM16.SLICE\[1\].RAM8.WORD\[0\].W.BYTE\[3\].B.CLK_B
+ SLICE_16\[1\].RAM16.SLICE\[1\].RAM8.WORD\[0\].W.BYTE\[3\].B.WE0_WIRE VGND VGND VPWR
+ VPWR SLICE_16\[1\].RAM16.SLICE\[1\].RAM8.WORD\[0\].W.BYTE\[3\].B.GCLK sky130_fd_sc_hd__dlclkp_1
XSLICE_16\[0\].RAM16.Do0_REG.OUTREG_BYTE\[3\].Do_FF\[1\] SLICE_16\[0\].RAM16.Do0_REG.CLKBUF\[3\]
+ SLICE_16\[0\].RAM16.BYTE\[3\].FLOATBUF0\[25\].Z VGND VGND VPWR VPWR Do0MUX.A0\[25\]
+ sky130_fd_sc_hd__dfxtp_1
XSLICE_16\[0\].RAM16.SLICE\[1\].RAM8.WORD\[7\].W.BYTE\[1\].B.BIT\[3\].genblk1.STORAGE
+ DIBUF\[11\].X SLICE_16\[0\].RAM16.SLICE\[1\].RAM8.WORD\[7\].W.BYTE\[1\].B.GCLK VGND
+ VGND VPWR VPWR SLICE_16\[0\].RAM16.SLICE\[1\].RAM8.WORD\[7\].W.BYTE\[1\].B.Q_WIRE\[3\]
+ sky130_fd_sc_hd__dlxtp_1
XSLICE_16\[0\].RAM16.SLICE\[1\].RAM8.WORD\[1\].W.BYTE\[2\].B.BIT\[4\].genblk1.STORAGE
+ DIBUF\[20\].X SLICE_16\[0\].RAM16.SLICE\[1\].RAM8.WORD\[1\].W.BYTE\[2\].B.GCLK VGND
+ VGND VPWR VPWR SLICE_16\[0\].RAM16.SLICE\[1\].RAM8.WORD\[1\].W.BYTE\[2\].B.Q_WIRE\[4\]
+ sky130_fd_sc_hd__dlxtp_1
XSLICE_16\[0\].RAM16.SLICE\[1\].RAM8.WORD\[2\].W.BYTE\[0\].B.BIT\[6\].OBUF0 SLICE_16\[0\].RAM16.SLICE\[1\].RAM8.WORD\[2\].W.BYTE\[0\].B.Q_WIRE\[6\]
+ SLICE_16\[0\].RAM16.SLICE\[1\].RAM8.WORD\[2\].W.BYTE\[0\].B.SEL0_B VGND VGND VPWR
+ VPWR SLICE_16\[0\].RAM16.BYTE\[0\].FLOATBUF0\[6\].Z sky130_fd_sc_hd__ebufn_2
Xtap_35_30 VGND VPWR sky130_fd_sc_hd__tapvpwrvgnd_1
XSLICE_16\[0\].RAM16.SLICE\[0\].RAM8.WORD\[0\].W.BYTE\[2\].B.BIT\[0\].OBUF0 SLICE_16\[0\].RAM16.SLICE\[0\].RAM8.WORD\[0\].W.BYTE\[2\].B.Q_WIRE\[0\]
+ SLICE_16\[0\].RAM16.SLICE\[0\].RAM8.WORD\[0\].W.BYTE\[2\].B.SEL0_B VGND VGND VPWR
+ VPWR SLICE_16\[0\].RAM16.BYTE\[2\].FLOATBUF0\[16\].Z sky130_fd_sc_hd__ebufn_2
Xtap_1_1 VGND VPWR sky130_fd_sc_hd__tapvpwrvgnd_1
XSLICE_16\[0\].RAM16.SLICE\[0\].RAM8.WORD\[5\].W.BYTE\[2\].B.genblk1.CLKINV SLICE_16\[0\].RAM16.SLICE\[0\].RAM8.WORD\[5\].W.BYTE\[0\].B.CLK
+ VGND VGND VPWR VPWR SLICE_16\[0\].RAM16.SLICE\[0\].RAM8.WORD\[5\].W.BYTE\[2\].B.CLK_B
+ sky130_fd_sc_hd__inv_1
XSLICE_16\[0\].RAM16.SLICE\[1\].RAM8.WORD\[0\].W.BYTE\[0\].B.SEL0INV SLICE_16\[0\].RAM16.SLICE\[1\].RAM8.WORD\[0\].W.BYTE\[0\].B.SEL0
+ VGND VGND VPWR VPWR SLICE_16\[0\].RAM16.SLICE\[1\].RAM8.WORD\[0\].W.BYTE\[0\].B.SEL0_B
+ sky130_fd_sc_hd__inv_1
XSLICE_16\[1\].RAM16.SLICE\[1\].RAM8.WORD\[4\].W.BYTE\[2\].B.DIODE_CLK SLICE_16\[1\].RAM16.SLICE\[1\].RAM8.WORD\[4\].W.BYTE\[0\].B.CLK
+ VGND VGND VPWR VPWR sky130_fd_sc_hd__diode_2
XSLICE_16\[1\].RAM16.SLICE\[1\].RAM8.WORD\[3\].W.BYTE\[2\].B.BIT\[5\].OBUF0 SLICE_16\[1\].RAM16.SLICE\[1\].RAM8.WORD\[3\].W.BYTE\[2\].B.Q_WIRE\[5\]
+ SLICE_16\[1\].RAM16.SLICE\[1\].RAM8.WORD\[3\].W.BYTE\[2\].B.SEL0_B VGND VGND VPWR
+ VPWR SLICE_16\[1\].RAM16.BYTE\[2\].FLOATBUF0\[21\].Z sky130_fd_sc_hd__ebufn_2
XSLICE_16\[1\].RAM16.SLICE\[0\].RAM8.WORD\[7\].W.BYTE\[2\].B.genblk1.CG SLICE_16\[1\].RAM16.SLICE\[0\].RAM8.WORD\[7\].W.BYTE\[2\].B.CLK_B
+ SLICE_16\[1\].RAM16.SLICE\[0\].RAM8.WORD\[7\].W.BYTE\[2\].B.WE0_WIRE VGND VGND VPWR
+ VPWR SLICE_16\[1\].RAM16.SLICE\[0\].RAM8.WORD\[7\].W.BYTE\[2\].B.GCLK sky130_fd_sc_hd__dlclkp_1
Xfill_22_4 VGND VGND VPWR VPWR sky130_fd_sc_hd__decap_12
Xfill_15_3 VGND VGND VPWR VPWR sky130_fd_sc_hd__decap_6
XSLICE_16\[0\].RAM16.SLICE\[1\].RAM8.WORD\[5\].W.BYTE\[1\].B.BIT\[6\].OBUF0 SLICE_16\[0\].RAM16.SLICE\[1\].RAM8.WORD\[5\].W.BYTE\[1\].B.Q_WIRE\[6\]
+ SLICE_16\[0\].RAM16.SLICE\[1\].RAM8.WORD\[5\].W.BYTE\[1\].B.SEL0_B VGND VGND VPWR
+ VPWR SLICE_16\[0\].RAM16.BYTE\[1\].FLOATBUF0\[14\].Z sky130_fd_sc_hd__ebufn_2
Xtap_2_25 VGND VPWR sky130_fd_sc_hd__tapvpwrvgnd_1
Xtap_2_14 VGND VPWR sky130_fd_sc_hd__tapvpwrvgnd_1
XSLICE_16\[0\].RAM16.SLICE\[0\].RAM8.WORD\[3\].W.BYTE\[3\].B.BIT\[0\].OBUF0 SLICE_16\[0\].RAM16.SLICE\[0\].RAM8.WORD\[3\].W.BYTE\[3\].B.Q_WIRE\[0\]
+ SLICE_16\[0\].RAM16.SLICE\[0\].RAM8.WORD\[3\].W.BYTE\[3\].B.SEL0_B VGND VGND VPWR
+ VPWR SLICE_16\[0\].RAM16.BYTE\[3\].FLOATBUF0\[24\].Z sky130_fd_sc_hd__ebufn_2
Xfill_44_39 VGND VPWR sky130_fd_sc_hd__tapvpwrvgnd_1
Xfill_44_28 VGND VGND VPWR VPWR sky130_fd_sc_hd__decap_12
Xfill_44_17 VGND VGND VPWR VPWR sky130_fd_sc_hd__decap_12
XSLICE_16\[0\].RAM16.Do0_REG.OUTREG_BYTE\[0\].DIODE\[4\] SLICE_16\[0\].RAM16.BYTE\[0\].FLOATBUF0\[4\].Z
+ VGND VGND VPWR VPWR sky130_fd_sc_hd__diode_2
XSLICE_16\[0\].RAM16.SLICE\[1\].RAM8.WORD\[7\].W.BYTE\[1\].B.DIODE_CLK SLICE_16\[0\].RAM16.SLICE\[1\].RAM8.WORD\[7\].W.BYTE\[0\].B.CLK
+ VGND VGND VPWR VPWR sky130_fd_sc_hd__diode_2
XSLICE_16\[0\].RAM16.SLICE\[0\].RAM8.WORD\[0\].W.BYTE\[0\].B.BIT\[5\].OBUF0 SLICE_16\[0\].RAM16.SLICE\[0\].RAM8.WORD\[0\].W.BYTE\[0\].B.Q_WIRE\[5\]
+ SLICE_16\[0\].RAM16.SLICE\[0\].RAM8.WORD\[0\].W.BYTE\[0\].B.SEL0_B VGND VGND VPWR
+ VPWR SLICE_16\[0\].RAM16.BYTE\[0\].FLOATBUF0\[5\].Z sky130_fd_sc_hd__ebufn_2
XSLICE_16\[1\].RAM16.SLICE\[1\].RAM8.WORD\[2\].W.BYTE\[0\].B.BIT\[2\].OBUF0 SLICE_16\[1\].RAM16.SLICE\[1\].RAM8.WORD\[2\].W.BYTE\[0\].B.Q_WIRE\[2\]
+ SLICE_16\[1\].RAM16.SLICE\[1\].RAM8.WORD\[2\].W.BYTE\[0\].B.SEL0_B VGND VGND VPWR
+ VPWR SLICE_16\[1\].RAM16.BYTE\[0\].FLOATBUF0\[2\].Z sky130_fd_sc_hd__ebufn_2
XSLICE_16\[0\].RAM16.BYTE\[0\].FLOATBUF0\[7\].__cell__ SLICE_16\[0\].RAM16.BYTE\[0\].FLOATBUF0\[0\].A
+ SLICE_16\[0\].RAM16.BYTE\[0\].FLOATBUF0\[0\].TE_B VGND VGND VPWR VPWR SLICE_16\[0\].RAM16.BYTE\[0\].FLOATBUF0\[7\].Z
+ sky130_fd_sc_hd__ebufn_2
XSLICE_16\[1\].RAM16.SLICE\[1\].RAM8.WORD\[7\].W.BYTE\[0\].B.BIT\[6\].genblk1.STORAGE
+ DIBUF\[6\].X SLICE_16\[1\].RAM16.SLICE\[1\].RAM8.WORD\[7\].W.BYTE\[0\].B.GCLK VGND
+ VGND VPWR VPWR SLICE_16\[1\].RAM16.SLICE\[1\].RAM8.WORD\[7\].W.BYTE\[0\].B.Q_WIRE\[6\]
+ sky130_fd_sc_hd__dlxtp_1
XSLICE_16\[1\].RAM16.SLICE\[1\].RAM8.WORD\[6\].W.BYTE\[3\].B.BIT\[5\].OBUF0 SLICE_16\[1\].RAM16.SLICE\[1\].RAM8.WORD\[6\].W.BYTE\[3\].B.Q_WIRE\[5\]
+ SLICE_16\[1\].RAM16.SLICE\[1\].RAM8.WORD\[6\].W.BYTE\[3\].B.SEL0_B VGND VGND VPWR
+ VPWR SLICE_16\[1\].RAM16.BYTE\[3\].FLOATBUF0\[29\].Z sky130_fd_sc_hd__ebufn_2
XSLICE_16\[1\].RAM16.SLICE\[1\].RAM8.WORD\[1\].W.BYTE\[1\].B.BIT\[7\].genblk1.STORAGE
+ DIBUF\[15\].X SLICE_16\[1\].RAM16.SLICE\[1\].RAM8.WORD\[1\].W.BYTE\[1\].B.GCLK VGND
+ VGND VPWR VPWR SLICE_16\[1\].RAM16.SLICE\[1\].RAM8.WORD\[1\].W.BYTE\[1\].B.Q_WIRE\[7\]
+ sky130_fd_sc_hd__dlxtp_1
XSLICE_16\[1\].RAM16.SLICE\[0\].RAM8.WORD\[2\].W.BYTE\[3\].B.BIT\[3\].genblk1.STORAGE
+ DIBUF\[27\].X SLICE_16\[1\].RAM16.SLICE\[0\].RAM8.WORD\[2\].W.BYTE\[3\].B.GCLK VGND
+ VGND VPWR VPWR SLICE_16\[1\].RAM16.SLICE\[0\].RAM8.WORD\[2\].W.BYTE\[3\].B.Q_WIRE\[3\]
+ sky130_fd_sc_hd__dlxtp_1
XSLICE_16\[1\].RAM16.SLICE\[0\].RAM8.WORD\[6\].W.BYTE\[0\].B.BIT\[1\].genblk1.STORAGE
+ DIBUF\[1\].X SLICE_16\[1\].RAM16.SLICE\[0\].RAM8.WORD\[6\].W.BYTE\[0\].B.GCLK VGND
+ VGND VPWR VPWR SLICE_16\[1\].RAM16.SLICE\[0\].RAM8.WORD\[6\].W.BYTE\[0\].B.Q_WIRE\[1\]
+ sky130_fd_sc_hd__dlxtp_1
XSLICE_16\[1\].RAM16.SLICE\[0\].RAM8.WORD\[0\].W.BYTE\[1\].B.BIT\[2\].genblk1.STORAGE
+ DIBUF\[10\].X SLICE_16\[1\].RAM16.SLICE\[0\].RAM8.WORD\[0\].W.BYTE\[1\].B.GCLK VGND
+ VGND VPWR VPWR SLICE_16\[1\].RAM16.SLICE\[0\].RAM8.WORD\[0\].W.BYTE\[1\].B.Q_WIRE\[2\]
+ sky130_fd_sc_hd__dlxtp_1
XSLICE_16\[0\].RAM16.SLICE\[1\].RAM8.WORD\[4\].W.BYTE\[3\].B.BIT\[4\].genblk1.STORAGE
+ DIBUF\[28\].X SLICE_16\[0\].RAM16.SLICE\[1\].RAM8.WORD\[4\].W.BYTE\[3\].B.GCLK VGND
+ VGND VPWR VPWR SLICE_16\[0\].RAM16.SLICE\[1\].RAM8.WORD\[4\].W.BYTE\[3\].B.Q_WIRE\[4\]
+ sky130_fd_sc_hd__dlxtp_1
XSLICE_16\[0\].RAM16.SLICE\[0\].RAM8.WEBUF\[1\].__cell__ SLICE_16\[0\].RAM16.SLICE\[0\].RAM8.WE0\[1\]
+ VGND VGND VPWR VPWR SLICE_16\[0\].RAM16.SLICE\[0\].RAM8.WE0_buf\[1\] sky130_fd_sc_hd__clkbuf_2
XSLICE_16\[1\].RAM16.SLICE\[0\].RAM8.WORD\[1\].W.BYTE\[2\].B.BIT\[4\].OBUF0 SLICE_16\[1\].RAM16.SLICE\[0\].RAM8.WORD\[1\].W.BYTE\[2\].B.Q_WIRE\[4\]
+ SLICE_16\[1\].RAM16.SLICE\[0\].RAM8.WORD\[1\].W.BYTE\[2\].B.SEL0_B VGND VGND VPWR
+ VPWR SLICE_16\[1\].RAM16.BYTE\[2\].FLOATBUF0\[20\].Z sky130_fd_sc_hd__ebufn_2
XSLICE_16\[0\].RAM16.SLICE\[1\].RAM8.WORD\[2\].W.BYTE\[1\].B.BIT\[3\].genblk1.STORAGE
+ DIBUF\[11\].X SLICE_16\[0\].RAM16.SLICE\[1\].RAM8.WORD\[2\].W.BYTE\[1\].B.GCLK VGND
+ VGND VPWR VPWR SLICE_16\[0\].RAM16.SLICE\[1\].RAM8.WORD\[2\].W.BYTE\[1\].B.Q_WIRE\[3\]
+ sky130_fd_sc_hd__dlxtp_1
Xfill_20_1 VGND VGND VPWR VPWR sky130_fd_sc_hd__decap_12
Xfill_13_0 VGND VPWR sky130_fd_sc_hd__tapvpwrvgnd_1
XSLICE_16\[0\].RAM16.SLICE\[0\].RAM8.WORD\[3\].W.BYTE\[1\].B.BIT\[5\].OBUF0 SLICE_16\[0\].RAM16.SLICE\[0\].RAM8.WORD\[3\].W.BYTE\[1\].B.Q_WIRE\[5\]
+ SLICE_16\[0\].RAM16.SLICE\[0\].RAM8.WORD\[3\].W.BYTE\[1\].B.SEL0_B VGND VGND VPWR
+ VPWR SLICE_16\[0\].RAM16.BYTE\[1\].FLOATBUF0\[13\].Z sky130_fd_sc_hd__ebufn_2
Xfill_39_39 VGND VPWR sky130_fd_sc_hd__tapvpwrvgnd_1
Xfill_39_28 VGND VGND VPWR VPWR sky130_fd_sc_hd__decap_12
Xfill_39_17 VGND VGND VPWR VPWR sky130_fd_sc_hd__decap_12
XSLICE_16\[1\].RAM16.SLICE\[1\].RAM8.WORD\[5\].W.BYTE\[1\].B.BIT\[2\].OBUF0 SLICE_16\[1\].RAM16.SLICE\[1\].RAM8.WORD\[5\].W.BYTE\[1\].B.Q_WIRE\[2\]
+ SLICE_16\[1\].RAM16.SLICE\[1\].RAM8.WORD\[5\].W.BYTE\[1\].B.SEL0_B VGND VGND VPWR
+ VPWR SLICE_16\[1\].RAM16.BYTE\[1\].FLOATBUF0\[10\].Z sky130_fd_sc_hd__ebufn_2
Xtap_35_7 VGND VPWR sky130_fd_sc_hd__tapvpwrvgnd_1
Xtap_28_6 VGND VPWR sky130_fd_sc_hd__tapvpwrvgnd_1
Xtap_16_32 VGND VPWR sky130_fd_sc_hd__tapvpwrvgnd_1
Xtap_16_21 VGND VPWR sky130_fd_sc_hd__tapvpwrvgnd_1
Xtap_16_10 VGND VPWR sky130_fd_sc_hd__tapvpwrvgnd_1
XSLICE_16\[0\].RAM16.SLICE\[0\].RAM8.WORD\[5\].W.CLKBUF SLICE_16\[0\].RAM16.SLICE\[0\].RAM8.CLKBUF.X
+ VGND VGND VPWR VPWR SLICE_16\[0\].RAM16.SLICE\[0\].RAM8.WORD\[5\].W.BYTE\[0\].B.CLK
+ sky130_fd_sc_hd__clkbuf_4
XDo0MUX.M\[0\].DIODE_A0MUX\[6\] Do0MUX.A0\[6\] VGND VGND VPWR VPWR sky130_fd_sc_hd__diode_2
Xtap_32_31 VGND VPWR sky130_fd_sc_hd__tapvpwrvgnd_1
Xtap_32_20 VGND VPWR sky130_fd_sc_hd__tapvpwrvgnd_1
XSLICE_16\[1\].RAM16.SLICE\[0\].RAM8.WORD\[0\].W.BYTE\[0\].B.BIT\[1\].OBUF0 SLICE_16\[1\].RAM16.SLICE\[0\].RAM8.WORD\[0\].W.BYTE\[0\].B.Q_WIRE\[1\]
+ SLICE_16\[1\].RAM16.SLICE\[0\].RAM8.WORD\[0\].W.BYTE\[0\].B.SEL0_B VGND VGND VPWR
+ VPWR SLICE_16\[1\].RAM16.BYTE\[0\].FLOATBUF0\[1\].Z sky130_fd_sc_hd__ebufn_2
Xfill_22_101 VGND VGND VPWR VPWR sky130_fd_sc_hd__decap_12
XSLICE_16\[0\].RAM16.SLICE\[1\].RAM8.WORD\[7\].W.BYTE\[0\].B.BIT\[3\].OBUF0 SLICE_16\[0\].RAM16.SLICE\[1\].RAM8.WORD\[7\].W.BYTE\[0\].B.Q_WIRE\[3\]
+ SLICE_16\[0\].RAM16.SLICE\[1\].RAM8.WORD\[7\].W.BYTE\[0\].B.SEL0_B VGND VGND VPWR
+ VPWR SLICE_16\[0\].RAM16.BYTE\[0\].FLOATBUF0\[3\].Z sky130_fd_sc_hd__ebufn_2
XSLICE_16\[1\].RAM16.SLICE\[0\].RAM8.WORD\[4\].W.BYTE\[3\].B.BIT\[4\].OBUF0 SLICE_16\[1\].RAM16.SLICE\[0\].RAM8.WORD\[4\].W.BYTE\[3\].B.Q_WIRE\[4\]
+ SLICE_16\[1\].RAM16.SLICE\[0\].RAM8.WORD\[4\].W.BYTE\[3\].B.SEL0_B VGND VGND VPWR
+ VPWR SLICE_16\[1\].RAM16.BYTE\[3\].FLOATBUF0\[28\].Z sky130_fd_sc_hd__ebufn_2
Xfill_20_96 VGND VPWR sky130_fd_sc_hd__tapvpwrvgnd_1
Xfill_20_85 VGND VGND VPWR VPWR sky130_fd_sc_hd__decap_12
Xfill_20_74 VGND VGND VPWR VPWR sky130_fd_sc_hd__decap_12
Xfill_20_63 VGND VPWR sky130_fd_sc_hd__tapvpwrvgnd_1
Xfill_20_52 VGND VGND VPWR VPWR sky130_fd_sc_hd__decap_12
Xfill_20_41 VGND VGND VPWR VPWR sky130_fd_sc_hd__decap_12
Xfill_20_30 VGND VPWR sky130_fd_sc_hd__tapvpwrvgnd_1
XSLICE_16\[0\].RAM16.SLICE\[1\].RAM8.WORD\[2\].W.BYTE\[2\].B.genblk1.CLKINV SLICE_16\[0\].RAM16.SLICE\[1\].RAM8.WORD\[2\].W.BYTE\[0\].B.CLK
+ VGND VGND VPWR VPWR SLICE_16\[0\].RAM16.SLICE\[1\].RAM8.WORD\[2\].W.BYTE\[2\].B.CLK_B
+ sky130_fd_sc_hd__inv_1
XSLICE_16\[1\].RAM16.SLICE\[1\].RAM8.WORD\[0\].W.BYTE\[1\].B.CGAND SLICE_16\[1\].RAM16.SLICE\[1\].RAM8.WORD\[0\].W.BYTE\[0\].B.SEL0
+ SLICE_16\[1\].RAM16.SLICE\[1\].RAM8.WE0_buf\[1\] VGND VGND VPWR VPWR SLICE_16\[1\].RAM16.SLICE\[1\].RAM8.WORD\[0\].W.BYTE\[1\].B.WE0_WIRE
+ sky130_fd_sc_hd__and2_1
Xfill_45_93 VGND VPWR sky130_fd_sc_hd__tapvpwrvgnd_1
Xfill_45_82 VGND VGND VPWR VPWR sky130_fd_sc_hd__decap_12
Xfill_45_71 VGND VGND VPWR VPWR sky130_fd_sc_hd__decap_12
Xfill_45_60 VGND VPWR sky130_fd_sc_hd__tapvpwrvgnd_1
XSLICE_16\[0\].RAM16.SLICE\[0\].RAM8.WORD\[6\].W.BYTE\[2\].B.BIT\[5\].OBUF0 SLICE_16\[0\].RAM16.SLICE\[0\].RAM8.WORD\[6\].W.BYTE\[2\].B.Q_WIRE\[5\]
+ SLICE_16\[0\].RAM16.SLICE\[0\].RAM8.WORD\[6\].W.BYTE\[2\].B.SEL0_B VGND VGND VPWR
+ VPWR SLICE_16\[0\].RAM16.BYTE\[2\].FLOATBUF0\[21\].Z sky130_fd_sc_hd__ebufn_2
XSLICE_16\[1\].RAM16.SLICE\[1\].RAM8.WORD\[4\].W.BYTE\[2\].B.BIT\[7\].genblk1.STORAGE
+ DIBUF\[23\].X SLICE_16\[1\].RAM16.SLICE\[1\].RAM8.WORD\[4\].W.BYTE\[2\].B.GCLK VGND
+ VGND VPWR VPWR SLICE_16\[1\].RAM16.SLICE\[1\].RAM8.WORD\[4\].W.BYTE\[2\].B.Q_WIRE\[7\]
+ sky130_fd_sc_hd__dlxtp_1
XSLICE_16\[1\].RAM16.SLICE\[1\].RAM8.WORD\[2\].W.BYTE\[0\].B.BIT\[6\].genblk1.STORAGE
+ DIBUF\[6\].X SLICE_16\[1\].RAM16.SLICE\[1\].RAM8.WORD\[2\].W.BYTE\[0\].B.GCLK VGND
+ VGND VPWR VPWR SLICE_16\[1\].RAM16.SLICE\[1\].RAM8.WORD\[2\].W.BYTE\[0\].B.Q_WIRE\[6\]
+ sky130_fd_sc_hd__dlxtp_1
XSLICE_16\[1\].RAM16.SLICE\[1\].RAM8.WORD\[7\].W.SEL0BUF SLICE_16\[1\].RAM16.SLICE\[1\].RAM8.DEC0.SEL\[7\]
+ VGND VGND VPWR VPWR SLICE_16\[1\].RAM16.SLICE\[1\].RAM8.WORD\[7\].W.BYTE\[0\].B.SEL0
+ sky130_fd_sc_hd__clkbuf_2
XSLICE_16\[1\].RAM16.SLICE\[0\].RAM8.WORD\[3\].W.BYTE\[2\].B.BIT\[2\].genblk1.STORAGE
+ DIBUF\[18\].X SLICE_16\[1\].RAM16.SLICE\[0\].RAM8.WORD\[3\].W.BYTE\[2\].B.GCLK VGND
+ VGND VPWR VPWR SLICE_16\[1\].RAM16.SLICE\[0\].RAM8.WORD\[3\].W.BYTE\[2\].B.Q_WIRE\[2\]
+ sky130_fd_sc_hd__dlxtp_1
Xfill_41_29 VGND VGND VPWR VPWR sky130_fd_sc_hd__decap_12
Xfill_41_18 VGND VPWR sky130_fd_sc_hd__tapvpwrvgnd_1
XSLICE_16\[1\].RAM16.SLICE\[0\].RAM8.WORD\[3\].W.BYTE\[1\].B.BIT\[1\].OBUF0 SLICE_16\[1\].RAM16.SLICE\[0\].RAM8.WORD\[3\].W.BYTE\[1\].B.Q_WIRE\[1\]
+ SLICE_16\[1\].RAM16.SLICE\[0\].RAM8.WORD\[3\].W.BYTE\[1\].B.SEL0_B VGND VGND VPWR
+ VPWR SLICE_16\[1\].RAM16.BYTE\[1\].FLOATBUF0\[9\].Z sky130_fd_sc_hd__ebufn_2
XSLICE_16\[1\].RAM16.SLICE\[0\].RAM8.WORD\[1\].W.BYTE\[0\].B.BIT\[1\].genblk1.STORAGE
+ DIBUF\[1\].X SLICE_16\[1\].RAM16.SLICE\[0\].RAM8.WORD\[1\].W.BYTE\[0\].B.GCLK VGND
+ VGND VPWR VPWR SLICE_16\[1\].RAM16.SLICE\[0\].RAM8.WORD\[1\].W.BYTE\[0\].B.Q_WIRE\[1\]
+ sky130_fd_sc_hd__dlxtp_1
XSLICE_16\[0\].RAM16.SLICE\[1\].RAM8.WORD\[5\].W.BYTE\[3\].B.genblk1.CLKINV SLICE_16\[0\].RAM16.SLICE\[1\].RAM8.WORD\[5\].W.BYTE\[0\].B.CLK
+ VGND VGND VPWR VPWR SLICE_16\[0\].RAM16.SLICE\[1\].RAM8.WORD\[5\].W.BYTE\[3\].B.CLK_B
+ sky130_fd_sc_hd__inv_1
XSLICE_16\[0\].RAM16.SLICE\[1\].RAM8.WORD\[5\].W.BYTE\[2\].B.BIT\[3\].genblk1.STORAGE
+ DIBUF\[19\].X SLICE_16\[0\].RAM16.SLICE\[1\].RAM8.WORD\[5\].W.BYTE\[2\].B.GCLK VGND
+ VGND VPWR VPWR SLICE_16\[0\].RAM16.SLICE\[1\].RAM8.WORD\[5\].W.BYTE\[2\].B.Q_WIRE\[3\]
+ sky130_fd_sc_hd__dlxtp_1
Xtap_8_13 VGND VPWR sky130_fd_sc_hd__tapvpwrvgnd_1
Xtap_8_24 VGND VPWR sky130_fd_sc_hd__tapvpwrvgnd_1
Xtap_8_35 VGND VPWR sky130_fd_sc_hd__tapvpwrvgnd_1
XSLICE_16\[0\].RAM16.SLICE\[1\].RAM8.WORD\[0\].W.BYTE\[3\].B.BIT\[0\].OBUF0 SLICE_16\[0\].RAM16.SLICE\[1\].RAM8.WORD\[0\].W.BYTE\[3\].B.Q_WIRE\[0\]
+ SLICE_16\[0\].RAM16.SLICE\[1\].RAM8.WORD\[0\].W.BYTE\[3\].B.SEL0_B VGND VGND VPWR
+ VPWR SLICE_16\[0\].RAM16.BYTE\[3\].FLOATBUF0\[24\].Z sky130_fd_sc_hd__ebufn_2
Xtap_40_5 VGND VPWR sky130_fd_sc_hd__tapvpwrvgnd_1
Xtap_33_4 VGND VPWR sky130_fd_sc_hd__tapvpwrvgnd_1
XSLICE_16\[0\].RAM16.SLICE\[1\].RAM8.WORD\[3\].W.BYTE\[0\].B.BIT\[2\].genblk1.STORAGE
+ DIBUF\[2\].X SLICE_16\[0\].RAM16.SLICE\[1\].RAM8.WORD\[3\].W.BYTE\[0\].B.GCLK VGND
+ VGND VPWR VPWR SLICE_16\[0\].RAM16.SLICE\[1\].RAM8.WORD\[3\].W.BYTE\[0\].B.Q_WIRE\[2\]
+ sky130_fd_sc_hd__dlxtp_1
Xtap_27_31 VGND VPWR sky130_fd_sc_hd__tapvpwrvgnd_1
Xtap_27_20 VGND VPWR sky130_fd_sc_hd__tapvpwrvgnd_1
Xtap_26_3 VGND VPWR sky130_fd_sc_hd__tapvpwrvgnd_1
XSLICE_16\[0\].RAM16.SLICE\[0\].RAM8.WORD\[5\].W.BYTE\[0\].B.BIT\[2\].OBUF0 SLICE_16\[0\].RAM16.SLICE\[0\].RAM8.WORD\[5\].W.BYTE\[0\].B.Q_WIRE\[2\]
+ SLICE_16\[0\].RAM16.SLICE\[0\].RAM8.WORD\[5\].W.BYTE\[0\].B.SEL0_B VGND VGND VPWR
+ VPWR SLICE_16\[0\].RAM16.BYTE\[0\].FLOATBUF0\[2\].Z sky130_fd_sc_hd__ebufn_2
XSLICE_16\[0\].RAM16.SLICE\[1\].RAM8.WORD\[2\].W.BYTE\[3\].B.CGAND SLICE_16\[0\].RAM16.SLICE\[1\].RAM8.WORD\[2\].W.BYTE\[0\].B.SEL0
+ SLICE_16\[0\].RAM16.SLICE\[1\].RAM8.WE0_buf\[3\] VGND VGND VPWR VPWR SLICE_16\[0\].RAM16.SLICE\[1\].RAM8.WORD\[2\].W.BYTE\[3\].B.WE0_WIRE
+ sky130_fd_sc_hd__and2_1
Xfill_47_6 VGND VPWR sky130_fd_sc_hd__tapvpwrvgnd_1
XDo0MUX.M\[1\].DIODE_A0MUX\[13\] Do0MUX.A0\[13\] VGND VGND VPWR VPWR sky130_fd_sc_hd__diode_2
XSLICE_16\[1\].RAM16.SLICE\[0\].RAM8.WORD\[6\].W.BYTE\[2\].B.BIT\[1\].OBUF0 SLICE_16\[1\].RAM16.SLICE\[0\].RAM8.WORD\[6\].W.BYTE\[2\].B.Q_WIRE\[1\]
+ SLICE_16\[1\].RAM16.SLICE\[0\].RAM8.WORD\[6\].W.BYTE\[2\].B.SEL0_B VGND VGND VPWR
+ VPWR SLICE_16\[1\].RAM16.BYTE\[2\].FLOATBUF0\[17\].Z sky130_fd_sc_hd__ebufn_2
Xfill_2_6 VGND VGND VPWR VPWR sky130_fd_sc_hd__decap_6
XSLICE_16\[0\].RAM16.SLICE\[0\].RAM8.WORD\[6\].W.BYTE\[2\].B.genblk1.CG SLICE_16\[0\].RAM16.SLICE\[0\].RAM8.WORD\[6\].W.BYTE\[2\].B.CLK_B
+ SLICE_16\[0\].RAM16.SLICE\[0\].RAM8.WORD\[6\].W.BYTE\[2\].B.WE0_WIRE VGND VGND VPWR
+ VPWR SLICE_16\[0\].RAM16.SLICE\[0\].RAM8.WORD\[6\].W.BYTE\[2\].B.GCLK sky130_fd_sc_hd__dlclkp_1
Xtap_12_9 VGND VPWR sky130_fd_sc_hd__tapvpwrvgnd_1
XSLICE_16\[0\].RAM16.SLICE\[1\].RAM8.WORD\[0\].W.BYTE\[1\].B.BIT\[5\].OBUF0 SLICE_16\[0\].RAM16.SLICE\[1\].RAM8.WORD\[0\].W.BYTE\[1\].B.Q_WIRE\[5\]
+ SLICE_16\[0\].RAM16.SLICE\[1\].RAM8.WORD\[0\].W.BYTE\[1\].B.SEL0_B VGND VGND VPWR
+ VPWR SLICE_16\[0\].RAM16.BYTE\[1\].FLOATBUF0\[13\].Z sky130_fd_sc_hd__ebufn_2
XSLICE_16\[1\].RAM16.SLICE\[1\].RAM8.WORD\[7\].W.BYTE\[3\].B.BIT\[7\].genblk1.STORAGE
+ DIBUF\[31\].X SLICE_16\[1\].RAM16.SLICE\[1\].RAM8.WORD\[7\].W.BYTE\[3\].B.GCLK VGND
+ VGND VPWR VPWR SLICE_16\[1\].RAM16.SLICE\[1\].RAM8.WORD\[7\].W.BYTE\[3\].B.Q_WIRE\[7\]
+ sky130_fd_sc_hd__dlxtp_1
Xtap_13_33 VGND VPWR sky130_fd_sc_hd__tapvpwrvgnd_1
Xtap_13_22 VGND VPWR sky130_fd_sc_hd__tapvpwrvgnd_1
Xtap_13_11 VGND VPWR sky130_fd_sc_hd__tapvpwrvgnd_1
Xtap_5_8 VGND VPWR sky130_fd_sc_hd__tapvpwrvgnd_1
XSLICE_16\[0\].RAM16.SLICE\[0\].RAM8.WORD\[6\].W.BYTE\[0\].B.CGAND SLICE_16\[0\].RAM16.SLICE\[0\].RAM8.WORD\[6\].W.BYTE\[0\].B.SEL0
+ SLICE_16\[0\].RAM16.SLICE\[0\].RAM8.WE0_buf\[0\] VGND VGND VPWR VPWR SLICE_16\[0\].RAM16.SLICE\[0\].RAM8.WORD\[6\].W.BYTE\[0\].B.WE0_WIRE
+ sky130_fd_sc_hd__and2_1
XDo0MUX.M\[2\].DIODE_A0MUX\[17\] Do0MUX.A0\[17\] VGND VGND VPWR VPWR sky130_fd_sc_hd__diode_2
XSLICE_16\[1\].RAM16.SLICE\[1\].RAM8.WORD\[5\].W.BYTE\[1\].B.BIT\[6\].genblk1.STORAGE
+ DIBUF\[14\].X SLICE_16\[1\].RAM16.SLICE\[1\].RAM8.WORD\[5\].W.BYTE\[1\].B.GCLK VGND
+ VGND VPWR VPWR SLICE_16\[1\].RAM16.SLICE\[1\].RAM8.WORD\[5\].W.BYTE\[1\].B.Q_WIRE\[6\]
+ sky130_fd_sc_hd__dlxtp_1
XSLICE_16\[0\].RAM16.SLICE\[0\].RAM8.DEC0.AND1 SLICE_16\[0\].RAM16.SLICE\[0\].RAM8.DEC0.A_buf\[2\]
+ SLICE_16\[0\].RAM16.SLICE\[0\].RAM8.DEC0.A_buf\[1\] SLICE_16\[0\].RAM16.SLICE\[0\].RAM8.DEC0.A_buf\[0\]
+ SLICE_16\[0\].RAM16.SLICE\[0\].RAM8.DEC0.EN_buf VGND VGND VPWR VPWR SLICE_16\[0\].RAM16.SLICE\[0\].RAM8.DEC0.SEL\[1\]
+ sky130_fd_sc_hd__and4bb_2
XDo0MUX.M\[0\].DIODE_A1MUX\[0\] Do0MUX.A1\[0\] VGND VGND VPWR VPWR sky130_fd_sc_hd__diode_2
Xtap_38_30 VGND VPWR sky130_fd_sc_hd__tapvpwrvgnd_1
Xtap_31_1 VGND VPWR sky130_fd_sc_hd__tapvpwrvgnd_1
XSLICE_16\[1\].RAM16.SLICE\[0\].RAM8.WORD\[6\].W.BYTE\[3\].B.BIT\[2\].genblk1.STORAGE
+ DIBUF\[26\].X SLICE_16\[1\].RAM16.SLICE\[0\].RAM8.WORD\[6\].W.BYTE\[3\].B.GCLK VGND
+ VGND VPWR VPWR SLICE_16\[1\].RAM16.SLICE\[0\].RAM8.WORD\[6\].W.BYTE\[3\].B.Q_WIRE\[2\]
+ sky130_fd_sc_hd__dlxtp_1
Xtap_24_0 VGND VPWR sky130_fd_sc_hd__tapvpwrvgnd_1
XSLICE_16\[1\].RAM16.SLICE\[1\].RAM8.WORD\[1\].W.BYTE\[3\].B.BIT\[4\].OBUF0 SLICE_16\[1\].RAM16.SLICE\[1\].RAM8.WORD\[1\].W.BYTE\[3\].B.Q_WIRE\[4\]
+ SLICE_16\[1\].RAM16.SLICE\[1\].RAM8.WORD\[1\].W.BYTE\[3\].B.SEL0_B VGND VGND VPWR
+ VPWR SLICE_16\[1\].RAM16.BYTE\[3\].FLOATBUF0\[28\].Z sky130_fd_sc_hd__ebufn_2
XSLICE_16\[1\].RAM16.SLICE\[0\].RAM8.WORD\[4\].W.BYTE\[1\].B.BIT\[1\].genblk1.STORAGE
+ DIBUF\[9\].X SLICE_16\[1\].RAM16.SLICE\[0\].RAM8.WORD\[4\].W.BYTE\[1\].B.GCLK VGND
+ VGND VPWR VPWR SLICE_16\[1\].RAM16.SLICE\[0\].RAM8.WORD\[4\].W.BYTE\[1\].B.Q_WIRE\[1\]
+ sky130_fd_sc_hd__dlxtp_1
XSLICE_16\[0\].RAM16.SLICE\[1\].RAM8.WORD\[6\].W.BYTE\[1\].B.BIT\[2\].genblk1.STORAGE
+ DIBUF\[10\].X SLICE_16\[0\].RAM16.SLICE\[1\].RAM8.WORD\[6\].W.BYTE\[1\].B.GCLK VGND
+ VGND VPWR VPWR SLICE_16\[0\].RAM16.SLICE\[1\].RAM8.WORD\[6\].W.BYTE\[1\].B.Q_WIRE\[2\]
+ sky130_fd_sc_hd__dlxtp_1
XSLICE_16\[1\].RAM16.Do0_REG.OUTREG_BYTE\[3\].DIODE\[7\] SLICE_16\[1\].RAM16.BYTE\[3\].FLOATBUF0\[31\].Z
+ VGND VGND VPWR VPWR sky130_fd_sc_hd__diode_2
XSLICE_16\[1\].RAM16.SLICE\[0\].RAM8.WORD\[3\].W.BYTE\[1\].B.genblk1.CG SLICE_16\[1\].RAM16.SLICE\[0\].RAM8.WORD\[3\].W.BYTE\[1\].B.CLK_B
+ SLICE_16\[1\].RAM16.SLICE\[0\].RAM8.WORD\[3\].W.BYTE\[1\].B.WE0_WIRE VGND VGND VPWR
+ VPWR SLICE_16\[1\].RAM16.SLICE\[0\].RAM8.WORD\[3\].W.BYTE\[1\].B.GCLK sky130_fd_sc_hd__dlclkp_1
XSLICE_16\[0\].RAM16.TIE0\[0\].__cell__ VGND VGND VPWR VPWR SLICE_16\[0\].RAM16.TIE0\[0\].__cell__/HI
+ SLICE_16\[0\].RAM16.BYTE\[0\].FLOATBUF0\[0\].A sky130_fd_sc_hd__conb_1
XSLICE_16\[0\].RAM16.SLICE\[1\].RAM8.WORD\[5\].W.SEL0BUF SLICE_16\[0\].RAM16.SLICE\[1\].RAM8.DEC0.SEL\[5\]
+ VGND VGND VPWR VPWR SLICE_16\[0\].RAM16.SLICE\[1\].RAM8.WORD\[5\].W.BYTE\[0\].B.SEL0
+ sky130_fd_sc_hd__clkbuf_2
XSLICE_16\[0\].RAM16.SLICE\[1\].RAM8.WORD\[0\].W.BYTE\[2\].B.BIT\[3\].genblk1.STORAGE
+ DIBUF\[19\].X SLICE_16\[0\].RAM16.SLICE\[1\].RAM8.WORD\[0\].W.BYTE\[2\].B.GCLK VGND
+ VGND VPWR VPWR SLICE_16\[0\].RAM16.SLICE\[1\].RAM8.WORD\[0\].W.BYTE\[2\].B.Q_WIRE\[3\]
+ sky130_fd_sc_hd__dlxtp_1
Xfill_42_94 VGND VGND VPWR VPWR sky130_fd_sc_hd__decap_12
Xfill_42_83 VGND VGND VPWR VPWR sky130_fd_sc_hd__decap_12
Xfill_42_72 VGND VPWR sky130_fd_sc_hd__tapvpwrvgnd_1
Xfill_42_61 VGND VGND VPWR VPWR sky130_fd_sc_hd__decap_12
Xfill_42_50 VGND VGND VPWR VPWR sky130_fd_sc_hd__decap_12
Xfill_45_3 VGND VPWR sky130_fd_sc_hd__tapvpwrvgnd_1
XSLICE_16\[1\].RAM16.SLICE\[0\].RAM8.WORD\[6\].W.BYTE\[0\].B.BIT\[6\].OBUF0 SLICE_16\[1\].RAM16.SLICE\[0\].RAM8.WORD\[6\].W.BYTE\[0\].B.Q_WIRE\[6\]
+ SLICE_16\[1\].RAM16.SLICE\[0\].RAM8.WORD\[6\].W.BYTE\[0\].B.SEL0_B VGND VGND VPWR
+ VPWR SLICE_16\[1\].RAM16.BYTE\[0\].FLOATBUF0\[6\].Z sky130_fd_sc_hd__ebufn_2
XSLICE_16\[0\].RAM16.SLICE\[1\].RAM8.WORD\[3\].W.BYTE\[2\].B.BIT\[5\].OBUF0 SLICE_16\[0\].RAM16.SLICE\[1\].RAM8.WORD\[3\].W.BYTE\[2\].B.Q_WIRE\[5\]
+ SLICE_16\[0\].RAM16.SLICE\[1\].RAM8.WORD\[3\].W.BYTE\[2\].B.SEL0_B VGND VGND VPWR
+ VPWR SLICE_16\[0\].RAM16.BYTE\[2\].FLOATBUF0\[21\].Z sky130_fd_sc_hd__ebufn_2
Xfill_38_2 VGND VGND VPWR VPWR sky130_fd_sc_hd__decap_3
Xfill_0_3 VGND VPWR sky130_fd_sc_hd__tapvpwrvgnd_1
Xtap_5_14 VGND VPWR sky130_fd_sc_hd__tapvpwrvgnd_1
Xtap_5_25 VGND VPWR sky130_fd_sc_hd__tapvpwrvgnd_1
Xtap_5_36 VGND VPWR sky130_fd_sc_hd__tapvpwrvgnd_1
XSLICE_16\[1\].RAM16.SLICE\[1\].RAM8.WORD\[0\].W.BYTE\[1\].B.BIT\[1\].OBUF0 SLICE_16\[1\].RAM16.SLICE\[1\].RAM8.WORD\[0\].W.BYTE\[1\].B.Q_WIRE\[1\]
+ SLICE_16\[1\].RAM16.SLICE\[1\].RAM8.WORD\[0\].W.BYTE\[1\].B.SEL0_B VGND VGND VPWR
+ VPWR SLICE_16\[1\].RAM16.BYTE\[1\].FLOATBUF0\[9\].Z sky130_fd_sc_hd__ebufn_2
Xfill_47_39 VGND VPWR sky130_fd_sc_hd__tapvpwrvgnd_1
Xfill_47_28 VGND VGND VPWR VPWR sky130_fd_sc_hd__decap_12
Xfill_47_17 VGND VGND VPWR VPWR sky130_fd_sc_hd__decap_12
Xtap_24_10 VGND VPWR sky130_fd_sc_hd__tapvpwrvgnd_1
Xtap_3_5 VGND VPWR sky130_fd_sc_hd__tapvpwrvgnd_1
Xtap_10_6 VGND VPWR sky130_fd_sc_hd__tapvpwrvgnd_1
Xtap_40_20 VGND VPWR sky130_fd_sc_hd__tapvpwrvgnd_1
Xtap_24_32 VGND VPWR sky130_fd_sc_hd__tapvpwrvgnd_1
Xtap_24_21 VGND VPWR sky130_fd_sc_hd__tapvpwrvgnd_1
XSLICE_16\[0\].RAM16.SLICE\[1\].RAM8.WORD\[2\].W.BYTE\[0\].B.BIT\[2\].OBUF0 SLICE_16\[0\].RAM16.SLICE\[1\].RAM8.WORD\[2\].W.BYTE\[0\].B.Q_WIRE\[2\]
+ SLICE_16\[0\].RAM16.SLICE\[1\].RAM8.WORD\[2\].W.BYTE\[0\].B.SEL0_B VGND VGND VPWR
+ VPWR SLICE_16\[0\].RAM16.BYTE\[0\].FLOATBUF0\[2\].Z sky130_fd_sc_hd__ebufn_2
XSLICE_16\[1\].RAM16.DIODE_A0\[1\].__cell__ A0BUF\[1\].X VGND VGND VPWR VPWR sky130_fd_sc_hd__diode_2
XSLICE_16\[1\].RAM16.SLICE\[0\].RAM8.WORD\[0\].W.BYTE\[0\].B.genblk1.CLKINV SLICE_16\[1\].RAM16.SLICE\[0\].RAM8.WORD\[0\].W.BYTE\[0\].B.CLK
+ VGND VGND VPWR VPWR SLICE_16\[1\].RAM16.SLICE\[0\].RAM8.WORD\[0\].W.BYTE\[0\].B.CLK_B
+ sky130_fd_sc_hd__inv_1
XSLICE_16\[0\].RAM16.SLICE\[1\].RAM8.WORD\[6\].W.BYTE\[3\].B.BIT\[5\].OBUF0 SLICE_16\[0\].RAM16.SLICE\[1\].RAM8.WORD\[6\].W.BYTE\[3\].B.Q_WIRE\[5\]
+ SLICE_16\[0\].RAM16.SLICE\[1\].RAM8.WORD\[6\].W.BYTE\[3\].B.SEL0_B VGND VGND VPWR
+ VPWR SLICE_16\[0\].RAM16.BYTE\[3\].FLOATBUF0\[29\].Z sky130_fd_sc_hd__ebufn_2
XSLICE_16\[1\].RAM16.SLICE\[1\].RAM8.WORD\[2\].W.BYTE\[3\].B.BIT\[7\].genblk1.STORAGE
+ DIBUF\[31\].X SLICE_16\[1\].RAM16.SLICE\[1\].RAM8.WORD\[2\].W.BYTE\[3\].B.GCLK VGND
+ VGND VPWR VPWR SLICE_16\[1\].RAM16.SLICE\[1\].RAM8.WORD\[2\].W.BYTE\[3\].B.Q_WIRE\[7\]
+ sky130_fd_sc_hd__dlxtp_1
Xfill_17_7 VGND VGND VPWR VPWR sky130_fd_sc_hd__decap_12
XSLICE_16\[0\].RAM16.BYTE\[2\].FLOATBUF0\[22\].__cell__ SLICE_16\[0\].RAM16.BYTE\[2\].FLOATBUF0\[16\].A
+ SLICE_16\[0\].RAM16.BYTE\[2\].FLOATBUF0\[16\].TE_B VGND VGND VPWR VPWR SLICE_16\[0\].RAM16.BYTE\[2\].FLOATBUF0\[22\].Z
+ sky130_fd_sc_hd__ebufn_2
XSLICE_16\[1\].RAM16.SLICE\[1\].RAM8.WORD\[6\].W.BYTE\[0\].B.BIT\[5\].genblk1.STORAGE
+ DIBUF\[5\].X SLICE_16\[1\].RAM16.SLICE\[1\].RAM8.WORD\[6\].W.BYTE\[0\].B.GCLK VGND
+ VGND VPWR VPWR SLICE_16\[1\].RAM16.SLICE\[1\].RAM8.WORD\[6\].W.BYTE\[0\].B.Q_WIRE\[5\]
+ sky130_fd_sc_hd__dlxtp_1
XSLICE_16\[1\].RAM16.SLICE\[1\].RAM8.WORD\[0\].W.BYTE\[1\].B.BIT\[6\].genblk1.STORAGE
+ DIBUF\[14\].X SLICE_16\[1\].RAM16.SLICE\[1\].RAM8.WORD\[0\].W.BYTE\[1\].B.GCLK VGND
+ VGND VPWR VPWR SLICE_16\[1\].RAM16.SLICE\[1\].RAM8.WORD\[0\].W.BYTE\[1\].B.Q_WIRE\[6\]
+ sky130_fd_sc_hd__dlxtp_1
XSLICE_16\[1\].RAM16.SLICE\[0\].RAM8.WORD\[7\].W.BYTE\[2\].B.BIT\[1\].genblk1.STORAGE
+ DIBUF\[17\].X SLICE_16\[1\].RAM16.SLICE\[0\].RAM8.WORD\[7\].W.BYTE\[2\].B.GCLK VGND
+ VGND VPWR VPWR SLICE_16\[1\].RAM16.SLICE\[0\].RAM8.WORD\[7\].W.BYTE\[2\].B.Q_WIRE\[1\]
+ sky130_fd_sc_hd__dlxtp_1
XSLICE_16\[0\].RAM16.SLICE\[0\].RAM8.WORD\[1\].W.BYTE\[2\].B.BIT\[4\].OBUF0 SLICE_16\[0\].RAM16.SLICE\[0\].RAM8.WORD\[1\].W.BYTE\[2\].B.Q_WIRE\[4\]
+ SLICE_16\[0\].RAM16.SLICE\[0\].RAM8.WORD\[1\].W.BYTE\[2\].B.SEL0_B VGND VGND VPWR
+ VPWR SLICE_16\[0\].RAM16.BYTE\[2\].FLOATBUF0\[20\].Z sky130_fd_sc_hd__ebufn_2
Xfill_0_22 VGND VPWR sky130_fd_sc_hd__tapvpwrvgnd_1
Xfill_0_11 VGND VGND VPWR VPWR sky130_fd_sc_hd__decap_12
XSLICE_16\[1\].RAM16.SLICE\[1\].RAM8.WORD\[3\].W.BYTE\[2\].B.BIT\[1\].OBUF0 SLICE_16\[1\].RAM16.SLICE\[1\].RAM8.WORD\[3\].W.BYTE\[2\].B.Q_WIRE\[1\]
+ SLICE_16\[1\].RAM16.SLICE\[1\].RAM8.WORD\[3\].W.BYTE\[2\].B.SEL0_B VGND VGND VPWR
+ VPWR SLICE_16\[1\].RAM16.BYTE\[2\].FLOATBUF0\[17\].Z sky130_fd_sc_hd__ebufn_2
XSLICE_16\[1\].RAM16.SLICE\[0\].RAM8.WORD\[5\].W.BYTE\[0\].B.BIT\[0\].genblk1.STORAGE
+ DIBUF\[0\].X SLICE_16\[1\].RAM16.SLICE\[0\].RAM8.WORD\[5\].W.BYTE\[0\].B.GCLK VGND
+ VGND VPWR VPWR SLICE_16\[1\].RAM16.SLICE\[0\].RAM8.WORD\[5\].W.BYTE\[0\].B.Q_WIRE\[0\]
+ sky130_fd_sc_hd__dlxtp_1
XSLICE_16\[1\].RAM16.SLICE\[0\].RAM8.WORD\[1\].W.BYTE\[3\].B.BIT\[2\].genblk1.STORAGE
+ DIBUF\[26\].X SLICE_16\[1\].RAM16.SLICE\[0\].RAM8.WORD\[1\].W.BYTE\[3\].B.GCLK VGND
+ VGND VPWR VPWR SLICE_16\[1\].RAM16.SLICE\[0\].RAM8.WORD\[1\].W.BYTE\[3\].B.Q_WIRE\[2\]
+ sky130_fd_sc_hd__dlxtp_1
XSLICE_16\[0\].RAM16.SLICE\[1\].RAM8.WORD\[3\].W.BYTE\[3\].B.BIT\[3\].genblk1.STORAGE
+ DIBUF\[27\].X SLICE_16\[0\].RAM16.SLICE\[1\].RAM8.WORD\[3\].W.BYTE\[3\].B.GCLK VGND
+ VGND VPWR VPWR SLICE_16\[0\].RAM16.SLICE\[1\].RAM8.WORD\[3\].W.BYTE\[3\].B.Q_WIRE\[3\]
+ sky130_fd_sc_hd__dlxtp_1
Xfill_43_0 VGND VPWR sky130_fd_sc_hd__tapvpwrvgnd_1
XSLICE_16\[0\].RAM16.SLICE\[1\].RAM8.WORD\[7\].W.BYTE\[0\].B.BIT\[1\].genblk1.STORAGE
+ DIBUF\[1\].X SLICE_16\[0\].RAM16.SLICE\[1\].RAM8.WORD\[7\].W.BYTE\[0\].B.GCLK VGND
+ VGND VPWR VPWR SLICE_16\[0\].RAM16.SLICE\[1\].RAM8.WORD\[7\].W.BYTE\[0\].B.Q_WIRE\[1\]
+ sky130_fd_sc_hd__dlxtp_1
XSLICE_16\[0\].RAM16.SLICE\[1\].RAM8.WORD\[1\].W.BYTE\[1\].B.BIT\[2\].genblk1.STORAGE
+ DIBUF\[10\].X SLICE_16\[0\].RAM16.SLICE\[1\].RAM8.WORD\[1\].W.BYTE\[1\].B.GCLK VGND
+ VGND VPWR VPWR SLICE_16\[0\].RAM16.SLICE\[1\].RAM8.WORD\[1\].W.BYTE\[1\].B.Q_WIRE\[2\]
+ sky130_fd_sc_hd__dlxtp_1
Xfill_46_140 VGND VGND VPWR VPWR sky130_fd_sc_hd__decap_12
XSLICE_16\[0\].RAM16.SLICE\[1\].RAM8.WORD\[5\].W.BYTE\[1\].B.BIT\[2\].OBUF0 SLICE_16\[0\].RAM16.SLICE\[1\].RAM8.WORD\[5\].W.BYTE\[1\].B.Q_WIRE\[2\]
+ SLICE_16\[0\].RAM16.SLICE\[1\].RAM8.WORD\[5\].W.BYTE\[1\].B.SEL0_B VGND VGND VPWR
+ VPWR SLICE_16\[0\].RAM16.BYTE\[1\].FLOATBUF0\[10\].Z sky130_fd_sc_hd__ebufn_2
XSLICE_16\[1\].RAM16.SLICE\[0\].RAM8.WORD\[3\].W.BYTE\[1\].B.genblk1.CLKINV SLICE_16\[1\].RAM16.SLICE\[0\].RAM8.WORD\[3\].W.BYTE\[0\].B.CLK
+ VGND VGND VPWR VPWR SLICE_16\[1\].RAM16.SLICE\[0\].RAM8.WORD\[3\].W.BYTE\[1\].B.CLK_B
+ sky130_fd_sc_hd__inv_1
Xtap_10_12 VGND VPWR sky130_fd_sc_hd__tapvpwrvgnd_1
Xtap_10_23 VGND VPWR sky130_fd_sc_hd__tapvpwrvgnd_1
Xtap_10_34 VGND VPWR sky130_fd_sc_hd__tapvpwrvgnd_1
Xtap_35_31 VGND VPWR sky130_fd_sc_hd__tapvpwrvgnd_1
Xtap_35_20 VGND VPWR sky130_fd_sc_hd__tapvpwrvgnd_1
XSLICE_16\[1\].RAM16.SLICE\[0\].RAM8.WORD\[1\].W.BYTE\[0\].B.DIODE_CLK SLICE_16\[1\].RAM16.SLICE\[0\].RAM8.WORD\[1\].W.BYTE\[0\].B.CLK
+ VGND VGND VPWR VPWR sky130_fd_sc_hd__diode_2
XSLICE_16\[0\].RAM16.SLICE\[0\].RAM8.WORD\[0\].W.BYTE\[0\].B.BIT\[1\].OBUF0 SLICE_16\[0\].RAM16.SLICE\[0\].RAM8.WORD\[0\].W.BYTE\[0\].B.Q_WIRE\[1\]
+ SLICE_16\[0\].RAM16.SLICE\[0\].RAM8.WORD\[0\].W.BYTE\[0\].B.SEL0_B VGND VGND VPWR
+ VPWR SLICE_16\[0\].RAM16.BYTE\[0\].FLOATBUF0\[1\].Z sky130_fd_sc_hd__ebufn_2
Xtap_1_2 VGND VPWR sky130_fd_sc_hd__tapvpwrvgnd_1
XSLICE_16\[0\].RAM16.SLICE\[0\].RAM8.DEC0.ABUF\[2\] SLICE_16\[0\].RAM16.A0BUF\[2\].X
+ VGND VGND VPWR VPWR SLICE_16\[0\].RAM16.SLICE\[0\].RAM8.DEC0.A_buf\[2\] sky130_fd_sc_hd__clkbuf_2
XSLICE_16\[0\].RAM16.SLICE\[0\].RAM8.WORD\[4\].W.BYTE\[0\].B.BIT\[7\].genblk1.STORAGE
+ DIBUF\[7\].X SLICE_16\[0\].RAM16.SLICE\[0\].RAM8.WORD\[4\].W.BYTE\[0\].B.GCLK VGND
+ VGND VPWR VPWR SLICE_16\[0\].RAM16.SLICE\[0\].RAM8.WORD\[4\].W.BYTE\[0\].B.Q_WIRE\[7\]
+ sky130_fd_sc_hd__dlxtp_1
XSLICE_16\[0\].RAM16.SLICE\[0\].RAM8.WORD\[4\].W.BYTE\[3\].B.BIT\[4\].OBUF0 SLICE_16\[0\].RAM16.SLICE\[0\].RAM8.WORD\[4\].W.BYTE\[3\].B.Q_WIRE\[4\]
+ SLICE_16\[0\].RAM16.SLICE\[0\].RAM8.WORD\[4\].W.BYTE\[3\].B.SEL0_B VGND VGND VPWR
+ VPWR SLICE_16\[0\].RAM16.BYTE\[3\].FLOATBUF0\[28\].Z sky130_fd_sc_hd__ebufn_2
XSLICE_16\[1\].RAM16.SLICE\[1\].RAM8.WORD\[6\].W.BYTE\[3\].B.BIT\[1\].OBUF0 SLICE_16\[1\].RAM16.SLICE\[1\].RAM8.WORD\[6\].W.BYTE\[3\].B.Q_WIRE\[1\]
+ SLICE_16\[1\].RAM16.SLICE\[1\].RAM8.WORD\[6\].W.BYTE\[3\].B.SEL0_B VGND VGND VPWR
+ VPWR SLICE_16\[1\].RAM16.BYTE\[3\].FLOATBUF0\[25\].Z sky130_fd_sc_hd__ebufn_2
XSLICE_16\[1\].RAM16.SLICE\[1\].RAM8.WORD\[3\].W.BYTE\[0\].B.BIT\[6\].OBUF0 SLICE_16\[1\].RAM16.SLICE\[1\].RAM8.WORD\[3\].W.BYTE\[0\].B.Q_WIRE\[6\]
+ SLICE_16\[1\].RAM16.SLICE\[1\].RAM8.WORD\[3\].W.BYTE\[0\].B.SEL0_B VGND VGND VPWR
+ VPWR SLICE_16\[1\].RAM16.BYTE\[0\].FLOATBUF0\[6\].Z sky130_fd_sc_hd__ebufn_2
XSLICE_16\[1\].RAM16.SLICE\[0\].RAM8.WORD\[1\].W.BYTE\[2\].B.BIT\[0\].OBUF0 SLICE_16\[1\].RAM16.SLICE\[0\].RAM8.WORD\[1\].W.BYTE\[2\].B.Q_WIRE\[0\]
+ SLICE_16\[1\].RAM16.SLICE\[0\].RAM8.WORD\[1\].W.BYTE\[2\].B.SEL0_B VGND VGND VPWR
+ VPWR SLICE_16\[1\].RAM16.BYTE\[2\].FLOATBUF0\[16\].Z sky130_fd_sc_hd__ebufn_2
Xfill_22_5 VGND VGND VPWR VPWR sky130_fd_sc_hd__decap_12
Xfill_15_4 VGND VPWR sky130_fd_sc_hd__tapvpwrvgnd_1
XSLICE_16\[1\].RAM16.SLICE\[0\].RAM8.WORD\[6\].W.BYTE\[2\].B.genblk1.CLKINV SLICE_16\[1\].RAM16.SLICE\[0\].RAM8.WORD\[6\].W.BYTE\[0\].B.CLK
+ VGND VGND VPWR VPWR SLICE_16\[1\].RAM16.SLICE\[0\].RAM8.WORD\[6\].W.BYTE\[2\].B.CLK_B
+ sky130_fd_sc_hd__inv_1
Xtap_2_26 VGND VPWR sky130_fd_sc_hd__tapvpwrvgnd_1
Xtap_2_15 VGND VPWR sky130_fd_sc_hd__tapvpwrvgnd_1
XSLICE_16\[0\].RAM16.SLICE\[0\].RAM8.WORD\[3\].W.BYTE\[1\].B.BIT\[1\].OBUF0 SLICE_16\[0\].RAM16.SLICE\[0\].RAM8.WORD\[3\].W.BYTE\[1\].B.Q_WIRE\[1\]
+ SLICE_16\[0\].RAM16.SLICE\[0\].RAM8.WORD\[3\].W.BYTE\[1\].B.SEL0_B VGND VGND VPWR
+ VPWR SLICE_16\[0\].RAM16.BYTE\[1\].FLOATBUF0\[9\].Z sky130_fd_sc_hd__ebufn_2
Xfill_44_18 VGND VPWR sky130_fd_sc_hd__tapvpwrvgnd_1
XSLICE_16\[1\].RAM16.SLICE\[1\].RAM8.WORD\[3\].W.BYTE\[2\].B.BIT\[6\].genblk1.STORAGE
+ DIBUF\[22\].X SLICE_16\[1\].RAM16.SLICE\[1\].RAM8.WORD\[3\].W.BYTE\[2\].B.GCLK VGND
+ VGND VPWR VPWR SLICE_16\[1\].RAM16.SLICE\[1\].RAM8.WORD\[3\].W.BYTE\[2\].B.Q_WIRE\[6\]
+ sky130_fd_sc_hd__dlxtp_1
Xfill_44_29 VGND VGND VPWR VPWR sky130_fd_sc_hd__decap_12
XSLICE_16\[1\].RAM16.SLICE\[1\].RAM8.WORD\[1\].W.BYTE\[0\].B.BIT\[5\].genblk1.STORAGE
+ DIBUF\[5\].X SLICE_16\[1\].RAM16.SLICE\[1\].RAM8.WORD\[1\].W.BYTE\[0\].B.GCLK VGND
+ VGND VPWR VPWR SLICE_16\[1\].RAM16.SLICE\[1\].RAM8.WORD\[1\].W.BYTE\[0\].B.Q_WIRE\[5\]
+ sky130_fd_sc_hd__dlxtp_1
XSLICE_16\[1\].RAM16.SLICE\[0\].RAM8.WORD\[2\].W.BYTE\[2\].B.BIT\[1\].genblk1.STORAGE
+ DIBUF\[17\].X SLICE_16\[1\].RAM16.SLICE\[0\].RAM8.WORD\[2\].W.BYTE\[2\].B.GCLK VGND
+ VGND VPWR VPWR SLICE_16\[1\].RAM16.SLICE\[0\].RAM8.WORD\[2\].W.BYTE\[2\].B.Q_WIRE\[1\]
+ sky130_fd_sc_hd__dlxtp_1
XSLICE_16\[1\].RAM16.SLICE\[0\].RAM8.WORD\[0\].W.BYTE\[0\].B.BIT\[0\].genblk1.STORAGE
+ DIBUF\[0\].X SLICE_16\[1\].RAM16.SLICE\[0\].RAM8.WORD\[0\].W.BYTE\[0\].B.GCLK VGND
+ VGND VPWR VPWR SLICE_16\[1\].RAM16.SLICE\[0\].RAM8.WORD\[0\].W.BYTE\[0\].B.Q_WIRE\[0\]
+ sky130_fd_sc_hd__dlxtp_1
XSLICE_16\[0\].RAM16.SLICE\[1\].RAM8.WORD\[4\].W.BYTE\[2\].B.BIT\[2\].genblk1.STORAGE
+ DIBUF\[18\].X SLICE_16\[0\].RAM16.SLICE\[1\].RAM8.WORD\[4\].W.BYTE\[2\].B.GCLK VGND
+ VGND VPWR VPWR SLICE_16\[0\].RAM16.SLICE\[1\].RAM8.WORD\[4\].W.BYTE\[2\].B.Q_WIRE\[2\]
+ sky130_fd_sc_hd__dlxtp_1
XSLICE_16\[0\].RAM16.SLICE\[1\].RAM8.WORD\[2\].W.BYTE\[0\].B.BIT\[1\].genblk1.STORAGE
+ DIBUF\[1\].X SLICE_16\[0\].RAM16.SLICE\[1\].RAM8.WORD\[2\].W.BYTE\[0\].B.GCLK VGND
+ VGND VPWR VPWR SLICE_16\[0\].RAM16.SLICE\[1\].RAM8.WORD\[2\].W.BYTE\[0\].B.Q_WIRE\[1\]
+ sky130_fd_sc_hd__dlxtp_1
XSLICE_16\[1\].RAM16.SLICE\[1\].RAM8.WORD\[6\].W.BYTE\[1\].B.BIT\[6\].OBUF0 SLICE_16\[1\].RAM16.SLICE\[1\].RAM8.WORD\[6\].W.BYTE\[1\].B.Q_WIRE\[6\]
+ SLICE_16\[1\].RAM16.SLICE\[1\].RAM8.WORD\[6\].W.BYTE\[1\].B.SEL0_B VGND VGND VPWR
+ VPWR SLICE_16\[1\].RAM16.BYTE\[1\].FLOATBUF0\[14\].Z sky130_fd_sc_hd__ebufn_2
XSLICE_16\[1\].RAM16.SLICE\[0\].RAM8.WORD\[4\].W.BYTE\[3\].B.BIT\[0\].OBUF0 SLICE_16\[1\].RAM16.SLICE\[0\].RAM8.WORD\[4\].W.BYTE\[3\].B.Q_WIRE\[0\]
+ SLICE_16\[1\].RAM16.SLICE\[0\].RAM8.WORD\[4\].W.BYTE\[3\].B.SEL0_B VGND VGND VPWR
+ VPWR SLICE_16\[1\].RAM16.BYTE\[3\].FLOATBUF0\[24\].Z sky130_fd_sc_hd__ebufn_2
XSLICE_16\[1\].RAM16.SLICE\[0\].RAM8.WORD\[4\].W.BYTE\[3\].B.DIODE_CLK SLICE_16\[1\].RAM16.SLICE\[0\].RAM8.WORD\[4\].W.BYTE\[0\].B.CLK
+ VGND VGND VPWR VPWR sky130_fd_sc_hd__diode_2
XSLICE_16\[1\].RAM16.SLICE\[0\].RAM8.WORD\[1\].W.BYTE\[0\].B.BIT\[5\].OBUF0 SLICE_16\[1\].RAM16.SLICE\[0\].RAM8.WORD\[1\].W.BYTE\[0\].B.Q_WIRE\[5\]
+ SLICE_16\[1\].RAM16.SLICE\[0\].RAM8.WORD\[1\].W.BYTE\[0\].B.SEL0_B VGND VGND VPWR
+ VPWR SLICE_16\[1\].RAM16.BYTE\[0\].FLOATBUF0\[5\].Z sky130_fd_sc_hd__ebufn_2
XSLICE_16\[0\].RAM16.SLICE\[0\].RAM8.WORD\[2\].W.BYTE\[1\].B.genblk1.CG SLICE_16\[0\].RAM16.SLICE\[0\].RAM8.WORD\[2\].W.BYTE\[1\].B.CLK_B
+ SLICE_16\[0\].RAM16.SLICE\[0\].RAM8.WORD\[2\].W.BYTE\[1\].B.WE0_WIRE VGND VGND VPWR
+ VPWR SLICE_16\[0\].RAM16.SLICE\[0\].RAM8.WORD\[2\].W.BYTE\[1\].B.GCLK sky130_fd_sc_hd__dlclkp_1
XSLICE_16\[0\].RAM16.SLICE\[0\].RAM8.WORD\[6\].W.BYTE\[2\].B.BIT\[1\].OBUF0 SLICE_16\[0\].RAM16.SLICE\[0\].RAM8.WORD\[6\].W.BYTE\[2\].B.Q_WIRE\[1\]
+ SLICE_16\[0\].RAM16.SLICE\[0\].RAM8.WORD\[6\].W.BYTE\[2\].B.SEL0_B VGND VGND VPWR
+ VPWR SLICE_16\[0\].RAM16.BYTE\[2\].FLOATBUF0\[17\].Z sky130_fd_sc_hd__ebufn_2
XSLICE_16\[0\].RAM16.SLICE\[0\].RAM8.WORD\[7\].W.BYTE\[1\].B.BIT\[7\].genblk1.STORAGE
+ DIBUF\[15\].X SLICE_16\[0\].RAM16.SLICE\[0\].RAM8.WORD\[7\].W.BYTE\[1\].B.GCLK VGND
+ VGND VPWR VPWR SLICE_16\[0\].RAM16.SLICE\[0\].RAM8.WORD\[7\].W.BYTE\[1\].B.Q_WIRE\[7\]
+ sky130_fd_sc_hd__dlxtp_1
XSLICE_16\[1\].RAM16.SLICE\[1\].RAM8.WORD\[6\].W.SEL0BUF SLICE_16\[1\].RAM16.SLICE\[1\].RAM8.DEC0.SEL\[6\]
+ VGND VGND VPWR VPWR SLICE_16\[1\].RAM16.SLICE\[1\].RAM8.WORD\[6\].W.BYTE\[0\].B.SEL0
+ sky130_fd_sc_hd__clkbuf_2
Xfill_20_2 VGND VGND VPWR VPWR sky130_fd_sc_hd__decap_12
Xfill_13_1 VGND VGND VPWR VPWR sky130_fd_sc_hd__decap_4
Xtap_35_8 VGND VPWR sky130_fd_sc_hd__tapvpwrvgnd_1
XSLICE_16\[0\].RAM16.SLICE\[0\].RAM8.WORD\[7\].W.BYTE\[2\].B.DIODE_CLK SLICE_16\[0\].RAM16.SLICE\[0\].RAM8.WORD\[7\].W.BYTE\[0\].B.CLK
+ VGND VGND VPWR VPWR sky130_fd_sc_hd__diode_2
XSLICE_16\[0\].RAM16.SLICE\[1\].RAM8.WORD\[1\].W.BYTE\[3\].B.DIODE_CLK SLICE_16\[0\].RAM16.SLICE\[1\].RAM8.WORD\[1\].W.BYTE\[0\].B.CLK
+ VGND VGND VPWR VPWR sky130_fd_sc_hd__diode_2
Xfill_39_29 VGND VGND VPWR VPWR sky130_fd_sc_hd__decap_12
Xfill_39_18 VGND VPWR sky130_fd_sc_hd__tapvpwrvgnd_1
XSLICE_16\[1\].RAM16.SLICE\[1\].RAM8.WORD\[3\].W.BYTE\[0\].B.DIODE_CLK SLICE_16\[1\].RAM16.SLICE\[1\].RAM8.WORD\[3\].W.BYTE\[0\].B.CLK
+ VGND VGND VPWR VPWR sky130_fd_sc_hd__diode_2
XSLICE_16\[1\].RAM16.SLICE\[1\].RAM8.WORD\[0\].W.BYTE\[1\].B.genblk1.CLKINV SLICE_16\[1\].RAM16.SLICE\[1\].RAM8.WORD\[0\].W.BYTE\[0\].B.CLK
+ VGND VGND VPWR VPWR SLICE_16\[1\].RAM16.SLICE\[1\].RAM8.WORD\[0\].W.BYTE\[1\].B.CLK_B
+ sky130_fd_sc_hd__inv_1
Xtap_28_7 VGND VPWR sky130_fd_sc_hd__tapvpwrvgnd_1
Xtap_16_11 VGND VPWR sky130_fd_sc_hd__tapvpwrvgnd_1
Xtap_32_32 VGND VPWR sky130_fd_sc_hd__tapvpwrvgnd_1
Xtap_32_21 VGND VPWR sky130_fd_sc_hd__tapvpwrvgnd_1
Xtap_32_10 VGND VPWR sky130_fd_sc_hd__tapvpwrvgnd_1
Xtap_16_33 VGND VPWR sky130_fd_sc_hd__tapvpwrvgnd_1
Xtap_16_22 VGND VPWR sky130_fd_sc_hd__tapvpwrvgnd_1
XSLICE_16\[1\].RAM16.Do0_REG.OUTREG_BYTE\[3\].Do_FF\[1\] SLICE_16\[1\].RAM16.Do0_REG.CLKBUF\[3\]
+ SLICE_16\[1\].RAM16.BYTE\[3\].FLOATBUF0\[25\].Z VGND VGND VPWR VPWR Do0MUX.A1\[25\]
+ sky130_fd_sc_hd__dfxtp_1
Xfill_22_102 VGND VPWR sky130_fd_sc_hd__tapvpwrvgnd_1
XSLICE_16\[1\].RAM16.SLICE\[1\].RAM8.WORD\[6\].W.BYTE\[3\].B.BIT\[6\].genblk1.STORAGE
+ DIBUF\[30\].X SLICE_16\[1\].RAM16.SLICE\[1\].RAM8.WORD\[6\].W.BYTE\[3\].B.GCLK VGND
+ VGND VPWR VPWR SLICE_16\[1\].RAM16.SLICE\[1\].RAM8.WORD\[6\].W.BYTE\[3\].B.Q_WIRE\[6\]
+ sky130_fd_sc_hd__dlxtp_1
XSLICE_16\[1\].RAM16.SLICE\[1\].RAM8.WORD\[4\].W.CLKBUF SLICE_16\[1\].RAM16.SLICE\[1\].RAM8.CLKBUF.X
+ VGND VGND VPWR VPWR SLICE_16\[1\].RAM16.SLICE\[1\].RAM8.WORD\[4\].W.BYTE\[0\].B.CLK
+ sky130_fd_sc_hd__clkbuf_4
XSLICE_16\[1\].RAM16.SLICE\[1\].RAM8.WORD\[4\].W.BYTE\[1\].B.BIT\[5\].genblk1.STORAGE
+ DIBUF\[13\].X SLICE_16\[1\].RAM16.SLICE\[1\].RAM8.WORD\[4\].W.BYTE\[1\].B.GCLK VGND
+ VGND VPWR VPWR SLICE_16\[1\].RAM16.SLICE\[1\].RAM8.WORD\[4\].W.BYTE\[1\].B.Q_WIRE\[5\]
+ sky130_fd_sc_hd__dlxtp_1
XSLICE_16\[1\].RAM16.SLICE\[0\].RAM8.WORD\[4\].W.BYTE\[1\].B.BIT\[5\].OBUF0 SLICE_16\[1\].RAM16.SLICE\[0\].RAM8.WORD\[4\].W.BYTE\[1\].B.Q_WIRE\[5\]
+ SLICE_16\[1\].RAM16.SLICE\[0\].RAM8.WORD\[4\].W.BYTE\[1\].B.SEL0_B VGND VGND VPWR
+ VPWR SLICE_16\[1\].RAM16.BYTE\[1\].FLOATBUF0\[13\].Z sky130_fd_sc_hd__ebufn_2
Xfill_20_97 VGND VGND VPWR VPWR sky130_fd_sc_hd__decap_12
Xfill_20_86 VGND VGND VPWR VPWR sky130_fd_sc_hd__decap_12
Xfill_20_75 VGND VPWR sky130_fd_sc_hd__tapvpwrvgnd_1
Xfill_20_64 VGND VGND VPWR VPWR sky130_fd_sc_hd__decap_12
Xfill_20_53 VGND VGND VPWR VPWR sky130_fd_sc_hd__decap_12
Xfill_20_42 VGND VPWR sky130_fd_sc_hd__tapvpwrvgnd_1
Xfill_20_31 VGND VGND VPWR VPWR sky130_fd_sc_hd__decap_12
Xfill_20_20 VGND VGND VPWR VPWR sky130_fd_sc_hd__decap_12
XSLICE_16\[0\].RAM16.SLICE\[1\].RAM8.WORD\[1\].W.BYTE\[3\].B.BIT\[4\].OBUF0 SLICE_16\[0\].RAM16.SLICE\[1\].RAM8.WORD\[1\].W.BYTE\[3\].B.Q_WIRE\[4\]
+ SLICE_16\[0\].RAM16.SLICE\[1\].RAM8.WORD\[1\].W.BYTE\[3\].B.SEL0_B VGND VGND VPWR
+ VPWR SLICE_16\[0\].RAM16.BYTE\[3\].FLOATBUF0\[28\].Z sky130_fd_sc_hd__ebufn_2
XSLICE_16\[1\].RAM16.SLICE\[0\].RAM8.WORD\[5\].W.BYTE\[3\].B.BIT\[1\].genblk1.STORAGE
+ DIBUF\[25\].X SLICE_16\[1\].RAM16.SLICE\[0\].RAM8.WORD\[5\].W.BYTE\[3\].B.GCLK VGND
+ VGND VPWR VPWR SLICE_16\[1\].RAM16.SLICE\[0\].RAM8.WORD\[5\].W.BYTE\[3\].B.Q_WIRE\[1\]
+ sky130_fd_sc_hd__dlxtp_1
Xfill_45_94 VGND VGND VPWR VPWR sky130_fd_sc_hd__decap_12
Xfill_45_83 VGND VGND VPWR VPWR sky130_fd_sc_hd__decap_12
Xfill_45_72 VGND VPWR sky130_fd_sc_hd__tapvpwrvgnd_1
Xfill_45_61 VGND VGND VPWR VPWR sky130_fd_sc_hd__decap_12
Xfill_45_50 VGND VGND VPWR VPWR sky130_fd_sc_hd__decap_12
XSLICE_16\[1\].RAM16.SLICE\[0\].RAM8.WORD\[3\].W.BYTE\[1\].B.BIT\[0\].genblk1.STORAGE
+ DIBUF\[8\].X SLICE_16\[1\].RAM16.SLICE\[0\].RAM8.WORD\[3\].W.BYTE\[1\].B.GCLK VGND
+ VGND VPWR VPWR SLICE_16\[1\].RAM16.SLICE\[0\].RAM8.WORD\[3\].W.BYTE\[1\].B.Q_WIRE\[0\]
+ sky130_fd_sc_hd__dlxtp_1
XSLICE_16\[0\].RAM16.SLICE\[1\].RAM8.WORD\[7\].W.BYTE\[3\].B.BIT\[2\].genblk1.STORAGE
+ DIBUF\[26\].X SLICE_16\[0\].RAM16.SLICE\[1\].RAM8.WORD\[7\].W.BYTE\[3\].B.GCLK VGND
+ VGND VPWR VPWR SLICE_16\[0\].RAM16.SLICE\[1\].RAM8.WORD\[7\].W.BYTE\[3\].B.Q_WIRE\[2\]
+ sky130_fd_sc_hd__dlxtp_1
XSLICE_16\[0\].RAM16.SLICE\[0\].RAM8.WORD\[6\].W.BYTE\[0\].B.BIT\[6\].OBUF0 SLICE_16\[0\].RAM16.SLICE\[0\].RAM8.WORD\[6\].W.BYTE\[0\].B.Q_WIRE\[6\]
+ SLICE_16\[0\].RAM16.SLICE\[0\].RAM8.WORD\[6\].W.BYTE\[0\].B.SEL0_B VGND VGND VPWR
+ VPWR SLICE_16\[0\].RAM16.BYTE\[0\].FLOATBUF0\[6\].Z sky130_fd_sc_hd__ebufn_2
XSLICE_16\[0\].RAM16.SLICE\[1\].RAM8.WORD\[5\].W.BYTE\[1\].B.BIT\[1\].genblk1.STORAGE
+ DIBUF\[9\].X SLICE_16\[0\].RAM16.SLICE\[1\].RAM8.WORD\[5\].W.BYTE\[1\].B.GCLK VGND
+ VGND VPWR VPWR SLICE_16\[0\].RAM16.SLICE\[1\].RAM8.WORD\[5\].W.BYTE\[1\].B.Q_WIRE\[1\]
+ sky130_fd_sc_hd__dlxtp_1
XSLICE_16\[1\].RAM16.SLICE\[1\].RAM8.WORD\[3\].W.BYTE\[2\].B.genblk1.CLKINV SLICE_16\[1\].RAM16.SLICE\[1\].RAM8.WORD\[3\].W.BYTE\[0\].B.CLK
+ VGND VGND VPWR VPWR SLICE_16\[1\].RAM16.SLICE\[1\].RAM8.WORD\[3\].W.BYTE\[2\].B.CLK_B
+ sky130_fd_sc_hd__inv_1
Xtap_8_14 VGND VPWR sky130_fd_sc_hd__tapvpwrvgnd_1
Xfill_9_0 VGND VPWR sky130_fd_sc_hd__tapvpwrvgnd_1
Xfill_41_19 VGND VGND VPWR VPWR sky130_fd_sc_hd__decap_12
XSLICE_16\[0\].RAM16.SLICE\[1\].RAM8.WORD\[7\].W.BYTE\[1\].B.genblk1.CG SLICE_16\[0\].RAM16.SLICE\[1\].RAM8.WORD\[7\].W.BYTE\[1\].B.CLK_B
+ SLICE_16\[0\].RAM16.SLICE\[1\].RAM8.WORD\[7\].W.BYTE\[1\].B.WE0_WIRE VGND VGND VPWR
+ VPWR SLICE_16\[0\].RAM16.SLICE\[1\].RAM8.WORD\[7\].W.BYTE\[1\].B.GCLK sky130_fd_sc_hd__dlclkp_1
Xtap_8_25 VGND VPWR sky130_fd_sc_hd__tapvpwrvgnd_1
XSLICE_16\[0\].RAM16.SLICE\[1\].RAM8.WORD\[0\].W.BYTE\[1\].B.BIT\[1\].OBUF0 SLICE_16\[0\].RAM16.SLICE\[1\].RAM8.WORD\[0\].W.BYTE\[1\].B.Q_WIRE\[1\]
+ SLICE_16\[0\].RAM16.SLICE\[1\].RAM8.WORD\[0\].W.BYTE\[1\].B.SEL0_B VGND VGND VPWR
+ VPWR SLICE_16\[0\].RAM16.BYTE\[1\].FLOATBUF0\[9\].Z sky130_fd_sc_hd__ebufn_2
Xtap_40_6 VGND VPWR sky130_fd_sc_hd__tapvpwrvgnd_1
Xtap_33_5 VGND VPWR sky130_fd_sc_hd__tapvpwrvgnd_1
XSLICE_16\[1\].RAM16.SLICE\[0\].RAM8.WORD\[7\].W.BYTE\[2\].B.BIT\[5\].OBUF0 SLICE_16\[1\].RAM16.SLICE\[0\].RAM8.WORD\[7\].W.BYTE\[2\].B.Q_WIRE\[5\]
+ SLICE_16\[1\].RAM16.SLICE\[0\].RAM8.WORD\[7\].W.BYTE\[2\].B.SEL0_B VGND VGND VPWR
+ VPWR SLICE_16\[1\].RAM16.BYTE\[2\].FLOATBUF0\[21\].Z sky130_fd_sc_hd__ebufn_2
Xtap_26_4 VGND VPWR sky130_fd_sc_hd__tapvpwrvgnd_1
XSLICE_16\[0\].RAM16.SLICE\[0\].RAM8.WORD\[2\].W.BYTE\[1\].B.BIT\[7\].genblk1.STORAGE
+ DIBUF\[15\].X SLICE_16\[0\].RAM16.SLICE\[0\].RAM8.WORD\[2\].W.BYTE\[1\].B.GCLK VGND
+ VGND VPWR VPWR SLICE_16\[0\].RAM16.SLICE\[0\].RAM8.WORD\[2\].W.BYTE\[1\].B.Q_WIRE\[7\]
+ sky130_fd_sc_hd__dlxtp_1
XSLICE_16\[1\].RAM16.Do0_REG.OUTREG_BYTE\[0\].DIODE\[4\] SLICE_16\[1\].RAM16.BYTE\[0\].FLOATBUF0\[4\].Z
+ VGND VGND VPWR VPWR sky130_fd_sc_hd__diode_2
Xtap_27_32 VGND VPWR sky130_fd_sc_hd__tapvpwrvgnd_1
Xtap_27_21 VGND VPWR sky130_fd_sc_hd__tapvpwrvgnd_1
Xtap_27_10 VGND VPWR sky130_fd_sc_hd__tapvpwrvgnd_1
XSLICE_16\[0\].RAM16.SLICE\[1\].RAM8.WORD\[4\].W.SEL0BUF SLICE_16\[0\].RAM16.SLICE\[1\].RAM8.DEC0.SEL\[4\]
+ VGND VGND VPWR VPWR SLICE_16\[0\].RAM16.SLICE\[1\].RAM8.WORD\[4\].W.BYTE\[0\].B.SEL0
+ sky130_fd_sc_hd__clkbuf_2
XSLICE_16\[0\].RAM16.SLICE\[0\].RAM8.WORD\[0\].W.BYTE\[0\].B.genblk1.CLKINV SLICE_16\[0\].RAM16.SLICE\[0\].RAM8.WORD\[0\].W.BYTE\[0\].B.CLK
+ VGND VGND VPWR VPWR SLICE_16\[0\].RAM16.SLICE\[0\].RAM8.WORD\[0\].W.BYTE\[0\].B.CLK_B
+ sky130_fd_sc_hd__inv_1
XSLICE_16\[1\].RAM16.BYTE\[0\].FLOATBUF0\[6\].__cell__ SLICE_16\[1\].RAM16.BYTE\[0\].FLOATBUF0\[0\].A
+ SLICE_16\[1\].RAM16.BYTE\[0\].FLOATBUF0\[0\].TE_B VGND VGND VPWR VPWR SLICE_16\[1\].RAM16.BYTE\[0\].FLOATBUF0\[6\].Z
+ sky130_fd_sc_hd__ebufn_2
XSLICE_16\[1\].RAM16.SLICE\[1\].RAM8.WORD\[6\].W.BYTE\[3\].B.DIODE_CLK SLICE_16\[1\].RAM16.SLICE\[1\].RAM8.WORD\[6\].W.BYTE\[0\].B.CLK
+ VGND VGND VPWR VPWR sky130_fd_sc_hd__diode_2
XSLICE_16\[1\].RAM16.SLICE\[1\].RAM8.WORD\[1\].W.BYTE\[3\].B.BIT\[0\].OBUF0 SLICE_16\[1\].RAM16.SLICE\[1\].RAM8.WORD\[1\].W.BYTE\[3\].B.Q_WIRE\[0\]
+ SLICE_16\[1\].RAM16.SLICE\[1\].RAM8.WORD\[1\].W.BYTE\[3\].B.SEL0_B VGND VGND VPWR
+ VPWR SLICE_16\[1\].RAM16.BYTE\[3\].FLOATBUF0\[24\].Z sky130_fd_sc_hd__ebufn_2
XSLICE_16\[1\].RAM16.SLICE\[0\].RAM8.WORD\[4\].W.BYTE\[2\].B.CGAND SLICE_16\[1\].RAM16.SLICE\[0\].RAM8.WORD\[4\].W.BYTE\[0\].B.SEL0
+ SLICE_16\[1\].RAM16.SLICE\[0\].RAM8.WE0_buf\[2\] VGND VGND VPWR VPWR SLICE_16\[1\].RAM16.SLICE\[0\].RAM8.WORD\[4\].W.BYTE\[2\].B.WE0_WIRE
+ sky130_fd_sc_hd__and2_1
XSLICE_16\[1\].RAM16.SLICE\[1\].RAM8.WORD\[6\].W.BYTE\[3\].B.genblk1.CLKINV SLICE_16\[1\].RAM16.SLICE\[1\].RAM8.WORD\[6\].W.BYTE\[0\].B.CLK
+ VGND VGND VPWR VPWR SLICE_16\[1\].RAM16.SLICE\[1\].RAM8.WORD\[6\].W.BYTE\[3\].B.CLK_B
+ sky130_fd_sc_hd__inv_1
Xfill_47_7 VGND VGND VPWR VPWR sky130_fd_sc_hd__decap_12
XSLICE_16\[1\].RAM16.SLICE\[1\].RAM8.WORD\[4\].W.BYTE\[0\].B.genblk1.CG SLICE_16\[1\].RAM16.SLICE\[1\].RAM8.WORD\[4\].W.BYTE\[0\].B.CLK_B
+ SLICE_16\[1\].RAM16.SLICE\[1\].RAM8.WORD\[4\].W.BYTE\[0\].B.WE0_WIRE VGND VGND VPWR
+ VPWR SLICE_16\[1\].RAM16.SLICE\[1\].RAM8.WORD\[4\].W.BYTE\[0\].B.GCLK sky130_fd_sc_hd__dlclkp_1
XSLICE_16\[1\].RAM16.SLICE\[0\].RAM8.WORD\[6\].W.BYTE\[0\].B.BIT\[2\].OBUF0 SLICE_16\[1\].RAM16.SLICE\[0\].RAM8.WORD\[6\].W.BYTE\[0\].B.Q_WIRE\[2\]
+ SLICE_16\[1\].RAM16.SLICE\[0\].RAM8.WORD\[6\].W.BYTE\[0\].B.SEL0_B VGND VGND VPWR
+ VPWR SLICE_16\[1\].RAM16.BYTE\[0\].FLOATBUF0\[2\].Z sky130_fd_sc_hd__ebufn_2
XSLICE_16\[1\].RAM16.SLICE\[0\].RAM8.WEBUF\[1\].__cell__ SLICE_16\[1\].RAM16.SLICE\[0\].RAM8.WE0\[1\]
+ VGND VGND VPWR VPWR SLICE_16\[1\].RAM16.SLICE\[0\].RAM8.WE0_buf\[1\] sky130_fd_sc_hd__clkbuf_2
XSLICE_16\[0\].RAM16.Do0_REG.OUTREG_BYTE\[2\].DIODE\[1\] SLICE_16\[0\].RAM16.BYTE\[2\].FLOATBUF0\[17\].Z
+ VGND VGND VPWR VPWR sky130_fd_sc_hd__diode_2
XSLICE_16\[1\].RAM16.SLICE\[1\].RAM8.WORD\[7\].W.BYTE\[2\].B.BIT\[5\].genblk1.STORAGE
+ DIBUF\[21\].X SLICE_16\[1\].RAM16.SLICE\[1\].RAM8.WORD\[7\].W.BYTE\[2\].B.GCLK VGND
+ VGND VPWR VPWR SLICE_16\[1\].RAM16.SLICE\[1\].RAM8.WORD\[7\].W.BYTE\[2\].B.Q_WIRE\[5\]
+ sky130_fd_sc_hd__dlxtp_1
XSLICE_16\[1\].RAM16.SLICE\[1\].RAM8.WORD\[1\].W.BYTE\[3\].B.BIT\[6\].genblk1.STORAGE
+ DIBUF\[30\].X SLICE_16\[1\].RAM16.SLICE\[1\].RAM8.WORD\[1\].W.BYTE\[3\].B.GCLK VGND
+ VGND VPWR VPWR SLICE_16\[1\].RAM16.SLICE\[1\].RAM8.WORD\[1\].W.BYTE\[3\].B.Q_WIRE\[6\]
+ sky130_fd_sc_hd__dlxtp_1
XSLICE_16\[0\].RAM16.SLICE\[1\].RAM8.WORD\[3\].W.BYTE\[2\].B.BIT\[1\].OBUF0 SLICE_16\[0\].RAM16.SLICE\[1\].RAM8.WORD\[3\].W.BYTE\[2\].B.Q_WIRE\[1\]
+ SLICE_16\[0\].RAM16.SLICE\[1\].RAM8.WORD\[3\].W.BYTE\[2\].B.SEL0_B VGND VGND VPWR
+ VPWR SLICE_16\[0\].RAM16.BYTE\[2\].FLOATBUF0\[17\].Z sky130_fd_sc_hd__ebufn_2
XSLICE_16\[1\].RAM16.SLICE\[1\].RAM8.WORD\[5\].W.BYTE\[0\].B.BIT\[4\].genblk1.STORAGE
+ DIBUF\[4\].X SLICE_16\[1\].RAM16.SLICE\[1\].RAM8.WORD\[5\].W.BYTE\[0\].B.GCLK VGND
+ VGND VPWR VPWR SLICE_16\[1\].RAM16.SLICE\[1\].RAM8.WORD\[5\].W.BYTE\[0\].B.Q_WIRE\[4\]
+ sky130_fd_sc_hd__dlxtp_1
XSLICE_16\[1\].RAM16.SLICE\[0\].RAM8.WORD\[6\].W.BYTE\[2\].B.BIT\[0\].genblk1.STORAGE
+ DIBUF\[16\].X SLICE_16\[1\].RAM16.SLICE\[0\].RAM8.WORD\[6\].W.BYTE\[2\].B.GCLK VGND
+ VGND VPWR VPWR SLICE_16\[1\].RAM16.SLICE\[0\].RAM8.WORD\[6\].W.BYTE\[2\].B.Q_WIRE\[0\]
+ sky130_fd_sc_hd__dlxtp_1
XSLICE_16\[1\].RAM16.SLICE\[0\].RAM8.WORD\[0\].W.BYTE\[3\].B.BIT\[1\].genblk1.STORAGE
+ DIBUF\[25\].X SLICE_16\[1\].RAM16.SLICE\[0\].RAM8.WORD\[0\].W.BYTE\[3\].B.GCLK VGND
+ VGND VPWR VPWR SLICE_16\[1\].RAM16.SLICE\[0\].RAM8.WORD\[0\].W.BYTE\[3\].B.Q_WIRE\[1\]
+ sky130_fd_sc_hd__dlxtp_1
Xtap_5_9 VGND VPWR sky130_fd_sc_hd__tapvpwrvgnd_1
XSLICE_16\[0\].RAM16.SLICE\[1\].RAM8.WORD\[6\].W.BYTE\[0\].B.BIT\[0\].genblk1.STORAGE
+ DIBUF\[0\].X SLICE_16\[0\].RAM16.SLICE\[1\].RAM8.WORD\[6\].W.BYTE\[0\].B.GCLK VGND
+ VGND VPWR VPWR SLICE_16\[0\].RAM16.SLICE\[1\].RAM8.WORD\[6\].W.BYTE\[0\].B.Q_WIRE\[0\]
+ sky130_fd_sc_hd__dlxtp_1
Xtap_13_34 VGND VPWR sky130_fd_sc_hd__tapvpwrvgnd_1
Xtap_13_23 VGND VPWR sky130_fd_sc_hd__tapvpwrvgnd_1
Xtap_13_12 VGND VPWR sky130_fd_sc_hd__tapvpwrvgnd_1
XSLICE_16\[0\].RAM16.SLICE\[0\].RAM8.WORD\[3\].W.BYTE\[1\].B.genblk1.CLKINV SLICE_16\[0\].RAM16.SLICE\[0\].RAM8.WORD\[3\].W.BYTE\[0\].B.CLK
+ VGND VGND VPWR VPWR SLICE_16\[0\].RAM16.SLICE\[0\].RAM8.WORD\[3\].W.BYTE\[1\].B.CLK_B
+ sky130_fd_sc_hd__inv_1
XSLICE_16\[0\].RAM16.SLICE\[1\].RAM8.WORD\[2\].W.BYTE\[3\].B.BIT\[2\].genblk1.STORAGE
+ DIBUF\[26\].X SLICE_16\[0\].RAM16.SLICE\[1\].RAM8.WORD\[2\].W.BYTE\[3\].B.GCLK VGND
+ VGND VPWR VPWR SLICE_16\[0\].RAM16.SLICE\[1\].RAM8.WORD\[2\].W.BYTE\[3\].B.Q_WIRE\[2\]
+ sky130_fd_sc_hd__dlxtp_1
XSLICE_16\[0\].RAM16.SLICE\[0\].RAM8.DEC0.AND2 SLICE_16\[0\].RAM16.SLICE\[0\].RAM8.DEC0.A_buf\[2\]
+ SLICE_16\[0\].RAM16.SLICE\[0\].RAM8.DEC0.A_buf\[0\] SLICE_16\[0\].RAM16.SLICE\[0\].RAM8.DEC0.A_buf\[1\]
+ SLICE_16\[0\].RAM16.SLICE\[0\].RAM8.DEC0.EN_buf VGND VGND VPWR VPWR SLICE_16\[0\].RAM16.SLICE\[0\].RAM8.DEC0.SEL\[2\]
+ sky130_fd_sc_hd__and4bb_2
XSLICE_16\[0\].RAM16.SLICE\[1\].RAM8.WORD\[0\].W.BYTE\[1\].B.BIT\[1\].genblk1.STORAGE
+ DIBUF\[9\].X SLICE_16\[0\].RAM16.SLICE\[1\].RAM8.WORD\[0\].W.BYTE\[1\].B.GCLK VGND
+ VGND VPWR VPWR SLICE_16\[0\].RAM16.SLICE\[1\].RAM8.WORD\[0\].W.BYTE\[1\].B.Q_WIRE\[1\]
+ sky130_fd_sc_hd__dlxtp_1
Xtap_38_31 VGND VPWR sky130_fd_sc_hd__tapvpwrvgnd_1
Xtap_38_20 VGND VPWR sky130_fd_sc_hd__tapvpwrvgnd_1
Xtap_31_2 VGND VPWR sky130_fd_sc_hd__tapvpwrvgnd_1
Xtap_24_1 VGND VPWR sky130_fd_sc_hd__tapvpwrvgnd_1
Xtap_17_0 VGND VPWR sky130_fd_sc_hd__tapvpwrvgnd_1
XSLICE_16\[1\].RAM16.SLICE\[1\].RAM8.WORD\[1\].W.BYTE\[1\].B.BIT\[5\].OBUF0 SLICE_16\[1\].RAM16.SLICE\[1\].RAM8.WORD\[1\].W.BYTE\[1\].B.Q_WIRE\[5\]
+ SLICE_16\[1\].RAM16.SLICE\[1\].RAM8.WORD\[1\].W.BYTE\[1\].B.SEL0_B VGND VGND VPWR
+ VPWR SLICE_16\[1\].RAM16.BYTE\[1\].FLOATBUF0\[13\].Z sky130_fd_sc_hd__ebufn_2
XSLICE_16\[0\].RAM16.SLICE\[1\].RAM8.WORD\[6\].W.BYTE\[3\].B.BIT\[1\].OBUF0 SLICE_16\[0\].RAM16.SLICE\[1\].RAM8.WORD\[6\].W.BYTE\[3\].B.Q_WIRE\[1\]
+ SLICE_16\[0\].RAM16.SLICE\[1\].RAM8.WORD\[6\].W.BYTE\[3\].B.SEL0_B VGND VGND VPWR
+ VPWR SLICE_16\[0\].RAM16.BYTE\[3\].FLOATBUF0\[25\].Z sky130_fd_sc_hd__ebufn_2
Xfill_42_73 VGND VGND VPWR VPWR sky130_fd_sc_hd__decap_12
Xfill_42_62 VGND VGND VPWR VPWR sky130_fd_sc_hd__decap_12
Xfill_42_51 VGND VPWR sky130_fd_sc_hd__tapvpwrvgnd_1
Xfill_42_40 VGND VGND VPWR VPWR sky130_fd_sc_hd__decap_12
XSLICE_16\[0\].RAM16.SLICE\[0\].RAM8.WORD\[5\].W.BYTE\[2\].B.BIT\[7\].genblk1.STORAGE
+ DIBUF\[23\].X SLICE_16\[0\].RAM16.SLICE\[0\].RAM8.WORD\[5\].W.BYTE\[2\].B.GCLK VGND
+ VGND VPWR VPWR SLICE_16\[0\].RAM16.SLICE\[0\].RAM8.WORD\[5\].W.BYTE\[2\].B.Q_WIRE\[7\]
+ sky130_fd_sc_hd__dlxtp_1
Xfill_42_95 VGND VGND VPWR VPWR sky130_fd_sc_hd__decap_12
Xfill_42_84 VGND VPWR sky130_fd_sc_hd__tapvpwrvgnd_1
XSLICE_16\[1\].RAM16.SLICE\[1\].RAM8.WORD\[5\].W.BYTE\[1\].B.CGAND SLICE_16\[1\].RAM16.SLICE\[1\].RAM8.WORD\[5\].W.BYTE\[0\].B.SEL0
+ SLICE_16\[1\].RAM16.SLICE\[1\].RAM8.WE0_buf\[1\] VGND VGND VPWR VPWR SLICE_16\[1\].RAM16.SLICE\[1\].RAM8.WORD\[5\].W.BYTE\[1\].B.WE0_WIRE
+ sky130_fd_sc_hd__and2_1
XSLICE_16\[0\].RAM16.SLICE\[0\].RAM8.WORD\[3\].W.BYTE\[0\].B.BIT\[6\].genblk1.STORAGE
+ DIBUF\[6\].X SLICE_16\[0\].RAM16.SLICE\[0\].RAM8.WORD\[3\].W.BYTE\[0\].B.GCLK VGND
+ VGND VPWR VPWR SLICE_16\[0\].RAM16.SLICE\[0\].RAM8.WORD\[3\].W.BYTE\[0\].B.Q_WIRE\[6\]
+ sky130_fd_sc_hd__dlxtp_1
Xfill_45_4 VGND VGND VPWR VPWR sky130_fd_sc_hd__decap_12
Xfill_38_3 VGND VPWR sky130_fd_sc_hd__tapvpwrvgnd_1
XSLICE_16\[0\].RAM16.Do0_REG.OUTREG_BYTE\[1\].Do_FF\[2\] SLICE_16\[0\].RAM16.Do0_REG.CLKBUF\[1\]
+ SLICE_16\[0\].RAM16.BYTE\[1\].FLOATBUF0\[10\].Z VGND VGND VPWR VPWR Do0MUX.A0\[10\]
+ sky130_fd_sc_hd__dfxtp_1
XSLICE_16\[0\].RAM16.SLICE\[1\].RAM8.WORD\[3\].W.BYTE\[0\].B.BIT\[6\].OBUF0 SLICE_16\[0\].RAM16.SLICE\[1\].RAM8.WORD\[3\].W.BYTE\[0\].B.Q_WIRE\[6\]
+ SLICE_16\[0\].RAM16.SLICE\[1\].RAM8.WORD\[3\].W.BYTE\[0\].B.SEL0_B VGND VGND VPWR
+ VPWR SLICE_16\[0\].RAM16.BYTE\[0\].FLOATBUF0\[6\].Z sky130_fd_sc_hd__ebufn_2
XSLICE_16\[0\].RAM16.SLICE\[0\].RAM8.WORD\[1\].W.BYTE\[2\].B.BIT\[0\].OBUF0 SLICE_16\[0\].RAM16.SLICE\[0\].RAM8.WORD\[1\].W.BYTE\[2\].B.Q_WIRE\[0\]
+ SLICE_16\[0\].RAM16.SLICE\[0\].RAM8.WORD\[1\].W.BYTE\[2\].B.SEL0_B VGND VGND VPWR
+ VPWR SLICE_16\[0\].RAM16.BYTE\[2\].FLOATBUF0\[16\].Z sky130_fd_sc_hd__ebufn_2
XSLICE_16\[0\].RAM16.SLICE\[0\].RAM8.WORD\[6\].W.BYTE\[2\].B.genblk1.CLKINV SLICE_16\[0\].RAM16.SLICE\[0\].RAM8.WORD\[6\].W.BYTE\[0\].B.CLK
+ VGND VGND VPWR VPWR SLICE_16\[0\].RAM16.SLICE\[0\].RAM8.WORD\[6\].W.BYTE\[2\].B.CLK_B
+ sky130_fd_sc_hd__inv_1
XDo0MUX.M\[3\].MUX\[4\] Do0MUX.A0\[28\] Do0MUX.A1\[28\] Do0MUX.SEL\[3\] VGND VGND
+ VPWR VPWR Do0[28] sky130_fd_sc_hd__mux2_1
XSLICE_16\[1\].RAM16.SLICE\[0\].RAM8.WORD\[0\].W.BYTE\[3\].B.BIT\[7\].OBUF0 SLICE_16\[1\].RAM16.SLICE\[0\].RAM8.WORD\[0\].W.BYTE\[3\].B.Q_WIRE\[7\]
+ SLICE_16\[1\].RAM16.SLICE\[0\].RAM8.WORD\[0\].W.BYTE\[3\].B.SEL0_B VGND VGND VPWR
+ VPWR SLICE_16\[1\].RAM16.BYTE\[3\].FLOATBUF0\[31\].Z sky130_fd_sc_hd__ebufn_2
Xfill_0_4 VGND VGND VPWR VPWR sky130_fd_sc_hd__decap_12
Xtap_5_15 VGND VPWR sky130_fd_sc_hd__tapvpwrvgnd_1
Xtap_5_26 VGND VPWR sky130_fd_sc_hd__tapvpwrvgnd_1
Xtap_10_7 VGND VPWR sky130_fd_sc_hd__tapvpwrvgnd_1
Xfill_47_29 VGND VGND VPWR VPWR sky130_fd_sc_hd__decap_12
Xfill_47_18 VGND VPWR sky130_fd_sc_hd__tapvpwrvgnd_1
XSLICE_16\[1\].RAM16.SLICE\[1\].RAM8.WORD\[4\].W.BYTE\[2\].B.BIT\[5\].OBUF0 SLICE_16\[1\].RAM16.SLICE\[1\].RAM8.WORD\[4\].W.BYTE\[2\].B.Q_WIRE\[5\]
+ SLICE_16\[1\].RAM16.SLICE\[1\].RAM8.WORD\[4\].W.BYTE\[2\].B.SEL0_B VGND VGND VPWR
+ VPWR SLICE_16\[1\].RAM16.BYTE\[2\].FLOATBUF0\[21\].Z sky130_fd_sc_hd__ebufn_2
Xtap_24_33 VGND VPWR sky130_fd_sc_hd__tapvpwrvgnd_1
Xtap_24_22 VGND VPWR sky130_fd_sc_hd__tapvpwrvgnd_1
Xtap_24_11 VGND VPWR sky130_fd_sc_hd__tapvpwrvgnd_1
Xtap_3_6 VGND VPWR sky130_fd_sc_hd__tapvpwrvgnd_1
Xtap_40_21 VGND VPWR sky130_fd_sc_hd__tapvpwrvgnd_1
Xtap_40_10 VGND VPWR sky130_fd_sc_hd__tapvpwrvgnd_1
XSLICE_16\[1\].RAM16.SLICE\[1\].RAM8.WORD\[2\].W.BYTE\[2\].B.BIT\[5\].genblk1.STORAGE
+ DIBUF\[21\].X SLICE_16\[1\].RAM16.SLICE\[1\].RAM8.WORD\[2\].W.BYTE\[2\].B.GCLK VGND
+ VGND VPWR VPWR SLICE_16\[1\].RAM16.SLICE\[1\].RAM8.WORD\[2\].W.BYTE\[2\].B.Q_WIRE\[5\]
+ sky130_fd_sc_hd__dlxtp_1
XSLICE_16\[1\].RAM16.SLICE\[1\].RAM8.WORD\[0\].W.BYTE\[0\].B.BIT\[4\].genblk1.STORAGE
+ DIBUF\[4\].X SLICE_16\[1\].RAM16.SLICE\[1\].RAM8.WORD\[0\].W.BYTE\[0\].B.GCLK VGND
+ VGND VPWR VPWR SLICE_16\[1\].RAM16.SLICE\[1\].RAM8.WORD\[0\].W.BYTE\[0\].B.Q_WIRE\[4\]
+ sky130_fd_sc_hd__dlxtp_1
XSLICE_16\[1\].RAM16.SLICE\[0\].RAM8.WORD\[1\].W.BYTE\[2\].B.BIT\[0\].genblk1.STORAGE
+ DIBUF\[16\].X SLICE_16\[1\].RAM16.SLICE\[0\].RAM8.WORD\[1\].W.BYTE\[2\].B.GCLK VGND
+ VGND VPWR VPWR SLICE_16\[1\].RAM16.SLICE\[0\].RAM8.WORD\[1\].W.BYTE\[2\].B.Q_WIRE\[0\]
+ sky130_fd_sc_hd__dlxtp_1
XSLICE_16\[0\].RAM16.SLICE\[1\].RAM8.WORD\[7\].W.BYTE\[3\].B.CGAND SLICE_16\[0\].RAM16.SLICE\[1\].RAM8.WORD\[7\].W.BYTE\[0\].B.SEL0
+ SLICE_16\[0\].RAM16.SLICE\[1\].RAM8.WE0_buf\[3\] VGND VGND VPWR VPWR SLICE_16\[0\].RAM16.SLICE\[1\].RAM8.WORD\[7\].W.BYTE\[3\].B.WE0_WIRE
+ sky130_fd_sc_hd__and2_1
XSLICE_16\[0\].RAM16.SLICE\[1\].RAM8.WORD\[6\].W.BYTE\[1\].B.BIT\[6\].OBUF0 SLICE_16\[0\].RAM16.SLICE\[1\].RAM8.WORD\[6\].W.BYTE\[1\].B.Q_WIRE\[6\]
+ SLICE_16\[0\].RAM16.SLICE\[1\].RAM8.WORD\[6\].W.BYTE\[1\].B.SEL0_B VGND VGND VPWR
+ VPWR SLICE_16\[0\].RAM16.BYTE\[1\].FLOATBUF0\[14\].Z sky130_fd_sc_hd__ebufn_2
XSLICE_16\[0\].RAM16.SLICE\[0\].RAM8.WORD\[4\].W.BYTE\[3\].B.BIT\[0\].OBUF0 SLICE_16\[0\].RAM16.SLICE\[0\].RAM8.WORD\[4\].W.BYTE\[3\].B.Q_WIRE\[0\]
+ SLICE_16\[0\].RAM16.SLICE\[0\].RAM8.WORD\[4\].W.BYTE\[3\].B.SEL0_B VGND VGND VPWR
+ VPWR SLICE_16\[0\].RAM16.BYTE\[3\].FLOATBUF0\[24\].Z sky130_fd_sc_hd__ebufn_2
XDo0MUX.M\[2\].MUX\[6\] Do0MUX.A0\[22\] Do0MUX.A1\[22\] Do0MUX.SEL\[2\] VGND VGND
+ VPWR VPWR Do0[22] sky130_fd_sc_hd__mux2_1
XSLICE_16\[0\].RAM16.SLICE\[1\].RAM8.WORD\[3\].W.BYTE\[2\].B.BIT\[1\].genblk1.STORAGE
+ DIBUF\[17\].X SLICE_16\[0\].RAM16.SLICE\[1\].RAM8.WORD\[3\].W.BYTE\[2\].B.GCLK VGND
+ VGND VPWR VPWR SLICE_16\[0\].RAM16.SLICE\[1\].RAM8.WORD\[3\].W.BYTE\[2\].B.Q_WIRE\[1\]
+ sky130_fd_sc_hd__dlxtp_1
Xfill_17_8 VGND VGND VPWR VPWR sky130_fd_sc_hd__decap_12
Xfill_0_23 VGND VPWR sky130_fd_sc_hd__tapvpwrvgnd_1
Xfill_0_12 VGND VPWR sky130_fd_sc_hd__tapvpwrvgnd_1
XSLICE_16\[0\].RAM16.SLICE\[1\].RAM8.WORD\[1\].W.BYTE\[0\].B.BIT\[0\].genblk1.STORAGE
+ DIBUF\[0\].X SLICE_16\[0\].RAM16.SLICE\[1\].RAM8.WORD\[1\].W.BYTE\[0\].B.GCLK VGND
+ VGND VPWR VPWR SLICE_16\[0\].RAM16.SLICE\[1\].RAM8.WORD\[1\].W.BYTE\[0\].B.Q_WIRE\[0\]
+ sky130_fd_sc_hd__dlxtp_1
XSLICE_16\[1\].RAM16.SLICE\[0\].RAM8.WORD\[0\].W.BYTE\[3\].B.genblk1.CG SLICE_16\[1\].RAM16.SLICE\[0\].RAM8.WORD\[0\].W.BYTE\[3\].B.CLK_B
+ SLICE_16\[1\].RAM16.SLICE\[0\].RAM8.WORD\[0\].W.BYTE\[3\].B.WE0_WIRE VGND VGND VPWR
+ VPWR SLICE_16\[1\].RAM16.SLICE\[0\].RAM8.WORD\[0\].W.BYTE\[3\].B.GCLK sky130_fd_sc_hd__dlclkp_1
XSLICE_16\[0\].RAM16.BYTE\[1\].FLOATBUF0\[14\].__cell__ SLICE_16\[0\].RAM16.BYTE\[1\].FLOATBUF0\[10\].A
+ SLICE_16\[0\].RAM16.BYTE\[1\].FLOATBUF0\[10\].TE_B VGND VGND VPWR VPWR SLICE_16\[0\].RAM16.BYTE\[1\].FLOATBUF0\[14\].Z
+ sky130_fd_sc_hd__ebufn_2
XSLICE_16\[0\].RAM16.SLICE\[0\].RAM8.WORD\[1\].W.BYTE\[0\].B.BIT\[5\].OBUF0 SLICE_16\[0\].RAM16.SLICE\[0\].RAM8.WORD\[1\].W.BYTE\[0\].B.Q_WIRE\[5\]
+ SLICE_16\[0\].RAM16.SLICE\[0\].RAM8.WORD\[1\].W.BYTE\[0\].B.SEL0_B VGND VGND VPWR
+ VPWR SLICE_16\[0\].RAM16.BYTE\[0\].FLOATBUF0\[5\].Z sky130_fd_sc_hd__ebufn_2
XSLICE_16\[1\].RAM16.SLICE\[1\].RAM8.WORD\[3\].W.BYTE\[0\].B.BIT\[2\].OBUF0 SLICE_16\[1\].RAM16.SLICE\[1\].RAM8.WORD\[3\].W.BYTE\[0\].B.Q_WIRE\[2\]
+ SLICE_16\[1\].RAM16.SLICE\[1\].RAM8.WORD\[3\].W.BYTE\[0\].B.SEL0_B VGND VGND VPWR
+ VPWR SLICE_16\[1\].RAM16.BYTE\[0\].FLOATBUF0\[2\].Z sky130_fd_sc_hd__ebufn_2
Xfill_43_1 VGND VGND VPWR VPWR sky130_fd_sc_hd__decap_12
XSLICE_16\[1\].RAM16.SLICE\[1\].RAM8.WORD\[7\].W.BYTE\[3\].B.BIT\[5\].OBUF0 SLICE_16\[1\].RAM16.SLICE\[1\].RAM8.WORD\[7\].W.BYTE\[3\].B.Q_WIRE\[5\]
+ SLICE_16\[1\].RAM16.SLICE\[1\].RAM8.WORD\[7\].W.BYTE\[3\].B.SEL0_B VGND VGND VPWR
+ VPWR SLICE_16\[1\].RAM16.BYTE\[3\].FLOATBUF0\[29\].Z sky130_fd_sc_hd__ebufn_2
Xfill_36_0 VGND VPWR sky130_fd_sc_hd__tapvpwrvgnd_1
XSLICE_16\[0\].RAM16.SLICE\[0\].RAM8.WORD\[6\].W.BYTE\[1\].B.BIT\[6\].genblk1.STORAGE
+ DIBUF\[14\].X SLICE_16\[0\].RAM16.SLICE\[0\].RAM8.WORD\[6\].W.BYTE\[1\].B.GCLK VGND
+ VGND VPWR VPWR SLICE_16\[0\].RAM16.SLICE\[0\].RAM8.WORD\[6\].W.BYTE\[1\].B.Q_WIRE\[6\]
+ sky130_fd_sc_hd__dlxtp_1
Xfill_46_141 VGND VPWR sky130_fd_sc_hd__tapvpwrvgnd_1
Xfill_46_130 VGND VGND VPWR VPWR sky130_fd_sc_hd__decap_12
XSLICE_16\[0\].RAM16.SLICE\[0\].RAM8.WORD\[0\].W.BYTE\[2\].B.BIT\[7\].genblk1.STORAGE
+ DIBUF\[23\].X SLICE_16\[0\].RAM16.SLICE\[0\].RAM8.WORD\[0\].W.BYTE\[2\].B.GCLK VGND
+ VGND VPWR VPWR SLICE_16\[0\].RAM16.SLICE\[0\].RAM8.WORD\[0\].W.BYTE\[2\].B.Q_WIRE\[7\]
+ sky130_fd_sc_hd__dlxtp_1
XSLICE_16\[1\].RAM16.SLICE\[0\].RAM8.WORD\[2\].W.BYTE\[2\].B.BIT\[4\].OBUF0 SLICE_16\[1\].RAM16.SLICE\[0\].RAM8.WORD\[2\].W.BYTE\[2\].B.Q_WIRE\[4\]
+ SLICE_16\[1\].RAM16.SLICE\[0\].RAM8.WORD\[2\].W.BYTE\[2\].B.SEL0_B VGND VGND VPWR
+ VPWR SLICE_16\[1\].RAM16.BYTE\[2\].FLOATBUF0\[20\].Z sky130_fd_sc_hd__ebufn_2
XSLICE_16\[0\].RAM16.SLICE\[1\].RAM8.WORD\[0\].W.BYTE\[1\].B.genblk1.CLKINV SLICE_16\[0\].RAM16.SLICE\[1\].RAM8.WORD\[0\].W.BYTE\[0\].B.CLK
+ VGND VGND VPWR VPWR SLICE_16\[0\].RAM16.SLICE\[1\].RAM8.WORD\[0\].W.BYTE\[1\].B.CLK_B
+ sky130_fd_sc_hd__inv_1
Xtap_10_13 VGND VPWR sky130_fd_sc_hd__tapvpwrvgnd_1
Xtap_10_24 VGND VPWR sky130_fd_sc_hd__tapvpwrvgnd_1
Xtap_10_35 VGND VPWR sky130_fd_sc_hd__tapvpwrvgnd_1
Xtap_35_10 VGND VPWR sky130_fd_sc_hd__tapvpwrvgnd_1
XSLICE_16\[1\].RAM16.SLICE\[0\].RAM8.WORD\[0\].W.BYTE\[1\].B.CGAND SLICE_16\[1\].RAM16.SLICE\[0\].RAM8.WORD\[0\].W.BYTE\[0\].B.SEL0
+ SLICE_16\[1\].RAM16.SLICE\[0\].RAM8.WE0_buf\[1\] VGND VGND VPWR VPWR SLICE_16\[1\].RAM16.SLICE\[0\].RAM8.WORD\[0\].W.BYTE\[1\].B.WE0_WIRE
+ sky130_fd_sc_hd__and2_1
Xtap_35_32 VGND VPWR sky130_fd_sc_hd__tapvpwrvgnd_1
Xtap_35_21 VGND VPWR sky130_fd_sc_hd__tapvpwrvgnd_1
Xtap_1_3 VGND VPWR sky130_fd_sc_hd__tapvpwrvgnd_1
XSLICE_16\[0\].RAM16.SLICE\[0\].RAM8.WORD\[4\].W.BYTE\[1\].B.BIT\[5\].OBUF0 SLICE_16\[0\].RAM16.SLICE\[0\].RAM8.WORD\[4\].W.BYTE\[1\].B.Q_WIRE\[5\]
+ SLICE_16\[0\].RAM16.SLICE\[0\].RAM8.WORD\[4\].W.BYTE\[1\].B.SEL0_B VGND VGND VPWR
+ VPWR SLICE_16\[0\].RAM16.BYTE\[1\].FLOATBUF0\[13\].Z sky130_fd_sc_hd__ebufn_2
XSLICE_16\[1\].RAM16.SLICE\[1\].RAM8.WORD\[6\].W.BYTE\[1\].B.BIT\[2\].OBUF0 SLICE_16\[1\].RAM16.SLICE\[1\].RAM8.WORD\[6\].W.BYTE\[1\].B.Q_WIRE\[2\]
+ SLICE_16\[1\].RAM16.SLICE\[1\].RAM8.WORD\[6\].W.BYTE\[1\].B.SEL0_B VGND VGND VPWR
+ VPWR SLICE_16\[1\].RAM16.BYTE\[1\].FLOATBUF0\[10\].Z sky130_fd_sc_hd__ebufn_2
XSLICE_16\[1\].RAM16.SLICE\[1\].RAM8.WORD\[5\].W.SEL0BUF SLICE_16\[1\].RAM16.SLICE\[1\].RAM8.DEC0.SEL\[5\]
+ VGND VGND VPWR VPWR SLICE_16\[1\].RAM16.SLICE\[1\].RAM8.WORD\[5\].W.BYTE\[0\].B.SEL0
+ sky130_fd_sc_hd__clkbuf_2
XSLICE_16\[1\].RAM16.SLICE\[1\].RAM8.WORD\[5\].W.BYTE\[3\].B.BIT\[5\].genblk1.STORAGE
+ DIBUF\[29\].X SLICE_16\[1\].RAM16.SLICE\[1\].RAM8.WORD\[5\].W.BYTE\[3\].B.GCLK VGND
+ VGND VPWR VPWR SLICE_16\[1\].RAM16.SLICE\[1\].RAM8.WORD\[5\].W.BYTE\[3\].B.Q_WIRE\[5\]
+ sky130_fd_sc_hd__dlxtp_1
Xfill_43_100 VGND VGND VPWR VPWR sky130_fd_sc_hd__decap_12
XSLICE_16\[1\].RAM16.SLICE\[1\].RAM8.WORD\[3\].W.BYTE\[1\].B.BIT\[4\].genblk1.STORAGE
+ DIBUF\[12\].X SLICE_16\[1\].RAM16.SLICE\[1\].RAM8.WORD\[3\].W.BYTE\[1\].B.GCLK VGND
+ VGND VPWR VPWR SLICE_16\[1\].RAM16.SLICE\[1\].RAM8.WORD\[3\].W.BYTE\[1\].B.Q_WIRE\[4\]
+ sky130_fd_sc_hd__dlxtp_1
XSLICE_16\[1\].RAM16.SLICE\[0\].RAM8.WORD\[4\].W.BYTE\[3\].B.BIT\[0\].genblk1.STORAGE
+ DIBUF\[24\].X SLICE_16\[1\].RAM16.SLICE\[0\].RAM8.WORD\[4\].W.BYTE\[3\].B.GCLK VGND
+ VGND VPWR VPWR SLICE_16\[1\].RAM16.SLICE\[0\].RAM8.WORD\[4\].W.BYTE\[3\].B.Q_WIRE\[0\]
+ sky130_fd_sc_hd__dlxtp_1
XSLICE_16\[1\].RAM16.SLICE\[0\].RAM8.WORD\[1\].W.BYTE\[0\].B.BIT\[1\].OBUF0 SLICE_16\[1\].RAM16.SLICE\[0\].RAM8.WORD\[1\].W.BYTE\[0\].B.Q_WIRE\[1\]
+ SLICE_16\[1\].RAM16.SLICE\[0\].RAM8.WORD\[1\].W.BYTE\[0\].B.SEL0_B VGND VGND VPWR
+ VPWR SLICE_16\[1\].RAM16.BYTE\[0\].FLOATBUF0\[1\].Z sky130_fd_sc_hd__ebufn_2
Xfill_22_6 VGND VPWR sky130_fd_sc_hd__tapvpwrvgnd_1
Xfill_15_5 VGND VGND VPWR VPWR sky130_fd_sc_hd__fill_2
XSLICE_16\[1\].RAM16.SLICE\[0\].RAM8.WORD\[5\].W.BYTE\[3\].B.BIT\[4\].OBUF0 SLICE_16\[1\].RAM16.SLICE\[0\].RAM8.WORD\[5\].W.BYTE\[3\].B.Q_WIRE\[4\]
+ SLICE_16\[1\].RAM16.SLICE\[0\].RAM8.WORD\[5\].W.BYTE\[3\].B.SEL0_B VGND VGND VPWR
+ VPWR SLICE_16\[1\].RAM16.BYTE\[3\].FLOATBUF0\[28\].Z sky130_fd_sc_hd__ebufn_2
XSLICE_16\[0\].RAM16.SLICE\[1\].RAM8.WORD\[6\].W.BYTE\[3\].B.BIT\[1\].genblk1.STORAGE
+ DIBUF\[25\].X SLICE_16\[0\].RAM16.SLICE\[1\].RAM8.WORD\[6\].W.BYTE\[3\].B.GCLK VGND
+ VGND VPWR VPWR SLICE_16\[0\].RAM16.SLICE\[1\].RAM8.WORD\[6\].W.BYTE\[3\].B.Q_WIRE\[1\]
+ sky130_fd_sc_hd__dlxtp_1
XSLICE_16\[0\].RAM16.SLICE\[1\].RAM8.WORD\[3\].W.BYTE\[2\].B.genblk1.CLKINV SLICE_16\[0\].RAM16.SLICE\[1\].RAM8.WORD\[3\].W.BYTE\[0\].B.CLK
+ VGND VGND VPWR VPWR SLICE_16\[0\].RAM16.SLICE\[1\].RAM8.WORD\[3\].W.BYTE\[2\].B.CLK_B
+ sky130_fd_sc_hd__inv_1
XSLICE_16\[0\].RAM16.SLICE\[1\].RAM8.WORD\[3\].W.BYTE\[0\].B.genblk1.CG SLICE_16\[0\].RAM16.SLICE\[1\].RAM8.WORD\[3\].W.BYTE\[0\].B.CLK_B
+ SLICE_16\[0\].RAM16.SLICE\[1\].RAM8.WORD\[3\].W.BYTE\[0\].B.WE0_WIRE VGND VGND VPWR
+ VPWR SLICE_16\[0\].RAM16.SLICE\[1\].RAM8.WORD\[3\].W.BYTE\[0\].B.GCLK sky130_fd_sc_hd__dlclkp_1
XSLICE_16\[0\].RAM16.SLICE\[1\].RAM8.WORD\[4\].W.BYTE\[1\].B.BIT\[0\].genblk1.STORAGE
+ DIBUF\[8\].X SLICE_16\[0\].RAM16.SLICE\[1\].RAM8.WORD\[4\].W.BYTE\[1\].B.GCLK VGND
+ VGND VPWR VPWR SLICE_16\[0\].RAM16.SLICE\[1\].RAM8.WORD\[4\].W.BYTE\[1\].B.Q_WIRE\[0\]
+ sky130_fd_sc_hd__dlxtp_1
Xtap_2_27 VGND VPWR sky130_fd_sc_hd__tapvpwrvgnd_1
Xtap_2_16 VGND VPWR sky130_fd_sc_hd__tapvpwrvgnd_1
XSLICE_16\[0\].RAM16.SLICE\[0\].RAM8.WORD\[2\].W.BYTE\[3\].B.CGAND SLICE_16\[0\].RAM16.SLICE\[0\].RAM8.WORD\[2\].W.BYTE\[0\].B.SEL0
+ SLICE_16\[0\].RAM16.SLICE\[0\].RAM8.WE0_buf\[3\] VGND VGND VPWR VPWR SLICE_16\[0\].RAM16.SLICE\[0\].RAM8.WORD\[2\].W.BYTE\[3\].B.WE0_WIRE
+ sky130_fd_sc_hd__and2_1
Xfill_44_19 VGND VGND VPWR VPWR sky130_fd_sc_hd__decap_12
XSLICE_16\[1\].RAM16.SLICE\[1\].RAM8.WORD\[5\].W.BYTE\[3\].B.genblk1.CG SLICE_16\[1\].RAM16.SLICE\[1\].RAM8.WORD\[5\].W.BYTE\[3\].B.CLK_B
+ SLICE_16\[1\].RAM16.SLICE\[1\].RAM8.WORD\[5\].W.BYTE\[3\].B.WE0_WIRE VGND VGND VPWR
+ VPWR SLICE_16\[1\].RAM16.SLICE\[1\].RAM8.WORD\[5\].W.BYTE\[3\].B.GCLK sky130_fd_sc_hd__dlclkp_1
XSLICE_16\[0\].RAM16.SLICE\[0\].RAM8.WORD\[7\].W.BYTE\[2\].B.BIT\[5\].OBUF0 SLICE_16\[0\].RAM16.SLICE\[0\].RAM8.WORD\[7\].W.BYTE\[2\].B.Q_WIRE\[5\]
+ SLICE_16\[0\].RAM16.SLICE\[0\].RAM8.WORD\[7\].W.BYTE\[2\].B.SEL0_B VGND VGND VPWR
+ VPWR SLICE_16\[0\].RAM16.BYTE\[2\].FLOATBUF0\[21\].Z sky130_fd_sc_hd__ebufn_2
XSLICE_16\[1\].RAM16.SLICE\[0\].RAM8.WORD\[7\].W.CLKBUF SLICE_16\[1\].RAM16.SLICE\[0\].RAM8.CLKBUF.X
+ VGND VGND VPWR VPWR SLICE_16\[1\].RAM16.SLICE\[0\].RAM8.WORD\[7\].W.BYTE\[0\].B.CLK
+ sky130_fd_sc_hd__clkbuf_4
XSLICE_16\[0\].RAM16.SLICE\[0\].RAM8.WORD\[3\].W.BYTE\[3\].B.BIT\[7\].genblk1.STORAGE
+ DIBUF\[31\].X SLICE_16\[0\].RAM16.SLICE\[0\].RAM8.WORD\[3\].W.BYTE\[3\].B.GCLK VGND
+ VGND VPWR VPWR SLICE_16\[0\].RAM16.SLICE\[0\].RAM8.WORD\[3\].W.BYTE\[3\].B.Q_WIRE\[7\]
+ sky130_fd_sc_hd__dlxtp_1
XSLICE_16\[1\].RAM16.SLICE\[1\].RAM8.WORD\[1\].W.BYTE\[0\].B.CGAND SLICE_16\[1\].RAM16.SLICE\[1\].RAM8.WORD\[1\].W.BYTE\[0\].B.SEL0
+ SLICE_16\[1\].RAM16.SLICE\[1\].RAM8.WE0_buf\[0\] VGND VGND VPWR VPWR SLICE_16\[1\].RAM16.SLICE\[1\].RAM8.WORD\[1\].W.BYTE\[0\].B.WE0_WIRE
+ sky130_fd_sc_hd__and2_1
Xfill_18_20 VGND VGND VPWR VPWR sky130_fd_sc_hd__decap_12
XSLICE_16\[0\].RAM16.SLICE\[0\].RAM8.WORD\[1\].W.BYTE\[1\].B.BIT\[6\].genblk1.STORAGE
+ DIBUF\[14\].X SLICE_16\[0\].RAM16.SLICE\[0\].RAM8.WORD\[1\].W.BYTE\[1\].B.GCLK VGND
+ VGND VPWR VPWR SLICE_16\[0\].RAM16.SLICE\[0\].RAM8.WORD\[1\].W.BYTE\[1\].B.Q_WIRE\[6\]
+ sky130_fd_sc_hd__dlxtp_1
XDIBUF\[25\].__cell__ Di0[25] VGND VGND VPWR VPWR DIBUF\[25\].X sky130_fd_sc_hd__clkbuf_16
XSLICE_16\[0\].RAM16.SLICE\[0\].RAM8.WORD\[7\].W.BYTE\[0\].B.BIT\[5\].genblk1.STORAGE
+ DIBUF\[5\].X SLICE_16\[0\].RAM16.SLICE\[0\].RAM8.WORD\[7\].W.BYTE\[0\].B.GCLK VGND
+ VGND VPWR VPWR SLICE_16\[0\].RAM16.SLICE\[0\].RAM8.WORD\[7\].W.BYTE\[0\].B.Q_WIRE\[5\]
+ sky130_fd_sc_hd__dlxtp_1
XSLICE_16\[1\].RAM16.SLICE\[0\].RAM8.WORD\[4\].W.BYTE\[1\].B.BIT\[1\].OBUF0 SLICE_16\[1\].RAM16.SLICE\[0\].RAM8.WORD\[4\].W.BYTE\[1\].B.Q_WIRE\[1\]
+ SLICE_16\[1\].RAM16.SLICE\[0\].RAM8.WORD\[4\].W.BYTE\[1\].B.SEL0_B VGND VGND VPWR
+ VPWR SLICE_16\[1\].RAM16.BYTE\[1\].FLOATBUF0\[9\].Z sky130_fd_sc_hd__ebufn_2
XSLICE_16\[0\].RAM16.SLICE\[1\].RAM8.WORD\[1\].W.BYTE\[3\].B.BIT\[0\].OBUF0 SLICE_16\[0\].RAM16.SLICE\[1\].RAM8.WORD\[1\].W.BYTE\[3\].B.Q_WIRE\[0\]
+ SLICE_16\[0\].RAM16.SLICE\[1\].RAM8.WORD\[1\].W.BYTE\[3\].B.SEL0_B VGND VGND VPWR
+ VPWR SLICE_16\[0\].RAM16.BYTE\[3\].FLOATBUF0\[24\].Z sky130_fd_sc_hd__ebufn_2
XSLICE_16\[0\].RAM16.SLICE\[1\].RAM8.WORD\[6\].W.BYTE\[3\].B.genblk1.CLKINV SLICE_16\[0\].RAM16.SLICE\[1\].RAM8.WORD\[6\].W.BYTE\[0\].B.CLK
+ VGND VGND VPWR VPWR SLICE_16\[0\].RAM16.SLICE\[1\].RAM8.WORD\[6\].W.BYTE\[3\].B.CLK_B
+ sky130_fd_sc_hd__inv_1
XSLICE_16\[0\].RAM16.SLICE\[0\].RAM8.WORD\[6\].W.BYTE\[0\].B.BIT\[2\].OBUF0 SLICE_16\[0\].RAM16.SLICE\[0\].RAM8.WORD\[6\].W.BYTE\[0\].B.Q_WIRE\[2\]
+ SLICE_16\[0\].RAM16.SLICE\[0\].RAM8.WORD\[6\].W.BYTE\[0\].B.SEL0_B VGND VGND VPWR
+ VPWR SLICE_16\[0\].RAM16.BYTE\[0\].FLOATBUF0\[2\].Z sky130_fd_sc_hd__ebufn_2
Xfill_20_3 VGND VPWR sky130_fd_sc_hd__tapvpwrvgnd_1
Xfill_13_2 VGND VPWR sky130_fd_sc_hd__tapvpwrvgnd_1
XSLICE_16\[1\].RAM16.SLICE\[1\].RAM8.WORD\[6\].W.BYTE\[2\].B.BIT\[4\].genblk1.STORAGE
+ DIBUF\[20\].X SLICE_16\[1\].RAM16.SLICE\[1\].RAM8.WORD\[6\].W.BYTE\[2\].B.GCLK VGND
+ VGND VPWR VPWR SLICE_16\[1\].RAM16.SLICE\[1\].RAM8.WORD\[6\].W.BYTE\[2\].B.Q_WIRE\[4\]
+ sky130_fd_sc_hd__dlxtp_1
Xtap_35_9 VGND VPWR sky130_fd_sc_hd__tapvpwrvgnd_1
Xfill_39_19 VGND VGND VPWR VPWR sky130_fd_sc_hd__decap_12
XSLICE_16\[1\].RAM16.SLICE\[1\].RAM8.WORD\[4\].W.BYTE\[0\].B.BIT\[3\].genblk1.STORAGE
+ DIBUF\[3\].X SLICE_16\[1\].RAM16.SLICE\[1\].RAM8.WORD\[4\].W.BYTE\[0\].B.GCLK VGND
+ VGND VPWR VPWR SLICE_16\[1\].RAM16.SLICE\[1\].RAM8.WORD\[4\].W.BYTE\[0\].B.Q_WIRE\[3\]
+ sky130_fd_sc_hd__dlxtp_1
XSLICE_16\[1\].RAM16.SLICE\[1\].RAM8.WORD\[0\].W.BYTE\[3\].B.BIT\[5\].genblk1.STORAGE
+ DIBUF\[29\].X SLICE_16\[1\].RAM16.SLICE\[1\].RAM8.WORD\[0\].W.BYTE\[3\].B.GCLK VGND
+ VGND VPWR VPWR SLICE_16\[1\].RAM16.SLICE\[1\].RAM8.WORD\[0\].W.BYTE\[3\].B.Q_WIRE\[5\]
+ sky130_fd_sc_hd__dlxtp_1
Xtap_28_8 VGND VPWR sky130_fd_sc_hd__tapvpwrvgnd_1
Xtap_16_34 VGND VPWR sky130_fd_sc_hd__tapvpwrvgnd_1
Xtap_16_23 VGND VPWR sky130_fd_sc_hd__tapvpwrvgnd_1
Xtap_16_12 VGND VPWR sky130_fd_sc_hd__tapvpwrvgnd_1
Xtap_32_33 VGND VPWR sky130_fd_sc_hd__tapvpwrvgnd_1
Xtap_32_22 VGND VPWR sky130_fd_sc_hd__tapvpwrvgnd_1
Xtap_32_11 VGND VPWR sky130_fd_sc_hd__tapvpwrvgnd_1
XSLICE_16\[1\].RAM16.SLICE\[0\].RAM8.WORD\[7\].W.BYTE\[2\].B.BIT\[1\].OBUF0 SLICE_16\[1\].RAM16.SLICE\[0\].RAM8.WORD\[7\].W.BYTE\[2\].B.Q_WIRE\[1\]
+ SLICE_16\[1\].RAM16.SLICE\[0\].RAM8.WORD\[7\].W.BYTE\[2\].B.SEL0_B VGND VGND VPWR
+ VPWR SLICE_16\[1\].RAM16.BYTE\[2\].FLOATBUF0\[17\].Z sky130_fd_sc_hd__ebufn_2
XSLICE_16\[0\].RAM16.SLICE\[1\].RAM8.WORD\[3\].W.SEL0BUF SLICE_16\[0\].RAM16.SLICE\[1\].RAM8.DEC0.SEL\[3\]
+ VGND VGND VPWR VPWR SLICE_16\[0\].RAM16.SLICE\[1\].RAM8.WORD\[3\].W.BYTE\[0\].B.SEL0
+ sky130_fd_sc_hd__clkbuf_2
XSLICE_16\[0\].RAM16.SLICE\[1\].RAM8.WORD\[3\].W.BYTE\[2\].B.CGAND SLICE_16\[0\].RAM16.SLICE\[1\].RAM8.WORD\[3\].W.BYTE\[0\].B.SEL0
+ SLICE_16\[0\].RAM16.SLICE\[1\].RAM8.WE0_buf\[2\] VGND VGND VPWR VPWR SLICE_16\[0\].RAM16.SLICE\[1\].RAM8.WORD\[3\].W.BYTE\[2\].B.WE0_WIRE
+ sky130_fd_sc_hd__and2_1
Xtap_47_0 VGND VPWR sky130_fd_sc_hd__tapvpwrvgnd_1
Xfill_22_103 VGND VGND VPWR VPWR sky130_fd_sc_hd__decap_6
Xfill_20_10 VGND VGND VPWR VPWR sky130_fd_sc_hd__decap_12
XSLICE_16\[0\].RAM16.SLICE\[1\].RAM8.WORD\[7\].W.BYTE\[2\].B.BIT\[0\].genblk1.STORAGE
+ DIBUF\[16\].X SLICE_16\[0\].RAM16.SLICE\[1\].RAM8.WORD\[7\].W.BYTE\[2\].B.GCLK VGND
+ VGND VPWR VPWR SLICE_16\[0\].RAM16.SLICE\[1\].RAM8.WORD\[7\].W.BYTE\[2\].B.Q_WIRE\[0\]
+ sky130_fd_sc_hd__dlxtp_1
XSLICE_16\[0\].RAM16.SLICE\[1\].RAM8.WORD\[1\].W.BYTE\[3\].B.BIT\[1\].genblk1.STORAGE
+ DIBUF\[25\].X SLICE_16\[0\].RAM16.SLICE\[1\].RAM8.WORD\[1\].W.BYTE\[3\].B.GCLK VGND
+ VGND VPWR VPWR SLICE_16\[0\].RAM16.SLICE\[1\].RAM8.WORD\[1\].W.BYTE\[3\].B.Q_WIRE\[1\]
+ sky130_fd_sc_hd__dlxtp_1
Xfill_20_98 VGND VGND VPWR VPWR sky130_fd_sc_hd__decap_12
Xfill_20_87 VGND VPWR sky130_fd_sc_hd__tapvpwrvgnd_1
Xfill_20_76 VGND VGND VPWR VPWR sky130_fd_sc_hd__decap_12
Xfill_20_65 VGND VGND VPWR VPWR sky130_fd_sc_hd__decap_12
Xfill_20_54 VGND VPWR sky130_fd_sc_hd__tapvpwrvgnd_1
Xfill_20_43 VGND VGND VPWR VPWR sky130_fd_sc_hd__decap_12
Xfill_20_32 VGND VGND VPWR VPWR sky130_fd_sc_hd__decap_12
Xfill_20_21 VGND VPWR sky130_fd_sc_hd__tapvpwrvgnd_1
XSLICE_16\[0\].RAM16.SLICE\[0\].RAM8.WORD\[7\].W.BYTE\[3\].B.SEL0INV SLICE_16\[0\].RAM16.SLICE\[0\].RAM8.WORD\[7\].W.BYTE\[0\].B.SEL0
+ VGND VGND VPWR VPWR SLICE_16\[0\].RAM16.SLICE\[0\].RAM8.WORD\[7\].W.BYTE\[3\].B.SEL0_B
+ sky130_fd_sc_hd__inv_1
XSLICE_16\[0\].RAM16.SLICE\[1\].RAM8.WORD\[1\].W.BYTE\[1\].B.BIT\[5\].OBUF0 SLICE_16\[0\].RAM16.SLICE\[1\].RAM8.WORD\[1\].W.BYTE\[1\].B.Q_WIRE\[5\]
+ SLICE_16\[0\].RAM16.SLICE\[1\].RAM8.WORD\[1\].W.BYTE\[1\].B.SEL0_B VGND VGND VPWR
+ VPWR SLICE_16\[0\].RAM16.BYTE\[1\].FLOATBUF0\[13\].Z sky130_fd_sc_hd__ebufn_2
Xfill_45_40 VGND VGND VPWR VPWR sky130_fd_sc_hd__decap_12
XSLICE_16\[0\].RAM16.DIODE_A0\[0\].__cell__ A0BUF\[0\].X VGND VGND VPWR VPWR sky130_fd_sc_hd__diode_2
Xfill_45_95 VGND VGND VPWR VPWR sky130_fd_sc_hd__decap_12
Xfill_45_84 VGND VPWR sky130_fd_sc_hd__tapvpwrvgnd_1
Xfill_45_73 VGND VGND VPWR VPWR sky130_fd_sc_hd__decap_12
Xfill_45_62 VGND VGND VPWR VPWR sky130_fd_sc_hd__decap_12
Xfill_45_51 VGND VPWR sky130_fd_sc_hd__tapvpwrvgnd_1
XSLICE_16\[0\].RAM16.SLICE\[0\].RAM8.WORD\[0\].W.BYTE\[3\].B.BIT\[7\].OBUF0 SLICE_16\[0\].RAM16.SLICE\[0\].RAM8.WORD\[0\].W.BYTE\[3\].B.Q_WIRE\[7\]
+ SLICE_16\[0\].RAM16.SLICE\[0\].RAM8.WORD\[0\].W.BYTE\[3\].B.SEL0_B VGND VGND VPWR
+ VPWR SLICE_16\[0\].RAM16.BYTE\[3\].FLOATBUF0\[31\].Z sky130_fd_sc_hd__ebufn_2
XSLICE_16\[0\].RAM16.SLICE\[0\].RAM8.WORD\[4\].W.BYTE\[2\].B.BIT\[6\].genblk1.STORAGE
+ DIBUF\[22\].X SLICE_16\[0\].RAM16.SLICE\[0\].RAM8.WORD\[4\].W.BYTE\[2\].B.GCLK VGND
+ VGND VPWR VPWR SLICE_16\[0\].RAM16.SLICE\[0\].RAM8.WORD\[4\].W.BYTE\[2\].B.Q_WIRE\[6\]
+ sky130_fd_sc_hd__dlxtp_1
XSLICE_16\[1\].RAM16.SLICE\[1\].RAM8.WORD\[2\].W.BYTE\[3\].B.BIT\[4\].OBUF0 SLICE_16\[1\].RAM16.SLICE\[1\].RAM8.WORD\[2\].W.BYTE\[3\].B.Q_WIRE\[4\]
+ SLICE_16\[1\].RAM16.SLICE\[1\].RAM8.WORD\[2\].W.BYTE\[3\].B.SEL0_B VGND VGND VPWR
+ VPWR SLICE_16\[1\].RAM16.BYTE\[3\].FLOATBUF0\[28\].Z sky130_fd_sc_hd__ebufn_2
XSLICE_16\[0\].RAM16.SLICE\[0\].RAM8.WORD\[2\].W.BYTE\[0\].B.BIT\[5\].genblk1.STORAGE
+ DIBUF\[5\].X SLICE_16\[0\].RAM16.SLICE\[0\].RAM8.WORD\[2\].W.BYTE\[0\].B.GCLK VGND
+ VGND VPWR VPWR SLICE_16\[0\].RAM16.SLICE\[0\].RAM8.WORD\[2\].W.BYTE\[0\].B.Q_WIRE\[5\]
+ sky130_fd_sc_hd__dlxtp_1
XDIBUF\[9\].__cell__ Di0[9] VGND VGND VPWR VPWR DIBUF\[9\].X sky130_fd_sc_hd__clkbuf_16
Xtap_8_15 VGND VPWR sky130_fd_sc_hd__tapvpwrvgnd_1
Xtap_8_26 VGND VPWR sky130_fd_sc_hd__tapvpwrvgnd_1
Xfill_9_1 VGND VPWR sky130_fd_sc_hd__tapvpwrvgnd_1
XSLICE_16\[1\].RAM16.SLICE\[0\].RAM8.WORD\[3\].W.BYTE\[1\].B.DIODE_CLK SLICE_16\[1\].RAM16.SLICE\[0\].RAM8.WORD\[3\].W.BYTE\[0\].B.CLK
+ VGND VGND VPWR VPWR sky130_fd_sc_hd__diode_2
Xtap_40_7 VGND VPWR sky130_fd_sc_hd__tapvpwrvgnd_1
Xtap_33_6 VGND VPWR sky130_fd_sc_hd__tapvpwrvgnd_1
XSLICE_16\[1\].RAM16.SLICE\[0\].RAM8.WORD\[7\].W.BYTE\[0\].B.BIT\[6\].OBUF0 SLICE_16\[1\].RAM16.SLICE\[0\].RAM8.WORD\[7\].W.BYTE\[0\].B.Q_WIRE\[6\]
+ SLICE_16\[1\].RAM16.SLICE\[0\].RAM8.WORD\[7\].W.BYTE\[0\].B.SEL0_B VGND VGND VPWR
+ VPWR SLICE_16\[1\].RAM16.BYTE\[0\].FLOATBUF0\[6\].Z sky130_fd_sc_hd__ebufn_2
Xtap_27_11 VGND VPWR sky130_fd_sc_hd__tapvpwrvgnd_1
Xtap_26_5 VGND VPWR sky130_fd_sc_hd__tapvpwrvgnd_1
XSLICE_16\[0\].RAM16.SLICE\[1\].RAM8.WORD\[4\].W.BYTE\[2\].B.BIT\[5\].OBUF0 SLICE_16\[0\].RAM16.SLICE\[1\].RAM8.WORD\[4\].W.BYTE\[2\].B.Q_WIRE\[5\]
+ SLICE_16\[0\].RAM16.SLICE\[1\].RAM8.WORD\[4\].W.BYTE\[2\].B.SEL0_B VGND VGND VPWR
+ VPWR SLICE_16\[0\].RAM16.BYTE\[2\].FLOATBUF0\[21\].Z sky130_fd_sc_hd__ebufn_2
Xtap_27_33 VGND VPWR sky130_fd_sc_hd__tapvpwrvgnd_1
Xtap_27_22 VGND VPWR sky130_fd_sc_hd__tapvpwrvgnd_1
XSLICE_16\[0\].RAM16.SLICE\[0\].RAM8.WORD\[6\].W.BYTE\[0\].B.DIODE_CLK SLICE_16\[0\].RAM16.SLICE\[0\].RAM8.WORD\[6\].W.BYTE\[0\].B.CLK
+ VGND VGND VPWR VPWR sky130_fd_sc_hd__diode_2
XSLICE_16\[0\].RAM16.SLICE\[1\].RAM8.WORD\[0\].W.BYTE\[1\].B.DIODE_CLK SLICE_16\[0\].RAM16.SLICE\[1\].RAM8.WORD\[0\].W.BYTE\[0\].B.CLK
+ VGND VGND VPWR VPWR sky130_fd_sc_hd__diode_2
XSLICE_16\[1\].RAM16.SLICE\[1\].RAM8.WORD\[7\].W.BYTE\[1\].B.BIT\[3\].genblk1.STORAGE
+ DIBUF\[11\].X SLICE_16\[1\].RAM16.SLICE\[1\].RAM8.WORD\[7\].W.BYTE\[1\].B.GCLK VGND
+ VGND VPWR VPWR SLICE_16\[1\].RAM16.SLICE\[1\].RAM8.WORD\[7\].W.BYTE\[1\].B.Q_WIRE\[3\]
+ sky130_fd_sc_hd__dlxtp_1
XSLICE_16\[1\].RAM16.SLICE\[1\].RAM8.WORD\[1\].W.BYTE\[2\].B.BIT\[4\].genblk1.STORAGE
+ DIBUF\[20\].X SLICE_16\[1\].RAM16.SLICE\[1\].RAM8.WORD\[1\].W.BYTE\[2\].B.GCLK VGND
+ VGND VPWR VPWR SLICE_16\[1\].RAM16.SLICE\[1\].RAM8.WORD\[1\].W.BYTE\[2\].B.Q_WIRE\[4\]
+ sky130_fd_sc_hd__dlxtp_1
XSLICE_16\[1\].RAM16.SLICE\[1\].RAM8.WORD\[1\].W.BYTE\[1\].B.BIT\[1\].OBUF0 SLICE_16\[1\].RAM16.SLICE\[1\].RAM8.WORD\[1\].W.BYTE\[1\].B.Q_WIRE\[1\]
+ SLICE_16\[1\].RAM16.SLICE\[1\].RAM8.WORD\[1\].W.BYTE\[1\].B.SEL0_B VGND VGND VPWR
+ VPWR SLICE_16\[1\].RAM16.BYTE\[1\].FLOATBUF0\[9\].Z sky130_fd_sc_hd__ebufn_2
XSLICE_16\[0\].RAM16.Do0_REG.OUTREG_BYTE\[3\].DIODE\[5\] SLICE_16\[0\].RAM16.BYTE\[3\].FLOATBUF0\[29\].Z
+ VGND VGND VPWR VPWR sky130_fd_sc_hd__diode_2
Xfill_47_8 VGND VGND VPWR VPWR sky130_fd_sc_hd__decap_12
XSLICE_16\[0\].RAM16.SLICE\[1\].RAM8.WORD\[3\].W.BYTE\[0\].B.BIT\[2\].OBUF0 SLICE_16\[0\].RAM16.SLICE\[1\].RAM8.WORD\[3\].W.BYTE\[0\].B.Q_WIRE\[2\]
+ SLICE_16\[0\].RAM16.SLICE\[1\].RAM8.WORD\[3\].W.BYTE\[0\].B.SEL0_B VGND VGND VPWR
+ VPWR SLICE_16\[0\].RAM16.BYTE\[0\].FLOATBUF0\[2\].Z sky130_fd_sc_hd__ebufn_2
XSLICE_16\[0\].RAM16.SLICE\[0\].RAM8.DEC0.ENBUF SLICE_16\[0\].RAM16.DEC0.SEL\[0\]
+ VGND VGND VPWR VPWR SLICE_16\[0\].RAM16.SLICE\[0\].RAM8.DEC0.EN_buf sky130_fd_sc_hd__clkbuf_2
XSLICE_16\[1\].RAM16.SLICE\[0\].RAM8.WORD\[1\].W.BYTE\[0\].B.genblk1.CLKINV SLICE_16\[1\].RAM16.SLICE\[0\].RAM8.WORD\[1\].W.BYTE\[0\].B.CLK
+ VGND VGND VPWR VPWR SLICE_16\[1\].RAM16.SLICE\[0\].RAM8.WORD\[1\].W.BYTE\[0\].B.CLK_B
+ sky130_fd_sc_hd__inv_1
XSLICE_16\[0\].RAM16.SLICE\[1\].RAM8.WORD\[7\].W.BYTE\[3\].B.BIT\[5\].OBUF0 SLICE_16\[0\].RAM16.SLICE\[1\].RAM8.WORD\[7\].W.BYTE\[3\].B.Q_WIRE\[5\]
+ SLICE_16\[0\].RAM16.SLICE\[1\].RAM8.WORD\[7\].W.BYTE\[3\].B.SEL0_B VGND VGND VPWR
+ VPWR SLICE_16\[0\].RAM16.BYTE\[3\].FLOATBUF0\[29\].Z sky130_fd_sc_hd__ebufn_2
XSLICE_16\[0\].RAM16.SLICE\[1\].RAM8.WORD\[2\].W.BYTE\[2\].B.BIT\[0\].genblk1.STORAGE
+ DIBUF\[16\].X SLICE_16\[0\].RAM16.SLICE\[1\].RAM8.WORD\[2\].W.BYTE\[2\].B.GCLK VGND
+ VGND VPWR VPWR SLICE_16\[0\].RAM16.SLICE\[1\].RAM8.WORD\[2\].W.BYTE\[2\].B.Q_WIRE\[0\]
+ sky130_fd_sc_hd__dlxtp_1
XSLICE_16\[1\].RAM16.SLICE\[0\].RAM8.WORD\[0\].W.BYTE\[3\].B.BIT\[3\].OBUF0 SLICE_16\[1\].RAM16.SLICE\[0\].RAM8.WORD\[0\].W.BYTE\[3\].B.Q_WIRE\[3\]
+ SLICE_16\[1\].RAM16.SLICE\[0\].RAM8.WORD\[0\].W.BYTE\[3\].B.SEL0_B VGND VGND VPWR
+ VPWR SLICE_16\[1\].RAM16.BYTE\[3\].FLOATBUF0\[27\].Z sky130_fd_sc_hd__ebufn_2
Xtap_13_35 VGND VPWR sky130_fd_sc_hd__tapvpwrvgnd_1
Xtap_13_24 VGND VPWR sky130_fd_sc_hd__tapvpwrvgnd_1
Xtap_13_13 VGND VPWR sky130_fd_sc_hd__tapvpwrvgnd_1
XSLICE_16\[0\].RAM16.SLICE\[0\].RAM8.WORD\[2\].W.BYTE\[2\].B.BIT\[4\].OBUF0 SLICE_16\[0\].RAM16.SLICE\[0\].RAM8.WORD\[2\].W.BYTE\[2\].B.Q_WIRE\[4\]
+ SLICE_16\[0\].RAM16.SLICE\[0\].RAM8.WORD\[2\].W.BYTE\[2\].B.SEL0_B VGND VGND VPWR
+ VPWR SLICE_16\[0\].RAM16.BYTE\[2\].FLOATBUF0\[20\].Z sky130_fd_sc_hd__ebufn_2
XSLICE_16\[0\].RAM16.SLICE\[0\].RAM8.WORD\[7\].W.BYTE\[3\].B.BIT\[6\].genblk1.STORAGE
+ DIBUF\[30\].X SLICE_16\[0\].RAM16.SLICE\[0\].RAM8.WORD\[7\].W.BYTE\[3\].B.GCLK VGND
+ VGND VPWR VPWR SLICE_16\[0\].RAM16.SLICE\[0\].RAM8.WORD\[7\].W.BYTE\[3\].B.Q_WIRE\[6\]
+ sky130_fd_sc_hd__dlxtp_1
XSLICE_16\[1\].RAM16.SLICE\[1\].RAM8.WORD\[4\].W.BYTE\[2\].B.BIT\[1\].OBUF0 SLICE_16\[1\].RAM16.SLICE\[1\].RAM8.WORD\[4\].W.BYTE\[2\].B.Q_WIRE\[1\]
+ SLICE_16\[1\].RAM16.SLICE\[1\].RAM8.WORD\[4\].W.BYTE\[2\].B.SEL0_B VGND VGND VPWR
+ VPWR SLICE_16\[1\].RAM16.BYTE\[2\].FLOATBUF0\[17\].Z sky130_fd_sc_hd__ebufn_2
XSLICE_16\[0\].RAM16.SLICE\[1\].RAM8.WORD\[4\].W.BYTE\[3\].B.genblk1.CG SLICE_16\[0\].RAM16.SLICE\[1\].RAM8.WORD\[4\].W.BYTE\[3\].B.CLK_B
+ SLICE_16\[0\].RAM16.SLICE\[1\].RAM8.WORD\[4\].W.BYTE\[3\].B.WE0_WIRE VGND VGND VPWR
+ VPWR SLICE_16\[0\].RAM16.SLICE\[1\].RAM8.WORD\[4\].W.BYTE\[3\].B.GCLK sky130_fd_sc_hd__dlclkp_1
XSLICE_16\[0\].RAM16.SLICE\[0\].RAM8.DEC0.AND3 SLICE_16\[0\].RAM16.SLICE\[0\].RAM8.DEC0.A_buf\[2\]
+ SLICE_16\[0\].RAM16.SLICE\[0\].RAM8.DEC0.A_buf\[1\] SLICE_16\[0\].RAM16.SLICE\[0\].RAM8.DEC0.A_buf\[0\]
+ SLICE_16\[0\].RAM16.SLICE\[0\].RAM8.DEC0.EN_buf VGND VGND VPWR VPWR SLICE_16\[0\].RAM16.SLICE\[0\].RAM8.DEC0.SEL\[3\]
+ sky130_fd_sc_hd__and4b_2
XSLICE_16\[0\].RAM16.SLICE\[0\].RAM8.WORD\[5\].W.BYTE\[1\].B.BIT\[5\].genblk1.STORAGE
+ DIBUF\[13\].X SLICE_16\[0\].RAM16.SLICE\[0\].RAM8.WORD\[5\].W.BYTE\[1\].B.GCLK VGND
+ VGND VPWR VPWR SLICE_16\[0\].RAM16.SLICE\[0\].RAM8.WORD\[5\].W.BYTE\[1\].B.Q_WIRE\[5\]
+ sky130_fd_sc_hd__dlxtp_1
Xtap_38_32 VGND VPWR sky130_fd_sc_hd__tapvpwrvgnd_1
Xtap_38_21 VGND VPWR sky130_fd_sc_hd__tapvpwrvgnd_1
Xtap_38_10 VGND VPWR sky130_fd_sc_hd__tapvpwrvgnd_1
Xtap_31_3 VGND VPWR sky130_fd_sc_hd__tapvpwrvgnd_1
Xtap_24_2 VGND VPWR sky130_fd_sc_hd__tapvpwrvgnd_1
Xtap_17_1 VGND VPWR sky130_fd_sc_hd__tapvpwrvgnd_1
XSLICE_16\[0\].RAM16.Do0_REG.OUTREG_BYTE\[2\].Do_FF\[6\] SLICE_16\[0\].RAM16.Do0_REG.CLKBUF\[2\]
+ SLICE_16\[0\].RAM16.BYTE\[2\].FLOATBUF0\[22\].Z VGND VGND VPWR VPWR Do0MUX.A0\[22\]
+ sky130_fd_sc_hd__dfxtp_1
XSLICE_16\[0\].RAM16.SLICE\[1\].RAM8.WORD\[6\].W.BYTE\[1\].B.BIT\[2\].OBUF0 SLICE_16\[0\].RAM16.SLICE\[1\].RAM8.WORD\[6\].W.BYTE\[1\].B.Q_WIRE\[2\]
+ SLICE_16\[0\].RAM16.SLICE\[1\].RAM8.WORD\[6\].W.BYTE\[1\].B.SEL0_B VGND VGND VPWR
+ VPWR SLICE_16\[0\].RAM16.BYTE\[1\].FLOATBUF0\[10\].Z sky130_fd_sc_hd__ebufn_2
Xfill_42_96 VGND VPWR sky130_fd_sc_hd__tapvpwrvgnd_1
Xfill_42_85 VGND VGND VPWR VPWR sky130_fd_sc_hd__decap_12
Xfill_42_74 VGND VGND VPWR VPWR sky130_fd_sc_hd__decap_12
Xfill_42_63 VGND VPWR sky130_fd_sc_hd__tapvpwrvgnd_1
Xfill_42_52 VGND VGND VPWR VPWR sky130_fd_sc_hd__decap_12
Xfill_42_41 VGND VGND VPWR VPWR sky130_fd_sc_hd__decap_12
Xfill_42_30 VGND VPWR sky130_fd_sc_hd__tapvpwrvgnd_1
XSLICE_16\[1\].RAM16.SLICE\[0\].RAM8.WORD\[5\].W.BYTE\[3\].B.SEL0INV SLICE_16\[1\].RAM16.SLICE\[0\].RAM8.WORD\[5\].W.BYTE\[0\].B.SEL0
+ VGND VGND VPWR VPWR SLICE_16\[1\].RAM16.SLICE\[0\].RAM8.WORD\[5\].W.BYTE\[3\].B.SEL0_B
+ sky130_fd_sc_hd__inv_1
XSLICE_16\[1\].RAM16.SLICE\[0\].RAM8.WORD\[4\].W.BYTE\[1\].B.genblk1.CLKINV SLICE_16\[1\].RAM16.SLICE\[0\].RAM8.WORD\[4\].W.BYTE\[0\].B.CLK
+ VGND VGND VPWR VPWR SLICE_16\[1\].RAM16.SLICE\[0\].RAM8.WORD\[4\].W.BYTE\[1\].B.CLK_B
+ sky130_fd_sc_hd__inv_1
Xfill_45_5 VGND VGND VPWR VPWR sky130_fd_sc_hd__decap_12
Xfill_38_4 VGND VGND VPWR VPWR sky130_fd_sc_hd__decap_6
XSLICE_16\[0\].RAM16.SLICE\[0\].RAM8.WORD\[1\].W.BYTE\[0\].B.BIT\[1\].OBUF0 SLICE_16\[0\].RAM16.SLICE\[0\].RAM8.WORD\[1\].W.BYTE\[0\].B.Q_WIRE\[1\]
+ SLICE_16\[0\].RAM16.SLICE\[0\].RAM8.WORD\[1\].W.BYTE\[0\].B.SEL0_B VGND VGND VPWR
+ VPWR SLICE_16\[0\].RAM16.BYTE\[0\].FLOATBUF0\[1\].Z sky130_fd_sc_hd__ebufn_2
XSLICE_16\[1\].RAM16.SLICE\[1\].RAM8.WORD\[5\].W.BYTE\[1\].B.DIODE_CLK SLICE_16\[1\].RAM16.SLICE\[1\].RAM8.WORD\[5\].W.BYTE\[0\].B.CLK
+ VGND VGND VPWR VPWR sky130_fd_sc_hd__diode_2
XSLICE_16\[1\].RAM16.SLICE\[1\].RAM8.WORD\[4\].W.BYTE\[3\].B.BIT\[4\].genblk1.STORAGE
+ DIBUF\[28\].X SLICE_16\[1\].RAM16.SLICE\[1\].RAM8.WORD\[4\].W.BYTE\[3\].B.GCLK VGND
+ VGND VPWR VPWR SLICE_16\[1\].RAM16.SLICE\[1\].RAM8.WORD\[4\].W.BYTE\[3\].B.Q_WIRE\[4\]
+ sky130_fd_sc_hd__dlxtp_1
XSLICE_16\[1\].RAM16.SLICE\[1\].RAM8.WORD\[1\].W.BYTE\[2\].B.genblk1.CG SLICE_16\[1\].RAM16.SLICE\[1\].RAM8.WORD\[1\].W.BYTE\[2\].B.CLK_B
+ SLICE_16\[1\].RAM16.SLICE\[1\].RAM8.WORD\[1\].W.BYTE\[2\].B.WE0_WIRE VGND VGND VPWR
+ VPWR SLICE_16\[1\].RAM16.SLICE\[1\].RAM8.WORD\[1\].W.BYTE\[2\].B.GCLK sky130_fd_sc_hd__dlclkp_1
Xfill_0_5 VGND VGND VPWR VPWR sky130_fd_sc_hd__decap_12
XSLICE_16\[0\].RAM16.SLICE\[0\].RAM8.WORD\[5\].W.BYTE\[3\].B.BIT\[4\].OBUF0 SLICE_16\[0\].RAM16.SLICE\[0\].RAM8.WORD\[5\].W.BYTE\[3\].B.Q_WIRE\[4\]
+ SLICE_16\[0\].RAM16.SLICE\[0\].RAM8.WORD\[5\].W.BYTE\[3\].B.SEL0_B VGND VGND VPWR
+ VPWR SLICE_16\[0\].RAM16.BYTE\[3\].FLOATBUF0\[28\].Z sky130_fd_sc_hd__ebufn_2
XSLICE_16\[1\].RAM16.SLICE\[1\].RAM8.WORD\[7\].W.BYTE\[3\].B.BIT\[1\].OBUF0 SLICE_16\[1\].RAM16.SLICE\[1\].RAM8.WORD\[7\].W.BYTE\[3\].B.Q_WIRE\[1\]
+ SLICE_16\[1\].RAM16.SLICE\[1\].RAM8.WORD\[7\].W.BYTE\[3\].B.SEL0_B VGND VGND VPWR
+ VPWR SLICE_16\[1\].RAM16.BYTE\[3\].FLOATBUF0\[25\].Z sky130_fd_sc_hd__ebufn_2
XSLICE_16\[1\].RAM16.SLICE\[1\].RAM8.WORD\[2\].W.BYTE\[1\].B.BIT\[3\].genblk1.STORAGE
+ DIBUF\[11\].X SLICE_16\[1\].RAM16.SLICE\[1\].RAM8.WORD\[2\].W.BYTE\[1\].B.GCLK VGND
+ VGND VPWR VPWR SLICE_16\[1\].RAM16.SLICE\[1\].RAM8.WORD\[2\].W.BYTE\[1\].B.Q_WIRE\[3\]
+ sky130_fd_sc_hd__dlxtp_1
Xtap_5_16 VGND VPWR sky130_fd_sc_hd__tapvpwrvgnd_1
Xtap_5_27 VGND VPWR sky130_fd_sc_hd__tapvpwrvgnd_1
XSLICE_16\[0\].RAM16.SLICE\[1\].RAM8.WORD\[1\].W.CLKBUF SLICE_16\[0\].RAM16.SLICE\[1\].RAM8.CLKBUF.X
+ VGND VGND VPWR VPWR SLICE_16\[0\].RAM16.SLICE\[1\].RAM8.WORD\[1\].W.BYTE\[0\].B.CLK
+ sky130_fd_sc_hd__clkbuf_4
Xfill_47_19 VGND VGND VPWR VPWR sky130_fd_sc_hd__decap_12
XSLICE_16\[0\].RAM16.SLICE\[1\].RAM8.WORD\[5\].W.BYTE\[3\].B.BIT\[0\].genblk1.STORAGE
+ DIBUF\[24\].X SLICE_16\[0\].RAM16.SLICE\[1\].RAM8.WORD\[5\].W.BYTE\[3\].B.GCLK VGND
+ VGND VPWR VPWR SLICE_16\[0\].RAM16.SLICE\[1\].RAM8.WORD\[5\].W.BYTE\[3\].B.Q_WIRE\[0\]
+ sky130_fd_sc_hd__dlxtp_1
Xtap_10_8 VGND VPWR sky130_fd_sc_hd__tapvpwrvgnd_1
XSLICE_16\[1\].RAM16.SLICE\[1\].RAM8.WORD\[4\].W.BYTE\[0\].B.BIT\[6\].OBUF0 SLICE_16\[1\].RAM16.SLICE\[1\].RAM8.WORD\[4\].W.BYTE\[0\].B.Q_WIRE\[6\]
+ SLICE_16\[1\].RAM16.SLICE\[1\].RAM8.WORD\[4\].W.BYTE\[0\].B.SEL0_B VGND VGND VPWR
+ VPWR SLICE_16\[1\].RAM16.BYTE\[0\].FLOATBUF0\[6\].Z sky130_fd_sc_hd__ebufn_2
XSLICE_16\[1\].RAM16.SLICE\[0\].RAM8.WORD\[2\].W.BYTE\[2\].B.BIT\[0\].OBUF0 SLICE_16\[1\].RAM16.SLICE\[0\].RAM8.WORD\[2\].W.BYTE\[2\].B.Q_WIRE\[0\]
+ SLICE_16\[1\].RAM16.SLICE\[0\].RAM8.WORD\[2\].W.BYTE\[2\].B.SEL0_B VGND VGND VPWR
+ VPWR SLICE_16\[1\].RAM16.BYTE\[2\].FLOATBUF0\[16\].Z sky130_fd_sc_hd__ebufn_2
Xtap_24_34 VGND VPWR sky130_fd_sc_hd__tapvpwrvgnd_1
Xtap_24_23 VGND VPWR sky130_fd_sc_hd__tapvpwrvgnd_1
Xtap_24_12 VGND VPWR sky130_fd_sc_hd__tapvpwrvgnd_1
Xtap_3_7 VGND VPWR sky130_fd_sc_hd__tapvpwrvgnd_1
XDo0MUX.M\[2\].DIODE_A0MUX\[22\] Do0MUX.A0\[22\] VGND VGND VPWR VPWR sky130_fd_sc_hd__diode_2
Xtap_40_22 VGND VPWR sky130_fd_sc_hd__tapvpwrvgnd_1
Xtap_40_11 VGND VPWR sky130_fd_sc_hd__tapvpwrvgnd_1
XSLICE_16\[1\].RAM16.SLICE\[0\].RAM8.WORD\[7\].W.BYTE\[2\].B.genblk1.CLKINV SLICE_16\[1\].RAM16.SLICE\[0\].RAM8.WORD\[7\].W.BYTE\[0\].B.CLK
+ VGND VGND VPWR VPWR SLICE_16\[1\].RAM16.SLICE\[0\].RAM8.WORD\[7\].W.BYTE\[2\].B.CLK_B
+ sky130_fd_sc_hd__inv_1
XSLICE_16\[0\].RAM16.SLICE\[0\].RAM8.WORD\[4\].W.BYTE\[1\].B.BIT\[1\].OBUF0 SLICE_16\[0\].RAM16.SLICE\[0\].RAM8.WORD\[4\].W.BYTE\[1\].B.Q_WIRE\[1\]
+ SLICE_16\[0\].RAM16.SLICE\[0\].RAM8.WORD\[4\].W.BYTE\[1\].B.SEL0_B VGND VGND VPWR
+ VPWR SLICE_16\[0\].RAM16.BYTE\[1\].FLOATBUF0\[9\].Z sky130_fd_sc_hd__ebufn_2
XSLICE_16\[1\].RAM16.SLICE\[1\].RAM8.WORD\[4\].W.SEL0BUF SLICE_16\[1\].RAM16.SLICE\[1\].RAM8.DEC0.SEL\[4\]
+ VGND VGND VPWR VPWR SLICE_16\[1\].RAM16.SLICE\[1\].RAM8.WORD\[4\].W.BYTE\[0\].B.SEL0
+ sky130_fd_sc_hd__clkbuf_2
Xfill_17_9 VGND VPWR sky130_fd_sc_hd__tapvpwrvgnd_1
Xfill_0_13 VGND VGND VPWR VPWR sky130_fd_sc_hd__decap_12
XSLICE_16\[0\].RAM16.SLICE\[0\].RAM8.WORD\[0\].W.BYTE\[1\].B.BIT\[5\].genblk1.STORAGE
+ DIBUF\[13\].X SLICE_16\[0\].RAM16.SLICE\[0\].RAM8.WORD\[0\].W.BYTE\[1\].B.GCLK VGND
+ VGND VPWR VPWR SLICE_16\[0\].RAM16.SLICE\[0\].RAM8.WORD\[0\].W.BYTE\[1\].B.Q_WIRE\[5\]
+ sky130_fd_sc_hd__dlxtp_1
XSLICE_16\[0\].RAM16.SLICE\[0\].RAM8.WORD\[2\].W.BYTE\[3\].B.BIT\[6\].genblk1.STORAGE
+ DIBUF\[30\].X SLICE_16\[0\].RAM16.SLICE\[0\].RAM8.WORD\[2\].W.BYTE\[3\].B.GCLK VGND
+ VGND VPWR VPWR SLICE_16\[0\].RAM16.SLICE\[0\].RAM8.WORD\[2\].W.BYTE\[3\].B.Q_WIRE\[6\]
+ sky130_fd_sc_hd__dlxtp_1
XSLICE_16\[0\].RAM16.SLICE\[0\].RAM8.WORD\[6\].W.BYTE\[0\].B.BIT\[4\].genblk1.STORAGE
+ DIBUF\[4\].X SLICE_16\[0\].RAM16.SLICE\[0\].RAM8.WORD\[6\].W.BYTE\[0\].B.GCLK VGND
+ VGND VPWR VPWR SLICE_16\[0\].RAM16.SLICE\[0\].RAM8.WORD\[6\].W.BYTE\[0\].B.Q_WIRE\[4\]
+ sky130_fd_sc_hd__dlxtp_1
XDo0MUX.M\[3\].DIODE_A0MUX\[26\] Do0MUX.A0\[26\] VGND VGND VPWR VPWR sky130_fd_sc_hd__diode_2
XSLICE_16\[1\].RAM16.Do0_REG.OUTREG_BYTE\[2\].DIODE\[1\] SLICE_16\[1\].RAM16.BYTE\[2\].FLOATBUF0\[17\].Z
+ VGND VGND VPWR VPWR sky130_fd_sc_hd__diode_2
Xfill_43_2 VGND VGND VPWR VPWR sky130_fd_sc_hd__decap_12
XSLICE_16\[1\].RAM16.SLICE\[1\].RAM8.WORD\[7\].W.BYTE\[1\].B.BIT\[6\].OBUF0 SLICE_16\[1\].RAM16.SLICE\[1\].RAM8.WORD\[7\].W.BYTE\[1\].B.Q_WIRE\[6\]
+ SLICE_16\[1\].RAM16.SLICE\[1\].RAM8.WORD\[7\].W.BYTE\[1\].B.SEL0_B VGND VGND VPWR
+ VPWR SLICE_16\[1\].RAM16.BYTE\[1\].FLOATBUF0\[14\].Z sky130_fd_sc_hd__ebufn_2
Xfill_36_1 VGND VPWR sky130_fd_sc_hd__tapvpwrvgnd_1
Xfill_29_0 VGND VPWR sky130_fd_sc_hd__tapvpwrvgnd_1
XSLICE_16\[1\].RAM16.SLICE\[0\].RAM8.WORD\[5\].W.BYTE\[3\].B.BIT\[0\].OBUF0 SLICE_16\[1\].RAM16.SLICE\[0\].RAM8.WORD\[5\].W.BYTE\[3\].B.Q_WIRE\[0\]
+ SLICE_16\[1\].RAM16.SLICE\[0\].RAM8.WORD\[5\].W.BYTE\[3\].B.SEL0_B VGND VGND VPWR
+ VPWR SLICE_16\[1\].RAM16.BYTE\[3\].FLOATBUF0\[24\].Z sky130_fd_sc_hd__ebufn_2
Xfill_46_142 VGND VGND VPWR VPWR sky130_fd_sc_hd__decap_12
Xfill_46_131 VGND VGND VPWR VPWR sky130_fd_sc_hd__decap_12
Xfill_46_120 VGND VPWR sky130_fd_sc_hd__tapvpwrvgnd_1
XSLICE_16\[1\].RAM16.SLICE\[0\].RAM8.WORD\[2\].W.BYTE\[0\].B.BIT\[5\].OBUF0 SLICE_16\[1\].RAM16.SLICE\[0\].RAM8.WORD\[2\].W.BYTE\[0\].B.Q_WIRE\[5\]
+ SLICE_16\[1\].RAM16.SLICE\[0\].RAM8.WORD\[2\].W.BYTE\[0\].B.SEL0_B VGND VGND VPWR
+ VPWR SLICE_16\[1\].RAM16.BYTE\[0\].FLOATBUF0\[5\].Z sky130_fd_sc_hd__ebufn_2
XSLICE_16\[0\].RAM16.SLICE\[0\].RAM8.WORD\[7\].W.BYTE\[2\].B.BIT\[1\].OBUF0 SLICE_16\[0\].RAM16.SLICE\[0\].RAM8.WORD\[7\].W.BYTE\[2\].B.Q_WIRE\[1\]
+ SLICE_16\[0\].RAM16.SLICE\[0\].RAM8.WORD\[7\].W.BYTE\[2\].B.SEL0_B VGND VGND VPWR
+ VPWR SLICE_16\[0\].RAM16.BYTE\[2\].FLOATBUF0\[17\].Z sky130_fd_sc_hd__ebufn_2
Xtap_10_14 VGND VPWR sky130_fd_sc_hd__tapvpwrvgnd_1
Xtap_10_25 VGND VPWR sky130_fd_sc_hd__tapvpwrvgnd_1
Xtap_35_33 VGND VPWR sky130_fd_sc_hd__tapvpwrvgnd_1
Xtap_35_22 VGND VPWR sky130_fd_sc_hd__tapvpwrvgnd_1
Xtap_35_11 VGND VPWR sky130_fd_sc_hd__tapvpwrvgnd_1
XDIBUF\[15\].__cell__ Di0[15] VGND VGND VPWR VPWR DIBUF\[15\].X sky130_fd_sc_hd__clkbuf_16
XSLICE_16\[1\].RAM16.SLICE\[1\].RAM8.WORD\[5\].W.BYTE\[2\].B.BIT\[3\].genblk1.STORAGE
+ DIBUF\[19\].X SLICE_16\[1\].RAM16.SLICE\[1\].RAM8.WORD\[5\].W.BYTE\[2\].B.GCLK VGND
+ VGND VPWR VPWR SLICE_16\[1\].RAM16.SLICE\[1\].RAM8.WORD\[5\].W.BYTE\[2\].B.Q_WIRE\[3\]
+ sky130_fd_sc_hd__dlxtp_1
XSLICE_16\[1\].RAM16.SLICE\[0\].RAM8.DEC0.ABUF\[2\] SLICE_16\[1\].RAM16.A0BUF\[2\].X
+ VGND VGND VPWR VPWR SLICE_16\[1\].RAM16.SLICE\[0\].RAM8.DEC0.A_buf\[2\] sky130_fd_sc_hd__clkbuf_2
Xtap_1_4 VGND VPWR sky130_fd_sc_hd__tapvpwrvgnd_1
XSLICE_16\[1\].RAM16.SLICE\[1\].RAM8.WORD\[3\].W.BYTE\[0\].B.BIT\[2\].genblk1.STORAGE
+ DIBUF\[2\].X SLICE_16\[1\].RAM16.SLICE\[1\].RAM8.WORD\[3\].W.BYTE\[0\].B.GCLK VGND
+ VGND VPWR VPWR SLICE_16\[1\].RAM16.SLICE\[1\].RAM8.WORD\[3\].W.BYTE\[0\].B.Q_WIRE\[2\]
+ sky130_fd_sc_hd__dlxtp_1
XSLICE_16\[1\].RAM16.SLICE\[1\].RAM8.WORD\[1\].W.BYTE\[1\].B.genblk1.CLKINV SLICE_16\[1\].RAM16.SLICE\[1\].RAM8.WORD\[1\].W.BYTE\[0\].B.CLK
+ VGND VGND VPWR VPWR SLICE_16\[1\].RAM16.SLICE\[1\].RAM8.WORD\[1\].W.BYTE\[1\].B.CLK_B
+ sky130_fd_sc_hd__inv_1
XSLICE_16\[0\].RAM16.SLICE\[1\].RAM8.WORD\[0\].W.BYTE\[3\].B.BIT\[0\].genblk1.STORAGE
+ DIBUF\[24\].X SLICE_16\[0\].RAM16.SLICE\[1\].RAM8.WORD\[0\].W.BYTE\[3\].B.GCLK VGND
+ VGND VPWR VPWR SLICE_16\[0\].RAM16.SLICE\[1\].RAM8.WORD\[0\].W.BYTE\[3\].B.Q_WIRE\[0\]
+ sky130_fd_sc_hd__dlxtp_1
Xfill_22_7 VGND VGND VPWR VPWR sky130_fd_sc_hd__decap_12
Xfill_43_101 VGND VGND VPWR VPWR sky130_fd_sc_hd__decap_8
Xfill_15_6 VGND VPWR sky130_fd_sc_hd__tapvpwrvgnd_1
XSLICE_16\[1\].RAM16.Do0_REG.OUTREG_BYTE\[1\].Do_FF\[2\] SLICE_16\[1\].RAM16.Do0_REG.CLKBUF\[1\]
+ SLICE_16\[1\].RAM16.BYTE\[1\].FLOATBUF0\[10\].Z VGND VGND VPWR VPWR Do0MUX.A1\[10\]
+ sky130_fd_sc_hd__dfxtp_1
XSLICE_16\[1\].RAM16.SLICE\[0\].RAM8.WORD\[5\].W.BYTE\[1\].B.BIT\[5\].OBUF0 SLICE_16\[1\].RAM16.SLICE\[0\].RAM8.WORD\[5\].W.BYTE\[1\].B.Q_WIRE\[5\]
+ SLICE_16\[1\].RAM16.SLICE\[0\].RAM8.WORD\[5\].W.BYTE\[1\].B.SEL0_B VGND VGND VPWR
+ VPWR SLICE_16\[1\].RAM16.BYTE\[1\].FLOATBUF0\[13\].Z sky130_fd_sc_hd__ebufn_2
XSLICE_16\[0\].RAM16.SLICE\[1\].RAM8.WORD\[2\].W.BYTE\[3\].B.BIT\[4\].OBUF0 SLICE_16\[0\].RAM16.SLICE\[1\].RAM8.WORD\[2\].W.BYTE\[3\].B.Q_WIRE\[4\]
+ SLICE_16\[0\].RAM16.SLICE\[1\].RAM8.WORD\[2\].W.BYTE\[3\].B.SEL0_B VGND VGND VPWR
+ VPWR SLICE_16\[0\].RAM16.BYTE\[3\].FLOATBUF0\[28\].Z sky130_fd_sc_hd__ebufn_2
Xtap_2_28 VGND VPWR sky130_fd_sc_hd__tapvpwrvgnd_1
Xtap_2_17 VGND VPWR sky130_fd_sc_hd__tapvpwrvgnd_1
XSLICE_16\[0\].RAM16.SLICE\[0\].RAM8.WORD\[3\].W.BYTE\[2\].B.BIT\[5\].genblk1.STORAGE
+ DIBUF\[21\].X SLICE_16\[0\].RAM16.SLICE\[0\].RAM8.WORD\[3\].W.BYTE\[2\].B.GCLK VGND
+ VGND VPWR VPWR SLICE_16\[0\].RAM16.SLICE\[0\].RAM8.WORD\[3\].W.BYTE\[2\].B.Q_WIRE\[5\]
+ sky130_fd_sc_hd__dlxtp_1
XSLICE_16\[0\].RAM16.SLICE\[1\].RAM8.WORD\[2\].W.SEL0BUF SLICE_16\[0\].RAM16.SLICE\[1\].RAM8.DEC0.SEL\[2\]
+ VGND VGND VPWR VPWR SLICE_16\[0\].RAM16.SLICE\[1\].RAM8.WORD\[2\].W.BYTE\[0\].B.SEL0
+ sky130_fd_sc_hd__clkbuf_2
XSLICE_16\[0\].RAM16.SLICE\[0\].RAM8.WORD\[1\].W.BYTE\[0\].B.BIT\[4\].genblk1.STORAGE
+ DIBUF\[4\].X SLICE_16\[0\].RAM16.SLICE\[0\].RAM8.WORD\[1\].W.BYTE\[0\].B.GCLK VGND
+ VGND VPWR VPWR SLICE_16\[0\].RAM16.SLICE\[0\].RAM8.WORD\[1\].W.BYTE\[0\].B.Q_WIRE\[4\]
+ sky130_fd_sc_hd__dlxtp_1
XSLICE_16\[0\].RAM16.SLICE\[0\].RAM8.WORD\[7\].W.BYTE\[0\].B.BIT\[6\].OBUF0 SLICE_16\[0\].RAM16.SLICE\[0\].RAM8.WORD\[7\].W.BYTE\[0\].B.Q_WIRE\[6\]
+ SLICE_16\[0\].RAM16.SLICE\[0\].RAM8.WORD\[7\].W.BYTE\[0\].B.SEL0_B VGND VGND VPWR
+ VPWR SLICE_16\[0\].RAM16.BYTE\[0\].FLOATBUF0\[6\].Z sky130_fd_sc_hd__ebufn_2
XSLICE_16\[1\].RAM16.SLICE\[1\].RAM8.WORD\[4\].W.BYTE\[2\].B.genblk1.CLKINV SLICE_16\[1\].RAM16.SLICE\[1\].RAM8.WORD\[4\].W.BYTE\[0\].B.CLK
+ VGND VGND VPWR VPWR SLICE_16\[1\].RAM16.SLICE\[1\].RAM8.WORD\[4\].W.BYTE\[2\].B.CLK_B
+ sky130_fd_sc_hd__inv_1
XSLICE_16\[0\].RAM16.SLICE\[0\].RAM8.WORD\[7\].W.BYTE\[2\].B.SEL0INV SLICE_16\[0\].RAM16.SLICE\[0\].RAM8.WORD\[7\].W.BYTE\[0\].B.SEL0
+ VGND VGND VPWR VPWR SLICE_16\[0\].RAM16.SLICE\[0\].RAM8.WORD\[7\].W.BYTE\[2\].B.SEL0_B
+ sky130_fd_sc_hd__inv_1
Xfill_18_21 VGND VPWR sky130_fd_sc_hd__tapvpwrvgnd_1
Xfill_18_10 VGND VGND VPWR VPWR sky130_fd_sc_hd__decap_12
XSLICE_16\[0\].RAM16.SLICE\[1\].RAM8.WORD\[1\].W.BYTE\[1\].B.BIT\[1\].OBUF0 SLICE_16\[0\].RAM16.SLICE\[1\].RAM8.WORD\[1\].W.BYTE\[1\].B.Q_WIRE\[1\]
+ SLICE_16\[0\].RAM16.SLICE\[1\].RAM8.WORD\[1\].W.BYTE\[1\].B.SEL0_B VGND VGND VPWR
+ VPWR SLICE_16\[0\].RAM16.BYTE\[1\].FLOATBUF0\[9\].Z sky130_fd_sc_hd__ebufn_2
XSLICE_16\[1\].RAM16.SLICE\[1\].RAM8.WORD\[6\].W.BYTE\[1\].B.BIT\[2\].genblk1.STORAGE
+ DIBUF\[10\].X SLICE_16\[1\].RAM16.SLICE\[1\].RAM8.WORD\[6\].W.BYTE\[1\].B.GCLK VGND
+ VGND VPWR VPWR SLICE_16\[1\].RAM16.SLICE\[1\].RAM8.WORD\[6\].W.BYTE\[1\].B.Q_WIRE\[2\]
+ sky130_fd_sc_hd__dlxtp_1
XSLICE_16\[1\].RAM16.SLICE\[1\].RAM8.WORD\[0\].W.BYTE\[2\].B.BIT\[3\].genblk1.STORAGE
+ DIBUF\[19\].X SLICE_16\[1\].RAM16.SLICE\[1\].RAM8.WORD\[0\].W.BYTE\[2\].B.GCLK VGND
+ VGND VPWR VPWR SLICE_16\[1\].RAM16.SLICE\[1\].RAM8.WORD\[0\].W.BYTE\[2\].B.Q_WIRE\[3\]
+ sky130_fd_sc_hd__dlxtp_1
Xfill_20_4 VGND VGND VPWR VPWR sky130_fd_sc_hd__decap_12
Xfill_13_3 VGND VPWR sky130_fd_sc_hd__tapvpwrvgnd_1
XSLICE_16\[0\].RAM16.SLICE\[0\].RAM8.WORD\[1\].W.BYTE\[0\].B.genblk1.CLKINV SLICE_16\[0\].RAM16.SLICE\[0\].RAM8.WORD\[1\].W.BYTE\[0\].B.CLK
+ VGND VGND VPWR VPWR SLICE_16\[0\].RAM16.SLICE\[0\].RAM8.WORD\[1\].W.BYTE\[0\].B.CLK_B
+ sky130_fd_sc_hd__inv_1
XSLICE_16\[0\].RAM16.SLICE\[0\].RAM8.WORD\[0\].W.BYTE\[3\].B.BIT\[3\].OBUF0 SLICE_16\[0\].RAM16.SLICE\[0\].RAM8.WORD\[0\].W.BYTE\[3\].B.Q_WIRE\[3\]
+ SLICE_16\[0\].RAM16.SLICE\[0\].RAM8.WORD\[0\].W.BYTE\[3\].B.SEL0_B VGND VGND VPWR
+ VPWR SLICE_16\[0\].RAM16.BYTE\[3\].FLOATBUF0\[27\].Z sky130_fd_sc_hd__ebufn_2
XSLICE_16\[1\].RAM16.SLICE\[1\].RAM8.WORD\[2\].W.BYTE\[3\].B.BIT\[0\].OBUF0 SLICE_16\[1\].RAM16.SLICE\[1\].RAM8.WORD\[2\].W.BYTE\[3\].B.Q_WIRE\[0\]
+ SLICE_16\[1\].RAM16.SLICE\[1\].RAM8.WORD\[2\].W.BYTE\[3\].B.SEL0_B VGND VGND VPWR
+ VPWR SLICE_16\[1\].RAM16.BYTE\[3\].FLOATBUF0\[24\].Z sky130_fd_sc_hd__ebufn_2
XSLICE_16\[1\].RAM16.SLICE\[1\].RAM8.WORD\[7\].W.BYTE\[3\].B.genblk1.CLKINV SLICE_16\[1\].RAM16.SLICE\[1\].RAM8.WORD\[7\].W.BYTE\[0\].B.CLK
+ VGND VGND VPWR VPWR SLICE_16\[1\].RAM16.SLICE\[1\].RAM8.WORD\[7\].W.BYTE\[3\].B.CLK_B
+ sky130_fd_sc_hd__inv_1
Xtap_28_9 VGND VPWR sky130_fd_sc_hd__tapvpwrvgnd_1
XSLICE_16\[0\].RAM16.SLICE\[1\].RAM8.WORD\[0\].W.BYTE\[2\].B.genblk1.CG SLICE_16\[0\].RAM16.SLICE\[1\].RAM8.WORD\[0\].W.BYTE\[2\].B.CLK_B
+ SLICE_16\[0\].RAM16.SLICE\[1\].RAM8.WORD\[0\].W.BYTE\[2\].B.WE0_WIRE VGND VGND VPWR
+ VPWR SLICE_16\[0\].RAM16.SLICE\[1\].RAM8.WORD\[0\].W.BYTE\[2\].B.GCLK sky130_fd_sc_hd__dlclkp_1
Xtap_16_35 VGND VPWR sky130_fd_sc_hd__tapvpwrvgnd_1
Xtap_16_24 VGND VPWR sky130_fd_sc_hd__tapvpwrvgnd_1
Xtap_16_13 VGND VPWR sky130_fd_sc_hd__tapvpwrvgnd_1
Xtap_32_34 VGND VPWR sky130_fd_sc_hd__tapvpwrvgnd_1
Xtap_32_23 VGND VPWR sky130_fd_sc_hd__tapvpwrvgnd_1
Xtap_32_12 VGND VPWR sky130_fd_sc_hd__tapvpwrvgnd_1
XSLICE_16\[1\].RAM16.SLICE\[0\].RAM8.WORD\[7\].W.BYTE\[0\].B.BIT\[2\].OBUF0 SLICE_16\[1\].RAM16.SLICE\[0\].RAM8.WORD\[7\].W.BYTE\[0\].B.Q_WIRE\[2\]
+ SLICE_16\[1\].RAM16.SLICE\[0\].RAM8.WORD\[7\].W.BYTE\[0\].B.SEL0_B VGND VGND VPWR
+ VPWR SLICE_16\[1\].RAM16.BYTE\[0\].FLOATBUF0\[2\].Z sky130_fd_sc_hd__ebufn_2
XSLICE_16\[1\].RAM16.SLICE\[0\].RAM8.DEC0.AND0 SLICE_16\[1\].RAM16.SLICE\[0\].RAM8.DEC0.A_buf\[0\]
+ SLICE_16\[1\].RAM16.SLICE\[0\].RAM8.DEC0.A_buf\[1\] SLICE_16\[1\].RAM16.SLICE\[0\].RAM8.DEC0.A_buf\[2\]
+ SLICE_16\[1\].RAM16.SLICE\[0\].RAM8.DEC0.EN_buf VGND VGND VPWR VPWR SLICE_16\[1\].RAM16.SLICE\[0\].RAM8.DEC0.SEL\[0\]
+ sky130_fd_sc_hd__nor4b_2
XSLICE_16\[0\].RAM16.Do0_REG.OUTREG_BYTE\[0\].DIODE\[2\] SLICE_16\[0\].RAM16.BYTE\[0\].FLOATBUF0\[2\].Z
+ VGND VGND VPWR VPWR sky130_fd_sc_hd__diode_2
XSLICE_16\[0\].RAM16.SLICE\[1\].RAM8.WORD\[4\].W.BYTE\[2\].B.BIT\[1\].OBUF0 SLICE_16\[0\].RAM16.SLICE\[1\].RAM8.WORD\[4\].W.BYTE\[2\].B.Q_WIRE\[1\]
+ SLICE_16\[0\].RAM16.SLICE\[1\].RAM8.WORD\[4\].W.BYTE\[2\].B.SEL0_B VGND VGND VPWR
+ VPWR SLICE_16\[0\].RAM16.BYTE\[2\].FLOATBUF0\[17\].Z sky130_fd_sc_hd__ebufn_2
Xtap_47_1 VGND VPWR sky130_fd_sc_hd__tapvpwrvgnd_1
XSLICE_16\[1\].RAM16.SLICE\[0\].RAM8.WORD\[5\].W.BYTE\[1\].B.CGAND SLICE_16\[1\].RAM16.SLICE\[0\].RAM8.WORD\[5\].W.BYTE\[0\].B.SEL0
+ SLICE_16\[1\].RAM16.SLICE\[0\].RAM8.WE0_buf\[1\] VGND VGND VPWR VPWR SLICE_16\[1\].RAM16.SLICE\[0\].RAM8.WORD\[5\].W.BYTE\[1\].B.WE0_WIRE
+ sky130_fd_sc_hd__and2_1
Xfill_20_44 VGND VGND VPWR VPWR sky130_fd_sc_hd__decap_12
Xfill_20_33 VGND VPWR sky130_fd_sc_hd__tapvpwrvgnd_1
Xfill_20_22 VGND VGND VPWR VPWR sky130_fd_sc_hd__decap_12
Xfill_20_11 VGND VGND VPWR VPWR sky130_fd_sc_hd__decap_12
XSLICE_16\[0\].RAM16.SLICE\[0\].RAM8.WORD\[6\].W.BYTE\[3\].B.BIT\[5\].genblk1.STORAGE
+ DIBUF\[29\].X SLICE_16\[0\].RAM16.SLICE\[0\].RAM8.WORD\[6\].W.BYTE\[3\].B.GCLK VGND
+ VGND VPWR VPWR SLICE_16\[0\].RAM16.SLICE\[0\].RAM8.WORD\[6\].W.BYTE\[3\].B.Q_WIRE\[5\]
+ sky130_fd_sc_hd__dlxtp_1
Xfill_20_99 VGND VPWR sky130_fd_sc_hd__tapvpwrvgnd_1
Xfill_20_88 VGND VGND VPWR VPWR sky130_fd_sc_hd__decap_12
Xfill_20_77 VGND VGND VPWR VPWR sky130_fd_sc_hd__decap_12
Xfill_20_66 VGND VPWR sky130_fd_sc_hd__tapvpwrvgnd_1
Xfill_20_55 VGND VGND VPWR VPWR sky130_fd_sc_hd__decap_12
XSLICE_16\[0\].RAM16.SLICE\[0\].RAM8.WORD\[4\].W.BYTE\[1\].B.BIT\[4\].genblk1.STORAGE
+ DIBUF\[12\].X SLICE_16\[0\].RAM16.SLICE\[0\].RAM8.WORD\[4\].W.BYTE\[1\].B.GCLK VGND
+ VGND VPWR VPWR SLICE_16\[0\].RAM16.SLICE\[0\].RAM8.WORD\[4\].W.BYTE\[1\].B.Q_WIRE\[4\]
+ sky130_fd_sc_hd__dlxtp_1
Xfill_45_74 VGND VGND VPWR VPWR sky130_fd_sc_hd__decap_12
Xfill_45_63 VGND VPWR sky130_fd_sc_hd__tapvpwrvgnd_1
Xfill_45_52 VGND VGND VPWR VPWR sky130_fd_sc_hd__decap_12
Xfill_45_41 VGND VGND VPWR VPWR sky130_fd_sc_hd__decap_12
Xfill_45_30 VGND VPWR sky130_fd_sc_hd__tapvpwrvgnd_1
XSLICE_16\[0\].RAM16.SLICE\[0\].RAM8.WORD\[4\].W.BYTE\[1\].B.genblk1.CLKINV SLICE_16\[0\].RAM16.SLICE\[0\].RAM8.WORD\[4\].W.BYTE\[0\].B.CLK
+ VGND VGND VPWR VPWR SLICE_16\[0\].RAM16.SLICE\[0\].RAM8.WORD\[4\].W.BYTE\[1\].B.CLK_B
+ sky130_fd_sc_hd__inv_1
XSLICE_16\[0\].RAM16.SLICE\[0\].RAM8.WORD\[7\].W.BYTE\[1\].B.genblk1.CG SLICE_16\[0\].RAM16.SLICE\[0\].RAM8.WORD\[7\].W.BYTE\[1\].B.CLK_B
+ SLICE_16\[0\].RAM16.SLICE\[0\].RAM8.WORD\[7\].W.BYTE\[1\].B.WE0_WIRE VGND VGND VPWR
+ VPWR SLICE_16\[0\].RAM16.SLICE\[0\].RAM8.WORD\[7\].W.BYTE\[1\].B.GCLK sky130_fd_sc_hd__dlclkp_1
Xfill_45_96 VGND VPWR sky130_fd_sc_hd__tapvpwrvgnd_1
Xfill_45_85 VGND VGND VPWR VPWR sky130_fd_sc_hd__decap_12
XSLICE_16\[1\].RAM16.SLICE\[1\].RAM8.WORD\[2\].W.BYTE\[1\].B.BIT\[5\].OBUF0 SLICE_16\[1\].RAM16.SLICE\[1\].RAM8.WORD\[2\].W.BYTE\[1\].B.Q_WIRE\[5\]
+ SLICE_16\[1\].RAM16.SLICE\[1\].RAM8.WORD\[2\].W.BYTE\[1\].B.SEL0_B VGND VGND VPWR
+ VPWR SLICE_16\[1\].RAM16.BYTE\[1\].FLOATBUF0\[13\].Z sky130_fd_sc_hd__ebufn_2
XSLICE_16\[0\].RAM16.SLICE\[1\].RAM8.WORD\[7\].W.BYTE\[3\].B.BIT\[1\].OBUF0 SLICE_16\[0\].RAM16.SLICE\[1\].RAM8.WORD\[7\].W.BYTE\[3\].B.Q_WIRE\[1\]
+ SLICE_16\[0\].RAM16.SLICE\[1\].RAM8.WORD\[7\].W.BYTE\[3\].B.SEL0_B VGND VGND VPWR
+ VPWR SLICE_16\[0\].RAM16.BYTE\[3\].FLOATBUF0\[25\].Z sky130_fd_sc_hd__ebufn_2
XSLICE_16\[0\].RAM16.BYTE\[0\].FLOATBUF0\[6\].__cell__ SLICE_16\[0\].RAM16.BYTE\[0\].FLOATBUF0\[0\].A
+ SLICE_16\[0\].RAM16.BYTE\[0\].FLOATBUF0\[0\].TE_B VGND VGND VPWR VPWR SLICE_16\[0\].RAM16.BYTE\[0\].FLOATBUF0\[6\].Z
+ sky130_fd_sc_hd__ebufn_2
Xfill_11_0 VGND VPWR sky130_fd_sc_hd__tapvpwrvgnd_1
Xtap_8_16 VGND VPWR sky130_fd_sc_hd__tapvpwrvgnd_1
Xtap_8_27 VGND VPWR sky130_fd_sc_hd__tapvpwrvgnd_1
Xfill_9_2 VGND VPWR sky130_fd_sc_hd__tapvpwrvgnd_1
Xtap_40_8 VGND VPWR sky130_fd_sc_hd__tapvpwrvgnd_1
XSLICE_16\[1\].RAM16.SLICE\[1\].RAM8.WORD\[3\].W.BYTE\[3\].B.BIT\[3\].genblk1.STORAGE
+ DIBUF\[27\].X SLICE_16\[1\].RAM16.SLICE\[1\].RAM8.WORD\[3\].W.BYTE\[3\].B.GCLK VGND
+ VGND VPWR VPWR SLICE_16\[1\].RAM16.SLICE\[1\].RAM8.WORD\[3\].W.BYTE\[3\].B.Q_WIRE\[3\]
+ sky130_fd_sc_hd__dlxtp_1
XSLICE_16\[0\].RAM16.SLICE\[0\].RAM8.WORD\[7\].W.BYTE\[3\].B.CGAND SLICE_16\[0\].RAM16.SLICE\[0\].RAM8.WORD\[7\].W.BYTE\[0\].B.SEL0
+ SLICE_16\[0\].RAM16.SLICE\[0\].RAM8.WE0_buf\[3\] VGND VGND VPWR VPWR SLICE_16\[0\].RAM16.SLICE\[0\].RAM8.WORD\[7\].W.BYTE\[3\].B.WE0_WIRE
+ sky130_fd_sc_hd__and2_1
XSLICE_16\[1\].RAM16.SLICE\[1\].RAM8.WORD\[7\].W.BYTE\[0\].B.BIT\[1\].genblk1.STORAGE
+ DIBUF\[1\].X SLICE_16\[1\].RAM16.SLICE\[1\].RAM8.WORD\[7\].W.BYTE\[0\].B.GCLK VGND
+ VGND VPWR VPWR SLICE_16\[1\].RAM16.SLICE\[1\].RAM8.WORD\[7\].W.BYTE\[0\].B.Q_WIRE\[1\]
+ sky130_fd_sc_hd__dlxtp_1
Xtap_33_7 VGND VPWR sky130_fd_sc_hd__tapvpwrvgnd_1
XSLICE_16\[1\].RAM16.SLICE\[1\].RAM8.WORD\[1\].W.BYTE\[1\].B.BIT\[2\].genblk1.STORAGE
+ DIBUF\[10\].X SLICE_16\[1\].RAM16.SLICE\[1\].RAM8.WORD\[1\].W.BYTE\[1\].B.GCLK VGND
+ VGND VPWR VPWR SLICE_16\[1\].RAM16.SLICE\[1\].RAM8.WORD\[1\].W.BYTE\[1\].B.Q_WIRE\[2\]
+ sky130_fd_sc_hd__dlxtp_1
Xtap_27_34 VGND VPWR sky130_fd_sc_hd__tapvpwrvgnd_1
Xtap_27_23 VGND VPWR sky130_fd_sc_hd__tapvpwrvgnd_1
Xtap_27_12 VGND VPWR sky130_fd_sc_hd__tapvpwrvgnd_1
XSLICE_16\[1\].RAM16.SLICE\[0\].RAM8.WORD\[4\].W.BYTE\[0\].B.genblk1.CG SLICE_16\[1\].RAM16.SLICE\[0\].RAM8.WORD\[4\].W.BYTE\[0\].B.CLK_B
+ SLICE_16\[1\].RAM16.SLICE\[0\].RAM8.WORD\[4\].W.BYTE\[0\].B.WE0_WIRE VGND VGND VPWR
+ VPWR SLICE_16\[1\].RAM16.SLICE\[0\].RAM8.WORD\[4\].W.BYTE\[0\].B.GCLK sky130_fd_sc_hd__dlclkp_1
Xtap_26_6 VGND VPWR sky130_fd_sc_hd__tapvpwrvgnd_1
XSLICE_16\[0\].RAM16.SLICE\[1\].RAM8.WORD\[4\].W.BYTE\[0\].B.BIT\[6\].OBUF0 SLICE_16\[0\].RAM16.SLICE\[1\].RAM8.WORD\[4\].W.BYTE\[0\].B.Q_WIRE\[6\]
+ SLICE_16\[0\].RAM16.SLICE\[1\].RAM8.WORD\[4\].W.BYTE\[0\].B.SEL0_B VGND VGND VPWR
+ VPWR SLICE_16\[0\].RAM16.BYTE\[0\].FLOATBUF0\[6\].Z sky130_fd_sc_hd__ebufn_2
XSLICE_16\[0\].RAM16.SLICE\[0\].RAM8.WEBUF\[0\].__cell__ SLICE_16\[0\].RAM16.SLICE\[0\].RAM8.WE0\[0\]
+ VGND VGND VPWR VPWR SLICE_16\[0\].RAM16.SLICE\[0\].RAM8.WE0_buf\[0\] sky130_fd_sc_hd__clkbuf_2
XSLICE_16\[0\].RAM16.SLICE\[0\].RAM8.WORD\[2\].W.BYTE\[2\].B.BIT\[0\].OBUF0 SLICE_16\[0\].RAM16.SLICE\[0\].RAM8.WORD\[2\].W.BYTE\[2\].B.Q_WIRE\[0\]
+ SLICE_16\[0\].RAM16.SLICE\[0\].RAM8.WORD\[2\].W.BYTE\[2\].B.SEL0_B VGND VGND VPWR
+ VPWR SLICE_16\[0\].RAM16.BYTE\[2\].FLOATBUF0\[16\].Z sky130_fd_sc_hd__ebufn_2
XSLICE_16\[0\].RAM16.SLICE\[0\].RAM8.WORD\[7\].W.BYTE\[2\].B.genblk1.CLKINV SLICE_16\[0\].RAM16.SLICE\[0\].RAM8.WORD\[7\].W.BYTE\[0\].B.CLK
+ VGND VGND VPWR VPWR SLICE_16\[0\].RAM16.SLICE\[0\].RAM8.WORD\[7\].W.BYTE\[2\].B.CLK_B
+ sky130_fd_sc_hd__inv_1
XSLICE_16\[1\].RAM16.SLICE\[0\].RAM8.WORD\[1\].W.BYTE\[3\].B.BIT\[7\].OBUF0 SLICE_16\[1\].RAM16.SLICE\[0\].RAM8.WORD\[1\].W.BYTE\[3\].B.Q_WIRE\[7\]
+ SLICE_16\[1\].RAM16.SLICE\[0\].RAM8.WORD\[1\].W.BYTE\[3\].B.SEL0_B VGND VGND VPWR
+ VPWR SLICE_16\[1\].RAM16.BYTE\[3\].FLOATBUF0\[31\].Z sky130_fd_sc_hd__ebufn_2
XDo0MUX.M\[0\].DIODE_A0MUX\[4\] Do0MUX.A0\[4\] VGND VGND VPWR VPWR sky130_fd_sc_hd__diode_2
XSLICE_16\[1\].RAM16.SLICE\[0\].RAM8.WORD\[5\].W.BYTE\[2\].B.SEL0INV SLICE_16\[1\].RAM16.SLICE\[0\].RAM8.WORD\[5\].W.BYTE\[0\].B.SEL0
+ VGND VGND VPWR VPWR SLICE_16\[1\].RAM16.SLICE\[0\].RAM8.WORD\[5\].W.BYTE\[2\].B.SEL0_B
+ sky130_fd_sc_hd__inv_1
Xfill_47_9 VGND VPWR sky130_fd_sc_hd__tapvpwrvgnd_1
XSLICE_16\[1\].RAM16.SLICE\[1\].RAM8.WORD\[6\].W.BYTE\[0\].B.CGAND SLICE_16\[1\].RAM16.SLICE\[1\].RAM8.WORD\[6\].W.BYTE\[0\].B.SEL0
+ SLICE_16\[1\].RAM16.SLICE\[1\].RAM8.WE0_buf\[0\] VGND VGND VPWR VPWR SLICE_16\[1\].RAM16.SLICE\[1\].RAM8.WORD\[6\].W.BYTE\[0\].B.WE0_WIRE
+ sky130_fd_sc_hd__and2_1
XSLICE_16\[1\].RAM16.SLICE\[1\].RAM8.WORD\[5\].W.BYTE\[2\].B.BIT\[5\].OBUF0 SLICE_16\[1\].RAM16.SLICE\[1\].RAM8.WORD\[5\].W.BYTE\[2\].B.Q_WIRE\[5\]
+ SLICE_16\[1\].RAM16.SLICE\[1\].RAM8.WORD\[5\].W.BYTE\[2\].B.SEL0_B VGND VGND VPWR
+ VPWR SLICE_16\[1\].RAM16.BYTE\[2\].FLOATBUF0\[21\].Z sky130_fd_sc_hd__ebufn_2
XSLICE_16\[1\].RAM16.SLICE\[0\].RAM8.WORD\[4\].W.BYTE\[0\].B.BIT\[7\].genblk1.STORAGE
+ DIBUF\[7\].X SLICE_16\[1\].RAM16.SLICE\[0\].RAM8.WORD\[4\].W.BYTE\[0\].B.GCLK VGND
+ VGND VPWR VPWR SLICE_16\[1\].RAM16.SLICE\[0\].RAM8.WORD\[4\].W.BYTE\[0\].B.Q_WIRE\[7\]
+ sky130_fd_sc_hd__dlxtp_1
XSLICE_16\[0\].RAM16.SLICE\[1\].RAM8.WORD\[7\].W.BYTE\[1\].B.BIT\[6\].OBUF0 SLICE_16\[0\].RAM16.SLICE\[1\].RAM8.WORD\[7\].W.BYTE\[1\].B.Q_WIRE\[6\]
+ SLICE_16\[0\].RAM16.SLICE\[1\].RAM8.WORD\[7\].W.BYTE\[1\].B.SEL0_B VGND VGND VPWR
+ VPWR SLICE_16\[0\].RAM16.BYTE\[1\].FLOATBUF0\[14\].Z sky130_fd_sc_hd__ebufn_2
XSLICE_16\[0\].RAM16.SLICE\[0\].RAM8.WORD\[1\].W.BYTE\[3\].B.BIT\[5\].genblk1.STORAGE
+ DIBUF\[29\].X SLICE_16\[0\].RAM16.SLICE\[0\].RAM8.WORD\[1\].W.BYTE\[3\].B.GCLK VGND
+ VGND VPWR VPWR SLICE_16\[0\].RAM16.SLICE\[0\].RAM8.WORD\[1\].W.BYTE\[3\].B.Q_WIRE\[5\]
+ sky130_fd_sc_hd__dlxtp_1
XSLICE_16\[0\].RAM16.SLICE\[0\].RAM8.WORD\[4\].W.CLKBUF SLICE_16\[0\].RAM16.SLICE\[0\].RAM8.CLKBUF.X
+ VGND VGND VPWR VPWR SLICE_16\[0\].RAM16.SLICE\[0\].RAM8.WORD\[4\].W.BYTE\[0\].B.CLK
+ sky130_fd_sc_hd__clkbuf_4
XSLICE_16\[0\].RAM16.SLICE\[0\].RAM8.WORD\[7\].W.BYTE\[2\].B.BIT\[4\].genblk1.STORAGE
+ DIBUF\[20\].X SLICE_16\[0\].RAM16.SLICE\[0\].RAM8.WORD\[7\].W.BYTE\[2\].B.GCLK VGND
+ VGND VPWR VPWR SLICE_16\[0\].RAM16.SLICE\[0\].RAM8.WORD\[7\].W.BYTE\[2\].B.Q_WIRE\[4\]
+ sky130_fd_sc_hd__dlxtp_1
XSLICE_16\[1\].RAM16.SLICE\[0\].RAM8.WORD\[0\].W.BYTE\[1\].B.BIT\[4\].OBUF0 SLICE_16\[1\].RAM16.SLICE\[0\].RAM8.WORD\[0\].W.BYTE\[1\].B.Q_WIRE\[4\]
+ SLICE_16\[1\].RAM16.SLICE\[0\].RAM8.WORD\[0\].W.BYTE\[1\].B.SEL0_B VGND VGND VPWR
+ VPWR SLICE_16\[1\].RAM16.BYTE\[1\].FLOATBUF0\[12\].Z sky130_fd_sc_hd__ebufn_2
XSLICE_16\[0\].RAM16.SLICE\[0\].RAM8.WORD\[5\].W.BYTE\[0\].B.BIT\[3\].genblk1.STORAGE
+ DIBUF\[3\].X SLICE_16\[0\].RAM16.SLICE\[0\].RAM8.WORD\[5\].W.BYTE\[0\].B.GCLK VGND
+ VGND VPWR VPWR SLICE_16\[0\].RAM16.SLICE\[0\].RAM8.WORD\[5\].W.BYTE\[0\].B.Q_WIRE\[3\]
+ sky130_fd_sc_hd__dlxtp_1
XSLICE_16\[0\].RAM16.SLICE\[0\].RAM8.WORD\[5\].W.BYTE\[3\].B.BIT\[0\].OBUF0 SLICE_16\[0\].RAM16.SLICE\[0\].RAM8.WORD\[5\].W.BYTE\[3\].B.Q_WIRE\[0\]
+ SLICE_16\[0\].RAM16.SLICE\[0\].RAM8.WORD\[5\].W.BYTE\[3\].B.SEL0_B VGND VGND VPWR
+ VPWR SLICE_16\[0\].RAM16.BYTE\[3\].FLOATBUF0\[24\].Z sky130_fd_sc_hd__ebufn_2
XSLICE_16\[0\].RAM16.SLICE\[0\].RAM8.WORD\[3\].W.BYTE\[3\].B.SEL0INV SLICE_16\[0\].RAM16.SLICE\[0\].RAM8.WORD\[3\].W.BYTE\[0\].B.SEL0
+ VGND VGND VPWR VPWR SLICE_16\[0\].RAM16.SLICE\[0\].RAM8.WORD\[3\].W.BYTE\[3\].B.SEL0_B
+ sky130_fd_sc_hd__inv_1
Xtap_13_36 VGND VPWR sky130_fd_sc_hd__tapvpwrvgnd_1
Xtap_13_25 VGND VPWR sky130_fd_sc_hd__tapvpwrvgnd_1
Xtap_13_14 VGND VPWR sky130_fd_sc_hd__tapvpwrvgnd_1
XSLICE_16\[0\].RAM16.SLICE\[0\].RAM8.WORD\[2\].W.BYTE\[0\].B.BIT\[5\].OBUF0 SLICE_16\[0\].RAM16.SLICE\[0\].RAM8.WORD\[2\].W.BYTE\[0\].B.Q_WIRE\[5\]
+ SLICE_16\[0\].RAM16.SLICE\[0\].RAM8.WORD\[2\].W.BYTE\[0\].B.SEL0_B VGND VGND VPWR
+ VPWR SLICE_16\[0\].RAM16.BYTE\[0\].FLOATBUF0\[5\].Z sky130_fd_sc_hd__ebufn_2
Xtap_38_22 VGND VPWR sky130_fd_sc_hd__tapvpwrvgnd_1
Xtap_38_11 VGND VPWR sky130_fd_sc_hd__tapvpwrvgnd_1
XSLICE_16\[1\].RAM16.SLICE\[1\].RAM8.WORD\[4\].W.BYTE\[0\].B.BIT\[2\].OBUF0 SLICE_16\[1\].RAM16.SLICE\[1\].RAM8.WORD\[4\].W.BYTE\[0\].B.Q_WIRE\[2\]
+ SLICE_16\[1\].RAM16.SLICE\[1\].RAM8.WORD\[4\].W.BYTE\[0\].B.SEL0_B VGND VGND VPWR
+ VPWR SLICE_16\[1\].RAM16.BYTE\[0\].FLOATBUF0\[2\].Z sky130_fd_sc_hd__ebufn_2
Xtap_31_4 VGND VPWR sky130_fd_sc_hd__tapvpwrvgnd_1
XSLICE_16\[0\].RAM16.SLICE\[0\].RAM8.WORD\[0\].W.BYTE\[2\].B.DIODE_CLK SLICE_16\[0\].RAM16.SLICE\[0\].RAM8.WORD\[0\].W.BYTE\[0\].B.CLK
+ VGND VGND VPWR VPWR sky130_fd_sc_hd__diode_2
XSLICE_16\[0\].RAM16.SLICE\[0\].RAM8.DEC0.AND4 SLICE_16\[0\].RAM16.SLICE\[0\].RAM8.DEC0.A_buf\[0\]
+ SLICE_16\[0\].RAM16.SLICE\[0\].RAM8.DEC0.A_buf\[1\] SLICE_16\[0\].RAM16.SLICE\[0\].RAM8.DEC0.A_buf\[2\]
+ SLICE_16\[0\].RAM16.SLICE\[0\].RAM8.DEC0.EN_buf VGND VGND VPWR VPWR SLICE_16\[0\].RAM16.SLICE\[0\].RAM8.DEC0.SEL\[4\]
+ sky130_fd_sc_hd__and4bb_2
Xtap_38_33 VGND VPWR sky130_fd_sc_hd__tapvpwrvgnd_1
XSLICE_16\[1\].RAM16.SLICE\[1\].RAM8.WORD\[3\].W.SEL0BUF SLICE_16\[1\].RAM16.SLICE\[1\].RAM8.DEC0.SEL\[3\]
+ VGND VGND VPWR VPWR SLICE_16\[1\].RAM16.SLICE\[1\].RAM8.WORD\[3\].W.BYTE\[0\].B.SEL0
+ sky130_fd_sc_hd__clkbuf_2
Xtap_24_3 VGND VPWR sky130_fd_sc_hd__tapvpwrvgnd_1
Xtap_17_2 VGND VPWR sky130_fd_sc_hd__tapvpwrvgnd_1
Xfill_42_97 VGND VGND VPWR VPWR sky130_fd_sc_hd__decap_12
Xfill_42_86 VGND VGND VPWR VPWR sky130_fd_sc_hd__decap_12
Xfill_42_75 VGND VPWR sky130_fd_sc_hd__tapvpwrvgnd_1
Xfill_42_64 VGND VGND VPWR VPWR sky130_fd_sc_hd__decap_12
Xfill_42_53 VGND VGND VPWR VPWR sky130_fd_sc_hd__decap_12
Xfill_42_42 VGND VPWR sky130_fd_sc_hd__tapvpwrvgnd_1
Xfill_42_31 VGND VGND VPWR VPWR sky130_fd_sc_hd__decap_12
Xfill_42_20 VGND VGND VPWR VPWR sky130_fd_sc_hd__decap_12
XSLICE_16\[1\].RAM16.SLICE\[1\].RAM8.WORD\[4\].W.BYTE\[2\].B.BIT\[2\].genblk1.STORAGE
+ DIBUF\[18\].X SLICE_16\[1\].RAM16.SLICE\[1\].RAM8.WORD\[4\].W.BYTE\[2\].B.GCLK VGND
+ VGND VPWR VPWR SLICE_16\[1\].RAM16.SLICE\[1\].RAM8.WORD\[4\].W.BYTE\[2\].B.Q_WIRE\[2\]
+ sky130_fd_sc_hd__dlxtp_1
XSLICE_16\[1\].RAM16.SLICE\[0\].RAM8.WORD\[3\].W.BYTE\[2\].B.BIT\[4\].OBUF0 SLICE_16\[1\].RAM16.SLICE\[0\].RAM8.WORD\[3\].W.BYTE\[2\].B.Q_WIRE\[4\]
+ SLICE_16\[1\].RAM16.SLICE\[0\].RAM8.WORD\[3\].W.BYTE\[2\].B.SEL0_B VGND VGND VPWR
+ VPWR SLICE_16\[1\].RAM16.BYTE\[2\].FLOATBUF0\[20\].Z sky130_fd_sc_hd__ebufn_2
XSLICE_16\[0\].RAM16.SLICE\[1\].RAM8.WORD\[1\].W.BYTE\[1\].B.genblk1.CLKINV SLICE_16\[0\].RAM16.SLICE\[1\].RAM8.WORD\[1\].W.BYTE\[0\].B.CLK
+ VGND VGND VPWR VPWR SLICE_16\[0\].RAM16.SLICE\[1\].RAM8.WORD\[1\].W.BYTE\[1\].B.CLK_B
+ sky130_fd_sc_hd__inv_1
XSLICE_16\[1\].RAM16.SLICE\[1\].RAM8.WORD\[2\].W.BYTE\[0\].B.BIT\[1\].genblk1.STORAGE
+ DIBUF\[1\].X SLICE_16\[1\].RAM16.SLICE\[1\].RAM8.WORD\[2\].W.BYTE\[0\].B.GCLK VGND
+ VGND VPWR VPWR SLICE_16\[1\].RAM16.SLICE\[1\].RAM8.WORD\[2\].W.BYTE\[0\].B.Q_WIRE\[1\]
+ sky130_fd_sc_hd__dlxtp_1
XDo0MUX.M\[1\].DIODE_A0MUX\[11\] Do0MUX.A0\[11\] VGND VGND VPWR VPWR sky130_fd_sc_hd__diode_2
Xfill_45_6 VGND VPWR sky130_fd_sc_hd__tapvpwrvgnd_1
Xfill_38_5 VGND VPWR sky130_fd_sc_hd__tapvpwrvgnd_1
Xfill_0_6 VGND VPWR sky130_fd_sc_hd__tapvpwrvgnd_1
XSLICE_16\[0\].RAM16.SLICE\[0\].RAM8.WORD\[5\].W.BYTE\[1\].B.BIT\[5\].OBUF0 SLICE_16\[0\].RAM16.SLICE\[0\].RAM8.WORD\[5\].W.BYTE\[1\].B.Q_WIRE\[5\]
+ SLICE_16\[0\].RAM16.SLICE\[0\].RAM8.WORD\[5\].W.BYTE\[1\].B.SEL0_B VGND VGND VPWR
+ VPWR SLICE_16\[0\].RAM16.BYTE\[1\].FLOATBUF0\[13\].Z sky130_fd_sc_hd__ebufn_2
XSLICE_16\[1\].RAM16.SLICE\[1\].RAM8.WORD\[7\].W.BYTE\[1\].B.BIT\[2\].OBUF0 SLICE_16\[1\].RAM16.SLICE\[1\].RAM8.WORD\[7\].W.BYTE\[1\].B.Q_WIRE\[2\]
+ SLICE_16\[1\].RAM16.SLICE\[1\].RAM8.WORD\[7\].W.BYTE\[1\].B.SEL0_B VGND VGND VPWR
+ VPWR SLICE_16\[1\].RAM16.BYTE\[1\].FLOATBUF0\[10\].Z sky130_fd_sc_hd__ebufn_2
XSLICE_16\[1\].RAM16.SLICE\[0\].RAM8.WORD\[7\].W.BYTE\[1\].B.BIT\[7\].genblk1.STORAGE
+ DIBUF\[15\].X SLICE_16\[1\].RAM16.SLICE\[0\].RAM8.WORD\[7\].W.BYTE\[1\].B.GCLK VGND
+ VGND VPWR VPWR SLICE_16\[1\].RAM16.SLICE\[0\].RAM8.WORD\[7\].W.BYTE\[1\].B.Q_WIRE\[7\]
+ sky130_fd_sc_hd__dlxtp_1
Xtap_5_17 VGND VPWR sky130_fd_sc_hd__tapvpwrvgnd_1
Xtap_5_28 VGND VPWR sky130_fd_sc_hd__tapvpwrvgnd_1
Xtap_10_9 VGND VPWR sky130_fd_sc_hd__tapvpwrvgnd_1
.ends
